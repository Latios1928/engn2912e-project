* LVS reference for DAC_signed_binary.gds (glayout_floorplan.two_row)
* note: x1_M1: 0.22/0.28 -> 0.5/0.64 (W/L kept)
* note: x1_M3: 0.22/0.28 -> 0.5/0.64 (W/L kept)
* note: x1_M5: 0.22/0.28 -> 0.5/0.64 (W/L kept)
* note: x1_M7: 0.22/0.28 -> 0.5/0.64 (W/L kept)
* note: x1_Men: 0.22/0.28 -> 0.5/0.64 (W/L kept)
* note: Mse: 0.22/0.28 -> 0.5/0.64 (W/L kept)
* note: Msi: 0.22/0.28 -> 0.5/0.64 (W/L kept)
* note: Mpi: 0.44/0.28 -> 0.5/0.32 (W/L kept)
* note: Mni: 0.22/0.28 -> 0.5/0.64 (W/L kept)
* note: G3 common-centroid, 15 units: D C D B D C D A D C D B D C D (A=x1_M2 x1, B=x1_M4 x2, C=x1_M6 x4, D=x1_M8 x8)
* note: ground net GND drawn as VSS
.subckt DAC_signed_binary Isum_e w[3] w[2] w[1] w[0] en s Vb Isum_i VDD VSS
Xx1_Men Y en x1_X VSS nfet_03v3 L=0.64u W=0.5u nf=1
XMse Isum_e sb Y VSS nfet_03v3 L=0.64u W=0.5u nf=1
XMsi Isum_i s Y VSS nfet_03v3 L=0.64u W=0.5u nf=1
Xx1_M8_u0 x1_net1 Vb VSS VSS nfet_03v3 L=8u W=1u nf=1
Xx1_M6_u0 x1_net3 Vb VSS VSS nfet_03v3 L=8u W=1u nf=1
Xx1_M8_u1 x1_net1 Vb VSS VSS nfet_03v3 L=8u W=1u nf=1
Xx1_M4_u0 x1_net2 Vb VSS VSS nfet_03v3 L=8u W=1u nf=1
Xx1_M8_u2 x1_net1 Vb VSS VSS nfet_03v3 L=8u W=1u nf=1
Xx1_M6_u1 x1_net3 Vb VSS VSS nfet_03v3 L=8u W=1u nf=1
Xx1_M8_u3 x1_net1 Vb VSS VSS nfet_03v3 L=8u W=1u nf=1
Xx1_M2_u0 x1_net4 Vb VSS VSS nfet_03v3 L=8u W=1u nf=1
Xx1_M8_u4 x1_net1 Vb VSS VSS nfet_03v3 L=8u W=1u nf=1
Xx1_M6_u2 x1_net3 Vb VSS VSS nfet_03v3 L=8u W=1u nf=1
Xx1_M8_u5 x1_net1 Vb VSS VSS nfet_03v3 L=8u W=1u nf=1
Xx1_M4_u1 x1_net2 Vb VSS VSS nfet_03v3 L=8u W=1u nf=1
Xx1_M8_u6 x1_net1 Vb VSS VSS nfet_03v3 L=8u W=1u nf=1
Xx1_M6_u3 x1_net3 Vb VSS VSS nfet_03v3 L=8u W=1u nf=1
Xx1_M8_u7 x1_net1 Vb VSS VSS nfet_03v3 L=8u W=1u nf=1
XMni sb s VSS VSS nfet_03v3 L=0.64u W=0.5u nf=1
Xx1_M1 x1_X w[0] x1_net4 x1_net4 nfet_03v3 L=0.64u W=0.5u nf=1
Xx1_M3_f0 x1_X w[1] x1_net2 x1_net2 nfet_03v3 L=0.64u W=0.5u nf=1
Xx1_M3_f1 x1_X w[1] x1_net2 x1_net2 nfet_03v3 L=0.64u W=0.5u nf=1
Xx1_M5_f0 x1_X w[2] x1_net3 x1_net3 nfet_03v3 L=0.64u W=0.5u nf=1
Xx1_M5_f1 x1_X w[2] x1_net3 x1_net3 nfet_03v3 L=0.64u W=0.5u nf=1
Xx1_M5_f2 x1_X w[2] x1_net3 x1_net3 nfet_03v3 L=0.64u W=0.5u nf=1
Xx1_M5_f3 x1_X w[2] x1_net3 x1_net3 nfet_03v3 L=0.64u W=0.5u nf=1
Xx1_M7_f0 x1_X w[3] x1_net1 x1_net1 nfet_03v3 L=0.64u W=0.5u nf=1
Xx1_M7_f1 x1_X w[3] x1_net1 x1_net1 nfet_03v3 L=0.64u W=0.5u nf=1
Xx1_M7_f2 x1_X w[3] x1_net1 x1_net1 nfet_03v3 L=0.64u W=0.5u nf=1
Xx1_M7_f3 x1_X w[3] x1_net1 x1_net1 nfet_03v3 L=0.64u W=0.5u nf=1
Xx1_M7_f4 x1_X w[3] x1_net1 x1_net1 nfet_03v3 L=0.64u W=0.5u nf=1
Xx1_M7_f5 x1_X w[3] x1_net1 x1_net1 nfet_03v3 L=0.64u W=0.5u nf=1
Xx1_M7_f6 x1_X w[3] x1_net1 x1_net1 nfet_03v3 L=0.64u W=0.5u nf=1
Xx1_M7_f7 x1_X w[3] x1_net1 x1_net1 nfet_03v3 L=0.64u W=0.5u nf=1
XMpi sb s VDD VDD pfet_03v3 L=0.32u W=0.5u nf=1
XDNN0 VSS VSS VSS VSS nfet_03v3 L=2u W=0.5u nf=1
XDNN1 VSS VSS VSS VSS nfet_03v3 L=2u W=0.5u nf=1
XDNN2 VSS VSS VSS VSS nfet_03v3 L=2u W=0.5u nf=1
XDNN3 VSS VSS VSS VSS nfet_03v3 L=2u W=0.5u nf=1
XDNN4 VSS VSS VSS VSS nfet_03v3 L=2u W=0.5u nf=1
XDNN5 VSS VSS VSS VSS nfet_03v3 L=2u W=0.5u nf=1
XDNN6 VSS VSS VSS VSS nfet_03v3 L=2u W=0.5u nf=1
XDNN7 VSS VSS VSS VSS nfet_03v3 L=2u W=0.5u nf=1
XDNN8 VSS VSS VSS VSS nfet_03v3 L=2u W=0.5u nf=1
XDNN9 VSS VSS VSS VSS nfet_03v3 L=2u W=0.5u nf=1
XDNN10 VSS VSS VSS VSS nfet_03v3 L=2u W=0.5u nf=1
XDNN11 VSS VSS VSS VSS nfet_03v3 L=2u W=0.5u nf=1
XDNN12 VSS VSS VSS VSS nfet_03v3 L=2u W=0.5u nf=1
XDNN13 VSS VSS VSS VSS nfet_03v3 L=2u W=0.5u nf=1
XDNN14 VSS VSS VSS VSS nfet_03v3 L=2u W=0.5u nf=1
XDNN15 VSS VSS VSS VSS nfet_03v3 L=2u W=0.5u nf=1
XDNN16 VSS VSS VSS VSS nfet_03v3 L=2u W=0.5u nf=1
XDNN17 VSS VSS VSS VSS nfet_03v3 L=2u W=0.5u nf=1
XDNN18 VSS VSS VSS VSS nfet_03v3 L=2u W=0.5u nf=1
XDNN19 VSS VSS VSS VSS nfet_03v3 L=2u W=0.5u nf=1
XDNN20 VSS VSS VSS VSS nfet_03v3 L=2u W=0.5u nf=1
XDNN21 VSS VSS VSS VSS nfet_03v3 L=2u W=0.5u nf=1
XDNN22 VSS VSS VSS VSS nfet_03v3 L=2u W=0.5u nf=1
XDNN23 VSS VSS VSS VSS nfet_03v3 L=2u W=0.5u nf=1
XDNN24 VSS VSS VSS VSS nfet_03v3 L=2u W=0.5u nf=1
XDNN25 VSS VSS VSS VSS nfet_03v3 L=2u W=0.5u nf=1
XDNN26 VSS VSS VSS VSS nfet_03v3 L=2u W=0.5u nf=1
XDNN27 VSS VSS VSS VSS nfet_03v3 L=2u W=0.5u nf=1
XDNN28 VSS VSS VSS VSS nfet_03v3 L=2u W=0.5u nf=1
XDNN29 VSS VSS VSS VSS nfet_03v3 L=2u W=0.5u nf=1
XDNN30 VSS VSS VSS VSS nfet_03v3 L=2u W=0.5u nf=1
XDNN31 VSS VSS VSS VSS nfet_03v3 L=2u W=0.5u nf=1
XDNN32 VSS VSS VSS VSS nfet_03v3 L=2u W=0.5u nf=1
XDNN33 VSS VSS VSS VSS nfet_03v3 L=2u W=0.5u nf=1
XDNN34 VSS VSS VSS VSS nfet_03v3 L=2u W=0.5u nf=1
XDNN35 VSS VSS VSS VSS nfet_03v3 L=2u W=0.5u nf=1
XDNN36 VSS VSS VSS VSS nfet_03v3 L=2u W=0.5u nf=1
XDNN37 VSS VSS VSS VSS nfet_03v3 L=2u W=0.5u nf=1
XDNN38 VSS VSS VSS VSS nfet_03v3 L=2u W=0.5u nf=1
XDNN39 VSS VSS VSS VSS nfet_03v3 L=2u W=0.5u nf=1
XDNN40 VSS VSS VSS VSS nfet_03v3 L=2u W=0.5u nf=1
XDNN41 VSS VSS VSS VSS nfet_03v3 L=2u W=0.5u nf=1
XDNN42 VSS VSS VSS VSS nfet_03v3 L=2u W=0.5u nf=1
XDNN43 VSS VSS VSS VSS nfet_03v3 L=2u W=0.5u nf=1
XDNN44 VSS VSS VSS VSS nfet_03v3 L=2u W=0.5u nf=1
XDNN45 VSS VSS VSS VSS nfet_03v3 L=2u W=0.5u nf=1
XDNN46 VSS VSS VSS VSS nfet_03v3 L=2u W=0.5u nf=1
XDNN47 VSS VSS VSS VSS nfet_03v3 L=2u W=0.5u nf=1
XDNN48 VSS VSS VSS VSS nfet_03v3 L=2u W=0.5u nf=1
XDNN49 VSS VSS VSS VSS nfet_03v3 L=2u W=0.5u nf=1
XDNN50 VSS VSS VSS VSS nfet_03v3 L=2u W=0.5u nf=1
XDNN51 VSS VSS VSS VSS nfet_03v3 L=2u W=0.5u nf=1
XDNN52 VSS VSS VSS VSS nfet_03v3 L=2u W=0.5u nf=1
XDNN53 VSS VSS VSS VSS nfet_03v3 L=2u W=0.5u nf=1
XDNN54 VSS VSS VSS VSS nfet_03v3 L=2u W=0.5u nf=1
XDNN55 VSS VSS VSS VSS nfet_03v3 L=2u W=0.5u nf=1
XDNN56 VSS VSS VSS VSS nfet_03v3 L=2u W=0.5u nf=1
XDNN57 VSS VSS VSS VSS nfet_03v3 L=2u W=0.5u nf=1
XDNN58 VSS VSS VSS VSS nfet_03v3 L=2u W=0.5u nf=1
XDNN59 VSS VSS VSS VSS nfet_03v3 L=2u W=0.5u nf=1
XDNN60 VSS VSS VSS VSS nfet_03v3 L=2u W=0.5u nf=1
XDNN61 VSS VSS VSS VSS nfet_03v3 L=2u W=0.5u nf=1
XDNN62 VSS VSS VSS VSS nfet_03v3 L=2u W=0.5u nf=1
XDNN63 VSS VSS VSS VSS nfet_03v3 L=2u W=0.5u nf=1
XDNN64 VSS VSS VSS VSS nfet_03v3 L=2u W=0.5u nf=1
XDNN65 VSS VSS VSS VSS nfet_03v3 L=2u W=0.5u nf=1
XDNN66 VSS VSS VSS VSS nfet_03v3 L=2u W=0.5u nf=1
XDNN67 VSS VSS VSS VSS nfet_03v3 L=2u W=0.5u nf=1
XDNN68 VSS VSS VSS VSS nfet_03v3 L=2u W=0.5u nf=1
XDNS0 VSS VSS VSS VSS nfet_03v3 L=2u W=0.5u nf=1
XDNS1 VSS VSS VSS VSS nfet_03v3 L=2u W=0.5u nf=1
XDNS2 VSS VSS VSS VSS nfet_03v3 L=2u W=0.5u nf=1
XDNS3 VSS VSS VSS VSS nfet_03v3 L=2u W=0.5u nf=1
XDNS4 VSS VSS VSS VSS nfet_03v3 L=2u W=0.5u nf=1
XDNS5 VSS VSS VSS VSS nfet_03v3 L=2u W=0.5u nf=1
XDNS6 VSS VSS VSS VSS nfet_03v3 L=2u W=0.5u nf=1
XDNS7 VSS VSS VSS VSS nfet_03v3 L=2u W=0.5u nf=1
XDNS8 VSS VSS VSS VSS nfet_03v3 L=2u W=0.5u nf=1
XDNS9 VSS VSS VSS VSS nfet_03v3 L=2u W=0.5u nf=1
XDNS10 VSS VSS VSS VSS nfet_03v3 L=2u W=0.5u nf=1
XDNS11 VSS VSS VSS VSS nfet_03v3 L=2u W=0.5u nf=1
XDNS12 VSS VSS VSS VSS nfet_03v3 L=2u W=0.5u nf=1
XDNS13 VSS VSS VSS VSS nfet_03v3 L=2u W=0.5u nf=1
XDNS14 VSS VSS VSS VSS nfet_03v3 L=2u W=0.5u nf=1
XDNS15 VSS VSS VSS VSS nfet_03v3 L=2u W=0.5u nf=1
XDNS16 VSS VSS VSS VSS nfet_03v3 L=2u W=0.5u nf=1
XDNS17 VSS VSS VSS VSS nfet_03v3 L=2u W=0.5u nf=1
XDNS18 VSS VSS VSS VSS nfet_03v3 L=2u W=0.5u nf=1
XDNS19 VSS VSS VSS VSS nfet_03v3 L=2u W=0.5u nf=1
XDNS20 VSS VSS VSS VSS nfet_03v3 L=2u W=0.5u nf=1
XDNS21 VSS VSS VSS VSS nfet_03v3 L=2u W=0.5u nf=1
XDNS22 VSS VSS VSS VSS nfet_03v3 L=2u W=0.5u nf=1
XDNS23 VSS VSS VSS VSS nfet_03v3 L=2u W=0.5u nf=1
XDNS24 VSS VSS VSS VSS nfet_03v3 L=2u W=0.5u nf=1
XDNS25 VSS VSS VSS VSS nfet_03v3 L=2u W=0.5u nf=1
XDNS26 VSS VSS VSS VSS nfet_03v3 L=2u W=0.5u nf=1
XDNS27 VSS VSS VSS VSS nfet_03v3 L=2u W=0.5u nf=1
XDNS28 VSS VSS VSS VSS nfet_03v3 L=2u W=0.5u nf=1
XDNS29 VSS VSS VSS VSS nfet_03v3 L=2u W=0.5u nf=1
XDNS30 VSS VSS VSS VSS nfet_03v3 L=2u W=0.5u nf=1
XDNS31 VSS VSS VSS VSS nfet_03v3 L=2u W=0.5u nf=1
XDNS32 VSS VSS VSS VSS nfet_03v3 L=2u W=0.5u nf=1
XDNS33 VSS VSS VSS VSS nfet_03v3 L=2u W=0.5u nf=1
XDNS34 VSS VSS VSS VSS nfet_03v3 L=2u W=0.5u nf=1
XDNS35 VSS VSS VSS VSS nfet_03v3 L=2u W=0.5u nf=1
XDNS36 VSS VSS VSS VSS nfet_03v3 L=2u W=0.5u nf=1
XDNS37 VSS VSS VSS VSS nfet_03v3 L=2u W=0.5u nf=1
XDNS38 VSS VSS VSS VSS nfet_03v3 L=2u W=0.5u nf=1
XDNS39 VSS VSS VSS VSS nfet_03v3 L=2u W=0.5u nf=1
XDNS40 VSS VSS VSS VSS nfet_03v3 L=2u W=0.5u nf=1
XDNS41 VSS VSS VSS VSS nfet_03v3 L=2u W=0.5u nf=1
XDNS42 VSS VSS VSS VSS nfet_03v3 L=2u W=0.5u nf=1
XDNS43 VSS VSS VSS VSS nfet_03v3 L=2u W=0.5u nf=1
XDNS44 VSS VSS VSS VSS nfet_03v3 L=2u W=0.5u nf=1
XDNS45 VSS VSS VSS VSS nfet_03v3 L=2u W=0.5u nf=1
XDNS46 VSS VSS VSS VSS nfet_03v3 L=2u W=0.5u nf=1
XDNS47 VSS VSS VSS VSS nfet_03v3 L=2u W=0.5u nf=1
XDNS48 VSS VSS VSS VSS nfet_03v3 L=2u W=0.5u nf=1
XDNS49 VSS VSS VSS VSS nfet_03v3 L=2u W=0.5u nf=1
XDNS50 VSS VSS VSS VSS nfet_03v3 L=2u W=0.5u nf=1
XDNS51 VSS VSS VSS VSS nfet_03v3 L=2u W=0.5u nf=1
XDNS52 VSS VSS VSS VSS nfet_03v3 L=2u W=0.5u nf=1
XDNS53 VSS VSS VSS VSS nfet_03v3 L=2u W=0.5u nf=1
XDNS54 VSS VSS VSS VSS nfet_03v3 L=2u W=0.5u nf=1
XDNS55 VSS VSS VSS VSS nfet_03v3 L=2u W=0.5u nf=1
XDNS56 VSS VSS VSS VSS nfet_03v3 L=2u W=0.5u nf=1
XDNS57 VSS VSS VSS VSS nfet_03v3 L=2u W=0.5u nf=1
XDNS58 VSS VSS VSS VSS nfet_03v3 L=2u W=0.5u nf=1
XDNS59 VSS VSS VSS VSS nfet_03v3 L=2u W=0.5u nf=1
XDNS60 VSS VSS VSS VSS nfet_03v3 L=2u W=0.5u nf=1
XDNS61 VSS VSS VSS VSS nfet_03v3 L=2u W=0.5u nf=1
XDNS62 VSS VSS VSS VSS nfet_03v3 L=2u W=0.5u nf=1
XDNS63 VSS VSS VSS VSS nfet_03v3 L=2u W=0.5u nf=1
XDNS64 VSS VSS VSS VSS nfet_03v3 L=2u W=0.5u nf=1
XDNS65 VSS VSS VSS VSS nfet_03v3 L=2u W=0.5u nf=1
XDNS66 VSS VSS VSS VSS nfet_03v3 L=2u W=0.5u nf=1
XDNS67 VSS VSS VSS VSS nfet_03v3 L=2u W=0.5u nf=1
XDNS68 VSS VSS VSS VSS nfet_03v3 L=2u W=0.5u nf=1
XDNW0 VSS VSS VSS VSS nfet_03v3 L=2u W=1u nf=1
XDNE0 VSS VSS VSS VSS nfet_03v3 L=2u W=1u nf=1
XDNI1N0 x1_net4 x1_net4 x1_net4 x1_net4 nfet_03v3 L=2u W=0.5u nf=1
XDNI1N1 x1_net4 x1_net4 x1_net4 x1_net4 nfet_03v3 L=2u W=0.5u nf=1
XDNI1N2 x1_net4 x1_net4 x1_net4 x1_net4 nfet_03v3 L=2u W=0.5u nf=1
XDNI1S0 x1_net4 x1_net4 x1_net4 x1_net4 nfet_03v3 L=2u W=0.5u nf=1
XDNI1S1 x1_net4 x1_net4 x1_net4 x1_net4 nfet_03v3 L=2u W=0.5u nf=1
XDNI1S2 x1_net4 x1_net4 x1_net4 x1_net4 nfet_03v3 L=2u W=0.5u nf=1
XDNI1W0 x1_net4 x1_net4 x1_net4 x1_net4 nfet_03v3 L=2u W=0.5u nf=1
XDNI1E0 x1_net4 x1_net4 x1_net4 x1_net4 nfet_03v3 L=2u W=0.5u nf=1
XDNI2N0 x1_net2 x1_net2 x1_net2 x1_net2 nfet_03v3 L=2u W=0.5u nf=1
XDNI2N1 x1_net2 x1_net2 x1_net2 x1_net2 nfet_03v3 L=2u W=0.5u nf=1
XDNI2N2 x1_net2 x1_net2 x1_net2 x1_net2 nfet_03v3 L=2u W=0.5u nf=1
XDNI2N3 x1_net2 x1_net2 x1_net2 x1_net2 nfet_03v3 L=2u W=0.5u nf=1
XDNI2S0 x1_net2 x1_net2 x1_net2 x1_net2 nfet_03v3 L=2u W=0.5u nf=1
XDNI2S1 x1_net2 x1_net2 x1_net2 x1_net2 nfet_03v3 L=2u W=0.5u nf=1
XDNI2S2 x1_net2 x1_net2 x1_net2 x1_net2 nfet_03v3 L=2u W=0.5u nf=1
XDNI2S3 x1_net2 x1_net2 x1_net2 x1_net2 nfet_03v3 L=2u W=0.5u nf=1
XDNI2W0 x1_net2 x1_net2 x1_net2 x1_net2 nfet_03v3 L=2u W=0.5u nf=1
XDNI2E0 x1_net2 x1_net2 x1_net2 x1_net2 nfet_03v3 L=2u W=0.5u nf=1
XDNI3N0 x1_net3 x1_net3 x1_net3 x1_net3 nfet_03v3 L=2u W=0.5u nf=1
XDNI3N1 x1_net3 x1_net3 x1_net3 x1_net3 nfet_03v3 L=2u W=0.5u nf=1
XDNI3N2 x1_net3 x1_net3 x1_net3 x1_net3 nfet_03v3 L=2u W=0.5u nf=1
XDNI3N3 x1_net3 x1_net3 x1_net3 x1_net3 nfet_03v3 L=2u W=0.5u nf=1
XDNI3N4 x1_net3 x1_net3 x1_net3 x1_net3 nfet_03v3 L=2u W=0.5u nf=1
XDNI3S0 x1_net3 x1_net3 x1_net3 x1_net3 nfet_03v3 L=2u W=0.5u nf=1
XDNI3S1 x1_net3 x1_net3 x1_net3 x1_net3 nfet_03v3 L=2u W=0.5u nf=1
XDNI3S2 x1_net3 x1_net3 x1_net3 x1_net3 nfet_03v3 L=2u W=0.5u nf=1
XDNI3S3 x1_net3 x1_net3 x1_net3 x1_net3 nfet_03v3 L=2u W=0.5u nf=1
XDNI3S4 x1_net3 x1_net3 x1_net3 x1_net3 nfet_03v3 L=2u W=0.5u nf=1
XDNI3W0 x1_net3 x1_net3 x1_net3 x1_net3 nfet_03v3 L=2u W=0.5u nf=1
XDNI3E0 x1_net3 x1_net3 x1_net3 x1_net3 nfet_03v3 L=2u W=0.5u nf=1
XDNI4N0 x1_net1 x1_net1 x1_net1 x1_net1 nfet_03v3 L=2u W=0.5u nf=1
XDNI4N1 x1_net1 x1_net1 x1_net1 x1_net1 nfet_03v3 L=2u W=0.5u nf=1
XDNI4N2 x1_net1 x1_net1 x1_net1 x1_net1 nfet_03v3 L=2u W=0.5u nf=1
XDNI4N3 x1_net1 x1_net1 x1_net1 x1_net1 nfet_03v3 L=2u W=0.5u nf=1
XDNI4N4 x1_net1 x1_net1 x1_net1 x1_net1 nfet_03v3 L=2u W=0.5u nf=1
XDNI4N5 x1_net1 x1_net1 x1_net1 x1_net1 nfet_03v3 L=2u W=0.5u nf=1
XDNI4N6 x1_net1 x1_net1 x1_net1 x1_net1 nfet_03v3 L=2u W=0.5u nf=1
XDNI4S0 x1_net1 x1_net1 x1_net1 x1_net1 nfet_03v3 L=2u W=0.5u nf=1
XDNI4S1 x1_net1 x1_net1 x1_net1 x1_net1 nfet_03v3 L=2u W=0.5u nf=1
XDNI4S2 x1_net1 x1_net1 x1_net1 x1_net1 nfet_03v3 L=2u W=0.5u nf=1
XDNI4S3 x1_net1 x1_net1 x1_net1 x1_net1 nfet_03v3 L=2u W=0.5u nf=1
XDNI4S4 x1_net1 x1_net1 x1_net1 x1_net1 nfet_03v3 L=2u W=0.5u nf=1
XDNI4S5 x1_net1 x1_net1 x1_net1 x1_net1 nfet_03v3 L=2u W=0.5u nf=1
XDNI4S6 x1_net1 x1_net1 x1_net1 x1_net1 nfet_03v3 L=2u W=0.5u nf=1
XDNI4W0 x1_net1 x1_net1 x1_net1 x1_net1 nfet_03v3 L=2u W=0.5u nf=1
XDNI4E0 x1_net1 x1_net1 x1_net1 x1_net1 nfet_03v3 L=2u W=0.5u nf=1
XDPN0 VDD VDD VDD VDD pfet_03v3 L=2u W=0.5u nf=1
XDPN1 VDD VDD VDD VDD pfet_03v3 L=2u W=0.5u nf=1
XDPN2 VDD VDD VDD VDD pfet_03v3 L=2u W=0.5u nf=1
XDPS0 VDD VDD VDD VDD pfet_03v3 L=2u W=0.5u nf=1
XDPS1 VDD VDD VDD VDD pfet_03v3 L=2u W=0.5u nf=1
XDPS2 VDD VDD VDD VDD pfet_03v3 L=2u W=0.5u nf=1
XDPW0 VDD VDD VDD VDD pfet_03v3 L=2u W=0.5u nf=1
XDPE0 VDD VDD VDD VDD pfet_03v3 L=2u W=0.5u nf=1
Cpred_Isum_e Isum_e VSS 3.766e-15
Cpred_Isum_i Isum_i VSS 3.745e-15
Cpred_Vb Vb VSS 9.565e-14
Cpred_Y Y VSS 1.076e-14
Cpred_en en VSS 5.865e-15
Cpred_s s VSS 6.811e-14
Cpred_sb sb VSS 5.109e-14
Cpred_w[0] w[0] VSS 7.879e-14
Cpred_w[1] w[1] VSS 8.546e-14
Cpred_w[2] w[2] VSS 8.187e-14
Cpred_w[3] w[3] VSS 6.604e-14
Cpred_x1_X x1_X VSS 1.026e-13
Cpred_x1_net1 x1_net1 VSS 1.137e-13
Cpred_x1_net2 x1_net2 VSS 7.159e-14
Cpred_x1_net3 x1_net3 VSS 9.641e-14
Cpred_x1_net4 x1_net4 VSS 4.356e-14
.ends
