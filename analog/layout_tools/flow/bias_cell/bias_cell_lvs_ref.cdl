* LVS reference for bias_cell.gds (glayout_floorplan.two_row)
* note: MO_Vb: W 1.435 -> 1.44 (glayout 10 nm width grid, L kept)
* note: MR_Vlk: m=8 x nf=1 -> nf=8, m=1 (parallel copies as fingers)
* note: MR_VKdn: m=4 x nf=1 -> nf=4, m=1 (parallel copies as fingers)
* note: MO_VIp: W 2.335 -> 2.34 (glayout 10 nm width grid, L kept)
* note: MR_Vamp_bias: 0.22/0.28 -> 0.5/0.64 (W/L kept)
* note: MR_VK: 0.22/40 -> 0.5/90.91 (W/L kept)
* note: MR_VNA: 0.22/20 -> 0.5/45.45 (W/L kept)
* note: MO_VNA: W 5.755 -> 5.76 (glayout 10 nm width grid, L kept)
* note: MO_VKup: W 6.005 -> 6.01 (glayout 10 nm width grid, L kept)
* note: MR_Vthr: 0.22/0.28 -> 0.5/0.64 (W/L kept)
* note: MR_Vthr: m=32 x nf=1 -> nf=32, m=1 (parallel copies as fingers)
* note: MO_Vthr: W 0.905 -> 0.91 (glayout 10 nm width grid, L kept)
* note: MR_VT_dpi: 0.22/0.28 -> 0.5/0.64 (W/L kept)
* note: MR_VT_dpi: m=32 x nf=1 -> nf=32, m=1 (parallel copies as fingers)
* note: MO_VT_dpi: W 1.165 -> 1.17 (glayout 10 nm width grid, L kept)
* note: MR_VT_inh: m=16 x nf=1 -> nf=16, m=1 (parallel copies as fingers)
* note: MO_VT_inh: W 0.625 -> 0.63 (glayout 10 nm width grid, L kept)
.subckt bias_cell VDD VSS Iref Vb Vlk VKdn VIp Vamp_bias VK VNA VKup Vthr VT_dpi VT_inh
MMNP vgp Iref VSS VSS nfet_03v3 L=8u W=10u nf=1
MMN0 Iref Iref VSS VSS nfet_03v3 L=8u W=10u nf=1
MMO_VNA VNA Iref VSS VSS nfet_03v3 L=8u W=5.76u nf=1
MMO_VKup VKup Iref VSS VSS nfet_03v3 L=8u W=6.01u nf=1
MMO_Vthr Vthr Iref VSS VSS nfet_03v3 L=32u W=0.91u nf=1
MMO_VT_dpi VT_dpi Iref VSS VSS nfet_03v3 L=32u W=1.17u nf=1
MMO_VT_inh VT_inh Iref VSS VSS nfet_03v3 L=32u W=0.63u nf=1
MMR_Vb Vb Vb VSS VSS nfet_03v3 L=8u W=1u nf=1
MMR_Vlk_f0 Vlk Vlk VSS VSS nfet_03v3 L=1u W=1u nf=1
MMR_Vlk_f1 Vlk Vlk VSS VSS nfet_03v3 L=1u W=1u nf=1
MMR_Vlk_f2 Vlk Vlk VSS VSS nfet_03v3 L=1u W=1u nf=1
MMR_Vlk_f3 Vlk Vlk VSS VSS nfet_03v3 L=1u W=1u nf=1
MMR_Vlk_f4 Vlk Vlk VSS VSS nfet_03v3 L=1u W=1u nf=1
MMR_Vlk_f5 Vlk Vlk VSS VSS nfet_03v3 L=1u W=1u nf=1
MMR_Vlk_f6 Vlk Vlk VSS VSS nfet_03v3 L=1u W=1u nf=1
MMR_Vlk_f7 Vlk Vlk VSS VSS nfet_03v3 L=1u W=1u nf=1
MMR_VKdn_f0 VKdn VKdn VSS VSS nfet_03v3 L=1u W=1u nf=1
MMR_VKdn_f1 VKdn VKdn VSS VSS nfet_03v3 L=1u W=1u nf=1
MMR_VKdn_f2 VKdn VKdn VSS VSS nfet_03v3 L=1u W=1u nf=1
MMR_VKdn_f3 VKdn VKdn VSS VSS nfet_03v3 L=1u W=1u nf=1
MMR_VIp VIp VIp VSS VSS nfet_03v3 L=1u W=1u nf=1
MMR_Vamp_bias Vamp_bias Vamp_bias VSS VSS nfet_03v3 L=0.64u W=0.5u nf=1
MMR_VK VK VK VSS VSS nfet_03v3 L=90.91u W=0.5u nf=1
MMO_Vb Vb vgp VDD VDD pfet_03v3 L=8u W=1.44u nf=1
MMO_VKdn VKdn vgp VDD VDD pfet_03v3 L=8u W=12.94u nf=1
MMP0 vgp vgp VDD VDD pfet_03v3 L=8u W=10u nf=1
MMO_VIp VIp vgp VDD VDD pfet_03v3 L=8u W=2.34u nf=1
MMO_Vamp_bias Vamp_bias vgp VDD VDD pfet_03v3 L=8u W=9.14u nf=1
MMO_VK VK vgp VDD VDD pfet_03v3 L=8u W=10.45u nf=1
MMO_Vlk Vlk vgp VDD VDD pfet_03v3 L=16u W=0.84u nf=1
MMR_VNA VNA VNA VDD VDD pfet_03v3 L=45.45u W=0.5u nf=1
MMR_VKup VKup VKup VDD VDD pfet_03v3 L=8u W=1u nf=1
MMR_Vthr_f0 Vthr Vthr VDD VDD pfet_03v3 L=0.64u W=0.5u nf=1
MMR_Vthr_f1 Vthr Vthr VDD VDD pfet_03v3 L=0.64u W=0.5u nf=1
MMR_Vthr_f2 Vthr Vthr VDD VDD pfet_03v3 L=0.64u W=0.5u nf=1
MMR_Vthr_f3 Vthr Vthr VDD VDD pfet_03v3 L=0.64u W=0.5u nf=1
MMR_Vthr_f4 Vthr Vthr VDD VDD pfet_03v3 L=0.64u W=0.5u nf=1
MMR_Vthr_f5 Vthr Vthr VDD VDD pfet_03v3 L=0.64u W=0.5u nf=1
MMR_Vthr_f6 Vthr Vthr VDD VDD pfet_03v3 L=0.64u W=0.5u nf=1
MMR_Vthr_f7 Vthr Vthr VDD VDD pfet_03v3 L=0.64u W=0.5u nf=1
MMR_Vthr_f8 Vthr Vthr VDD VDD pfet_03v3 L=0.64u W=0.5u nf=1
MMR_Vthr_f9 Vthr Vthr VDD VDD pfet_03v3 L=0.64u W=0.5u nf=1
MMR_Vthr_f10 Vthr Vthr VDD VDD pfet_03v3 L=0.64u W=0.5u nf=1
MMR_Vthr_f11 Vthr Vthr VDD VDD pfet_03v3 L=0.64u W=0.5u nf=1
MMR_Vthr_f12 Vthr Vthr VDD VDD pfet_03v3 L=0.64u W=0.5u nf=1
MMR_Vthr_f13 Vthr Vthr VDD VDD pfet_03v3 L=0.64u W=0.5u nf=1
MMR_Vthr_f14 Vthr Vthr VDD VDD pfet_03v3 L=0.64u W=0.5u nf=1
MMR_Vthr_f15 Vthr Vthr VDD VDD pfet_03v3 L=0.64u W=0.5u nf=1
MMR_Vthr_f16 Vthr Vthr VDD VDD pfet_03v3 L=0.64u W=0.5u nf=1
MMR_Vthr_f17 Vthr Vthr VDD VDD pfet_03v3 L=0.64u W=0.5u nf=1
MMR_Vthr_f18 Vthr Vthr VDD VDD pfet_03v3 L=0.64u W=0.5u nf=1
MMR_Vthr_f19 Vthr Vthr VDD VDD pfet_03v3 L=0.64u W=0.5u nf=1
MMR_Vthr_f20 Vthr Vthr VDD VDD pfet_03v3 L=0.64u W=0.5u nf=1
MMR_Vthr_f21 Vthr Vthr VDD VDD pfet_03v3 L=0.64u W=0.5u nf=1
MMR_Vthr_f22 Vthr Vthr VDD VDD pfet_03v3 L=0.64u W=0.5u nf=1
MMR_Vthr_f23 Vthr Vthr VDD VDD pfet_03v3 L=0.64u W=0.5u nf=1
MMR_Vthr_f24 Vthr Vthr VDD VDD pfet_03v3 L=0.64u W=0.5u nf=1
MMR_Vthr_f25 Vthr Vthr VDD VDD pfet_03v3 L=0.64u W=0.5u nf=1
MMR_Vthr_f26 Vthr Vthr VDD VDD pfet_03v3 L=0.64u W=0.5u nf=1
MMR_Vthr_f27 Vthr Vthr VDD VDD pfet_03v3 L=0.64u W=0.5u nf=1
MMR_Vthr_f28 Vthr Vthr VDD VDD pfet_03v3 L=0.64u W=0.5u nf=1
MMR_Vthr_f29 Vthr Vthr VDD VDD pfet_03v3 L=0.64u W=0.5u nf=1
MMR_Vthr_f30 Vthr Vthr VDD VDD pfet_03v3 L=0.64u W=0.5u nf=1
MMR_Vthr_f31 Vthr Vthr VDD VDD pfet_03v3 L=0.64u W=0.5u nf=1
MMR_VT_dpi_f0 VT_dpi VT_dpi VDD VDD pfet_03v3 L=0.64u W=0.5u nf=1
MMR_VT_dpi_f1 VT_dpi VT_dpi VDD VDD pfet_03v3 L=0.64u W=0.5u nf=1
MMR_VT_dpi_f2 VT_dpi VT_dpi VDD VDD pfet_03v3 L=0.64u W=0.5u nf=1
MMR_VT_dpi_f3 VT_dpi VT_dpi VDD VDD pfet_03v3 L=0.64u W=0.5u nf=1
MMR_VT_dpi_f4 VT_dpi VT_dpi VDD VDD pfet_03v3 L=0.64u W=0.5u nf=1
MMR_VT_dpi_f5 VT_dpi VT_dpi VDD VDD pfet_03v3 L=0.64u W=0.5u nf=1
MMR_VT_dpi_f6 VT_dpi VT_dpi VDD VDD pfet_03v3 L=0.64u W=0.5u nf=1
MMR_VT_dpi_f7 VT_dpi VT_dpi VDD VDD pfet_03v3 L=0.64u W=0.5u nf=1
MMR_VT_dpi_f8 VT_dpi VT_dpi VDD VDD pfet_03v3 L=0.64u W=0.5u nf=1
MMR_VT_dpi_f9 VT_dpi VT_dpi VDD VDD pfet_03v3 L=0.64u W=0.5u nf=1
MMR_VT_dpi_f10 VT_dpi VT_dpi VDD VDD pfet_03v3 L=0.64u W=0.5u nf=1
MMR_VT_dpi_f11 VT_dpi VT_dpi VDD VDD pfet_03v3 L=0.64u W=0.5u nf=1
MMR_VT_dpi_f12 VT_dpi VT_dpi VDD VDD pfet_03v3 L=0.64u W=0.5u nf=1
MMR_VT_dpi_f13 VT_dpi VT_dpi VDD VDD pfet_03v3 L=0.64u W=0.5u nf=1
MMR_VT_dpi_f14 VT_dpi VT_dpi VDD VDD pfet_03v3 L=0.64u W=0.5u nf=1
MMR_VT_dpi_f15 VT_dpi VT_dpi VDD VDD pfet_03v3 L=0.64u W=0.5u nf=1
MMR_VT_dpi_f16 VT_dpi VT_dpi VDD VDD pfet_03v3 L=0.64u W=0.5u nf=1
MMR_VT_dpi_f17 VT_dpi VT_dpi VDD VDD pfet_03v3 L=0.64u W=0.5u nf=1
MMR_VT_dpi_f18 VT_dpi VT_dpi VDD VDD pfet_03v3 L=0.64u W=0.5u nf=1
MMR_VT_dpi_f19 VT_dpi VT_dpi VDD VDD pfet_03v3 L=0.64u W=0.5u nf=1
MMR_VT_dpi_f20 VT_dpi VT_dpi VDD VDD pfet_03v3 L=0.64u W=0.5u nf=1
MMR_VT_dpi_f21 VT_dpi VT_dpi VDD VDD pfet_03v3 L=0.64u W=0.5u nf=1
MMR_VT_dpi_f22 VT_dpi VT_dpi VDD VDD pfet_03v3 L=0.64u W=0.5u nf=1
MMR_VT_dpi_f23 VT_dpi VT_dpi VDD VDD pfet_03v3 L=0.64u W=0.5u nf=1
MMR_VT_dpi_f24 VT_dpi VT_dpi VDD VDD pfet_03v3 L=0.64u W=0.5u nf=1
MMR_VT_dpi_f25 VT_dpi VT_dpi VDD VDD pfet_03v3 L=0.64u W=0.5u nf=1
MMR_VT_dpi_f26 VT_dpi VT_dpi VDD VDD pfet_03v3 L=0.64u W=0.5u nf=1
MMR_VT_dpi_f27 VT_dpi VT_dpi VDD VDD pfet_03v3 L=0.64u W=0.5u nf=1
MMR_VT_dpi_f28 VT_dpi VT_dpi VDD VDD pfet_03v3 L=0.64u W=0.5u nf=1
MMR_VT_dpi_f29 VT_dpi VT_dpi VDD VDD pfet_03v3 L=0.64u W=0.5u nf=1
MMR_VT_dpi_f30 VT_dpi VT_dpi VDD VDD pfet_03v3 L=0.64u W=0.5u nf=1
MMR_VT_dpi_f31 VT_dpi VT_dpi VDD VDD pfet_03v3 L=0.64u W=0.5u nf=1
MMR_VT_inh_f0 VT_inh VT_inh VDD VDD pfet_03v3 L=1.12u W=0.88u nf=1
MMR_VT_inh_f1 VT_inh VT_inh VDD VDD pfet_03v3 L=1.12u W=0.88u nf=1
MMR_VT_inh_f2 VT_inh VT_inh VDD VDD pfet_03v3 L=1.12u W=0.88u nf=1
MMR_VT_inh_f3 VT_inh VT_inh VDD VDD pfet_03v3 L=1.12u W=0.88u nf=1
MMR_VT_inh_f4 VT_inh VT_inh VDD VDD pfet_03v3 L=1.12u W=0.88u nf=1
MMR_VT_inh_f5 VT_inh VT_inh VDD VDD pfet_03v3 L=1.12u W=0.88u nf=1
MMR_VT_inh_f6 VT_inh VT_inh VDD VDD pfet_03v3 L=1.12u W=0.88u nf=1
MMR_VT_inh_f7 VT_inh VT_inh VDD VDD pfet_03v3 L=1.12u W=0.88u nf=1
MMR_VT_inh_f8 VT_inh VT_inh VDD VDD pfet_03v3 L=1.12u W=0.88u nf=1
MMR_VT_inh_f9 VT_inh VT_inh VDD VDD pfet_03v3 L=1.12u W=0.88u nf=1
MMR_VT_inh_f10 VT_inh VT_inh VDD VDD pfet_03v3 L=1.12u W=0.88u nf=1
MMR_VT_inh_f11 VT_inh VT_inh VDD VDD pfet_03v3 L=1.12u W=0.88u nf=1
MMR_VT_inh_f12 VT_inh VT_inh VDD VDD pfet_03v3 L=1.12u W=0.88u nf=1
MMR_VT_inh_f13 VT_inh VT_inh VDD VDD pfet_03v3 L=1.12u W=0.88u nf=1
MMR_VT_inh_f14 VT_inh VT_inh VDD VDD pfet_03v3 L=1.12u W=0.88u nf=1
MMR_VT_inh_f15 VT_inh VT_inh VDD VDD pfet_03v3 L=1.12u W=0.88u nf=1
MDNN0 VSS VSS VSS VSS nfet_03v3 L=2u W=0.5u nf=1
MDNN1 VSS VSS VSS VSS nfet_03v3 L=2u W=0.5u nf=1
MDNN2 VSS VSS VSS VSS nfet_03v3 L=2u W=0.5u nf=1
MDNN3 VSS VSS VSS VSS nfet_03v3 L=2u W=0.5u nf=1
MDNN4 VSS VSS VSS VSS nfet_03v3 L=2u W=0.5u nf=1
MDNN5 VSS VSS VSS VSS nfet_03v3 L=2u W=0.5u nf=1
MDNN6 VSS VSS VSS VSS nfet_03v3 L=2u W=0.5u nf=1
MDNN7 VSS VSS VSS VSS nfet_03v3 L=2u W=0.5u nf=1
MDNN8 VSS VSS VSS VSS nfet_03v3 L=2u W=0.5u nf=1
MDNN9 VSS VSS VSS VSS nfet_03v3 L=2u W=0.5u nf=1
MDNN10 VSS VSS VSS VSS nfet_03v3 L=2u W=0.5u nf=1
MDNN11 VSS VSS VSS VSS nfet_03v3 L=2u W=0.5u nf=1
MDNN12 VSS VSS VSS VSS nfet_03v3 L=2u W=0.5u nf=1
MDNN13 VSS VSS VSS VSS nfet_03v3 L=2u W=0.5u nf=1
MDNN14 VSS VSS VSS VSS nfet_03v3 L=2u W=0.5u nf=1
MDNN15 VSS VSS VSS VSS nfet_03v3 L=2u W=0.5u nf=1
MDNN16 VSS VSS VSS VSS nfet_03v3 L=2u W=0.5u nf=1
MDNN17 VSS VSS VSS VSS nfet_03v3 L=2u W=0.5u nf=1
MDNN18 VSS VSS VSS VSS nfet_03v3 L=2u W=0.5u nf=1
MDNN19 VSS VSS VSS VSS nfet_03v3 L=2u W=0.5u nf=1
MDNN20 VSS VSS VSS VSS nfet_03v3 L=2u W=0.5u nf=1
MDNN21 VSS VSS VSS VSS nfet_03v3 L=2u W=0.5u nf=1
MDNN22 VSS VSS VSS VSS nfet_03v3 L=2u W=0.5u nf=1
MDNN23 VSS VSS VSS VSS nfet_03v3 L=2u W=0.5u nf=1
MDNN24 VSS VSS VSS VSS nfet_03v3 L=2u W=0.5u nf=1
MDNN25 VSS VSS VSS VSS nfet_03v3 L=2u W=0.5u nf=1
MDNN26 VSS VSS VSS VSS nfet_03v3 L=2u W=0.5u nf=1
MDNN27 VSS VSS VSS VSS nfet_03v3 L=2u W=0.5u nf=1
MDNN28 VSS VSS VSS VSS nfet_03v3 L=2u W=0.5u nf=1
MDNN29 VSS VSS VSS VSS nfet_03v3 L=2u W=0.5u nf=1
MDNN30 VSS VSS VSS VSS nfet_03v3 L=2u W=0.5u nf=1
MDNN31 VSS VSS VSS VSS nfet_03v3 L=2u W=0.5u nf=1
MDNN32 VSS VSS VSS VSS nfet_03v3 L=2u W=0.5u nf=1
MDNN33 VSS VSS VSS VSS nfet_03v3 L=2u W=0.5u nf=1
MDNN34 VSS VSS VSS VSS nfet_03v3 L=2u W=0.5u nf=1
MDNN35 VSS VSS VSS VSS nfet_03v3 L=2u W=0.5u nf=1
MDNN36 VSS VSS VSS VSS nfet_03v3 L=2u W=0.5u nf=1
MDNN37 VSS VSS VSS VSS nfet_03v3 L=2u W=0.5u nf=1
MDNN38 VSS VSS VSS VSS nfet_03v3 L=2u W=0.5u nf=1
MDNN39 VSS VSS VSS VSS nfet_03v3 L=2u W=0.5u nf=1
MDNN40 VSS VSS VSS VSS nfet_03v3 L=2u W=0.5u nf=1
MDNN41 VSS VSS VSS VSS nfet_03v3 L=2u W=0.5u nf=1
MDNN42 VSS VSS VSS VSS nfet_03v3 L=2u W=0.5u nf=1
MDNN43 VSS VSS VSS VSS nfet_03v3 L=2u W=0.5u nf=1
MDNN44 VSS VSS VSS VSS nfet_03v3 L=2u W=0.5u nf=1
MDNN45 VSS VSS VSS VSS nfet_03v3 L=2u W=0.5u nf=1
MDNN46 VSS VSS VSS VSS nfet_03v3 L=2u W=0.5u nf=1
MDNN47 VSS VSS VSS VSS nfet_03v3 L=2u W=0.5u nf=1
MDNN48 VSS VSS VSS VSS nfet_03v3 L=2u W=0.5u nf=1
MDNN49 VSS VSS VSS VSS nfet_03v3 L=2u W=0.5u nf=1
MDNN50 VSS VSS VSS VSS nfet_03v3 L=2u W=0.5u nf=1
MDNN51 VSS VSS VSS VSS nfet_03v3 L=2u W=0.5u nf=1
MDNN52 VSS VSS VSS VSS nfet_03v3 L=2u W=0.5u nf=1
MDNN53 VSS VSS VSS VSS nfet_03v3 L=2u W=0.5u nf=1
MDNN54 VSS VSS VSS VSS nfet_03v3 L=2u W=0.5u nf=1
MDNN55 VSS VSS VSS VSS nfet_03v3 L=2u W=0.5u nf=1
MDNN56 VSS VSS VSS VSS nfet_03v3 L=2u W=0.5u nf=1
MDNN57 VSS VSS VSS VSS nfet_03v3 L=2u W=0.5u nf=1
MDNN58 VSS VSS VSS VSS nfet_03v3 L=2u W=0.5u nf=1
MDNN59 VSS VSS VSS VSS nfet_03v3 L=2u W=0.5u nf=1
MDNN60 VSS VSS VSS VSS nfet_03v3 L=2u W=0.5u nf=1
MDNN61 VSS VSS VSS VSS nfet_03v3 L=2u W=0.5u nf=1
MDNN62 VSS VSS VSS VSS nfet_03v3 L=2u W=0.5u nf=1
MDNN63 VSS VSS VSS VSS nfet_03v3 L=2u W=0.5u nf=1
MDNN64 VSS VSS VSS VSS nfet_03v3 L=2u W=0.5u nf=1
MDNN65 VSS VSS VSS VSS nfet_03v3 L=2u W=0.5u nf=1
MDNN66 VSS VSS VSS VSS nfet_03v3 L=2u W=0.5u nf=1
MDNN67 VSS VSS VSS VSS nfet_03v3 L=2u W=0.5u nf=1
MDNN68 VSS VSS VSS VSS nfet_03v3 L=2u W=0.5u nf=1
MDNN69 VSS VSS VSS VSS nfet_03v3 L=2u W=0.5u nf=1
MDNN70 VSS VSS VSS VSS nfet_03v3 L=2u W=0.5u nf=1
MDNN71 VSS VSS VSS VSS nfet_03v3 L=2u W=0.5u nf=1
MDNN72 VSS VSS VSS VSS nfet_03v3 L=2u W=0.5u nf=1
MDNN73 VSS VSS VSS VSS nfet_03v3 L=2u W=0.5u nf=1
MDNN74 VSS VSS VSS VSS nfet_03v3 L=2u W=0.5u nf=1
MDNN75 VSS VSS VSS VSS nfet_03v3 L=2u W=0.5u nf=1
MDNN76 VSS VSS VSS VSS nfet_03v3 L=2u W=0.5u nf=1
MDNN77 VSS VSS VSS VSS nfet_03v3 L=2u W=0.5u nf=1
MDNN78 VSS VSS VSS VSS nfet_03v3 L=2u W=0.5u nf=1
MDNN79 VSS VSS VSS VSS nfet_03v3 L=2u W=0.5u nf=1
MDNN80 VSS VSS VSS VSS nfet_03v3 L=2u W=0.5u nf=1
MDNN81 VSS VSS VSS VSS nfet_03v3 L=2u W=0.5u nf=1
MDNN82 VSS VSS VSS VSS nfet_03v3 L=2u W=0.5u nf=1
MDNN83 VSS VSS VSS VSS nfet_03v3 L=2u W=0.5u nf=1
MDNN84 VSS VSS VSS VSS nfet_03v3 L=2u W=0.5u nf=1
MDNN85 VSS VSS VSS VSS nfet_03v3 L=2u W=0.5u nf=1
MDNN86 VSS VSS VSS VSS nfet_03v3 L=2u W=0.5u nf=1
MDNN87 VSS VSS VSS VSS nfet_03v3 L=2u W=0.5u nf=1
MDNN88 VSS VSS VSS VSS nfet_03v3 L=2u W=0.5u nf=1
MDNN89 VSS VSS VSS VSS nfet_03v3 L=2u W=0.5u nf=1
MDNN90 VSS VSS VSS VSS nfet_03v3 L=2u W=0.5u nf=1
MDNN91 VSS VSS VSS VSS nfet_03v3 L=2u W=0.5u nf=1
MDNN92 VSS VSS VSS VSS nfet_03v3 L=2u W=0.5u nf=1
MDNN93 VSS VSS VSS VSS nfet_03v3 L=2u W=0.5u nf=1
MDNN94 VSS VSS VSS VSS nfet_03v3 L=2u W=0.5u nf=1
MDNN95 VSS VSS VSS VSS nfet_03v3 L=2u W=0.5u nf=1
MDNN96 VSS VSS VSS VSS nfet_03v3 L=2u W=0.5u nf=1
MDNN97 VSS VSS VSS VSS nfet_03v3 L=2u W=0.5u nf=1
MDNN98 VSS VSS VSS VSS nfet_03v3 L=2u W=0.5u nf=1
MDNN99 VSS VSS VSS VSS nfet_03v3 L=2u W=0.5u nf=1
MDNN100 VSS VSS VSS VSS nfet_03v3 L=2u W=0.5u nf=1
MDNN101 VSS VSS VSS VSS nfet_03v3 L=2u W=0.5u nf=1
MDNN102 VSS VSS VSS VSS nfet_03v3 L=2u W=0.5u nf=1
MDNN103 VSS VSS VSS VSS nfet_03v3 L=2u W=0.5u nf=1
MDNN104 VSS VSS VSS VSS nfet_03v3 L=2u W=0.5u nf=1
MDNN105 VSS VSS VSS VSS nfet_03v3 L=2u W=0.5u nf=1
MDNN106 VSS VSS VSS VSS nfet_03v3 L=2u W=0.5u nf=1
MDNN107 VSS VSS VSS VSS nfet_03v3 L=2u W=0.5u nf=1
MDNN108 VSS VSS VSS VSS nfet_03v3 L=2u W=0.5u nf=1
MDNN109 VSS VSS VSS VSS nfet_03v3 L=2u W=0.5u nf=1
MDNN110 VSS VSS VSS VSS nfet_03v3 L=2u W=0.5u nf=1
MDNS0 VSS VSS VSS VSS nfet_03v3 L=2u W=0.5u nf=1
MDNS1 VSS VSS VSS VSS nfet_03v3 L=2u W=0.5u nf=1
MDNS2 VSS VSS VSS VSS nfet_03v3 L=2u W=0.5u nf=1
MDNS3 VSS VSS VSS VSS nfet_03v3 L=2u W=0.5u nf=1
MDNS4 VSS VSS VSS VSS nfet_03v3 L=2u W=0.5u nf=1
MDNS5 VSS VSS VSS VSS nfet_03v3 L=2u W=0.5u nf=1
MDNS6 VSS VSS VSS VSS nfet_03v3 L=2u W=0.5u nf=1
MDNS7 VSS VSS VSS VSS nfet_03v3 L=2u W=0.5u nf=1
MDNS8 VSS VSS VSS VSS nfet_03v3 L=2u W=0.5u nf=1
MDNS9 VSS VSS VSS VSS nfet_03v3 L=2u W=0.5u nf=1
MDNS10 VSS VSS VSS VSS nfet_03v3 L=2u W=0.5u nf=1
MDNS11 VSS VSS VSS VSS nfet_03v3 L=2u W=0.5u nf=1
MDNS12 VSS VSS VSS VSS nfet_03v3 L=2u W=0.5u nf=1
MDNS13 VSS VSS VSS VSS nfet_03v3 L=2u W=0.5u nf=1
MDNS14 VSS VSS VSS VSS nfet_03v3 L=2u W=0.5u nf=1
MDNS15 VSS VSS VSS VSS nfet_03v3 L=2u W=0.5u nf=1
MDNS16 VSS VSS VSS VSS nfet_03v3 L=2u W=0.5u nf=1
MDNS17 VSS VSS VSS VSS nfet_03v3 L=2u W=0.5u nf=1
MDNS18 VSS VSS VSS VSS nfet_03v3 L=2u W=0.5u nf=1
MDNS19 VSS VSS VSS VSS nfet_03v3 L=2u W=0.5u nf=1
MDNS20 VSS VSS VSS VSS nfet_03v3 L=2u W=0.5u nf=1
MDNS21 VSS VSS VSS VSS nfet_03v3 L=2u W=0.5u nf=1
MDNS22 VSS VSS VSS VSS nfet_03v3 L=2u W=0.5u nf=1
MDNS23 VSS VSS VSS VSS nfet_03v3 L=2u W=0.5u nf=1
MDNS24 VSS VSS VSS VSS nfet_03v3 L=2u W=0.5u nf=1
MDNS25 VSS VSS VSS VSS nfet_03v3 L=2u W=0.5u nf=1
MDNS26 VSS VSS VSS VSS nfet_03v3 L=2u W=0.5u nf=1
MDNS27 VSS VSS VSS VSS nfet_03v3 L=2u W=0.5u nf=1
MDNS28 VSS VSS VSS VSS nfet_03v3 L=2u W=0.5u nf=1
MDNS29 VSS VSS VSS VSS nfet_03v3 L=2u W=0.5u nf=1
MDNS30 VSS VSS VSS VSS nfet_03v3 L=2u W=0.5u nf=1
MDNS31 VSS VSS VSS VSS nfet_03v3 L=2u W=0.5u nf=1
MDNS32 VSS VSS VSS VSS nfet_03v3 L=2u W=0.5u nf=1
MDNS33 VSS VSS VSS VSS nfet_03v3 L=2u W=0.5u nf=1
MDNS34 VSS VSS VSS VSS nfet_03v3 L=2u W=0.5u nf=1
MDNS35 VSS VSS VSS VSS nfet_03v3 L=2u W=0.5u nf=1
MDNS36 VSS VSS VSS VSS nfet_03v3 L=2u W=0.5u nf=1
MDNS37 VSS VSS VSS VSS nfet_03v3 L=2u W=0.5u nf=1
MDNS38 VSS VSS VSS VSS nfet_03v3 L=2u W=0.5u nf=1
MDNS39 VSS VSS VSS VSS nfet_03v3 L=2u W=0.5u nf=1
MDNS40 VSS VSS VSS VSS nfet_03v3 L=2u W=0.5u nf=1
MDNS41 VSS VSS VSS VSS nfet_03v3 L=2u W=0.5u nf=1
MDNS42 VSS VSS VSS VSS nfet_03v3 L=2u W=0.5u nf=1
MDNS43 VSS VSS VSS VSS nfet_03v3 L=2u W=0.5u nf=1
MDNS44 VSS VSS VSS VSS nfet_03v3 L=2u W=0.5u nf=1
MDNS45 VSS VSS VSS VSS nfet_03v3 L=2u W=0.5u nf=1
MDNS46 VSS VSS VSS VSS nfet_03v3 L=2u W=0.5u nf=1
MDNS47 VSS VSS VSS VSS nfet_03v3 L=2u W=0.5u nf=1
MDNS48 VSS VSS VSS VSS nfet_03v3 L=2u W=0.5u nf=1
MDNS49 VSS VSS VSS VSS nfet_03v3 L=2u W=0.5u nf=1
MDNS50 VSS VSS VSS VSS nfet_03v3 L=2u W=0.5u nf=1
MDNS51 VSS VSS VSS VSS nfet_03v3 L=2u W=0.5u nf=1
MDNS52 VSS VSS VSS VSS nfet_03v3 L=2u W=0.5u nf=1
MDNS53 VSS VSS VSS VSS nfet_03v3 L=2u W=0.5u nf=1
MDNS54 VSS VSS VSS VSS nfet_03v3 L=2u W=0.5u nf=1
MDNS55 VSS VSS VSS VSS nfet_03v3 L=2u W=0.5u nf=1
MDNS56 VSS VSS VSS VSS nfet_03v3 L=2u W=0.5u nf=1
MDNS57 VSS VSS VSS VSS nfet_03v3 L=2u W=0.5u nf=1
MDNS58 VSS VSS VSS VSS nfet_03v3 L=2u W=0.5u nf=1
MDNS59 VSS VSS VSS VSS nfet_03v3 L=2u W=0.5u nf=1
MDNS60 VSS VSS VSS VSS nfet_03v3 L=2u W=0.5u nf=1
MDNS61 VSS VSS VSS VSS nfet_03v3 L=2u W=0.5u nf=1
MDNS62 VSS VSS VSS VSS nfet_03v3 L=2u W=0.5u nf=1
MDNS63 VSS VSS VSS VSS nfet_03v3 L=2u W=0.5u nf=1
MDNS64 VSS VSS VSS VSS nfet_03v3 L=2u W=0.5u nf=1
MDNS65 VSS VSS VSS VSS nfet_03v3 L=2u W=0.5u nf=1
MDNS66 VSS VSS VSS VSS nfet_03v3 L=2u W=0.5u nf=1
MDNS67 VSS VSS VSS VSS nfet_03v3 L=2u W=0.5u nf=1
MDNS68 VSS VSS VSS VSS nfet_03v3 L=2u W=0.5u nf=1
MDNS69 VSS VSS VSS VSS nfet_03v3 L=2u W=0.5u nf=1
MDNS70 VSS VSS VSS VSS nfet_03v3 L=2u W=0.5u nf=1
MDNS71 VSS VSS VSS VSS nfet_03v3 L=2u W=0.5u nf=1
MDNS72 VSS VSS VSS VSS nfet_03v3 L=2u W=0.5u nf=1
MDNS73 VSS VSS VSS VSS nfet_03v3 L=2u W=0.5u nf=1
MDNS74 VSS VSS VSS VSS nfet_03v3 L=2u W=0.5u nf=1
MDNS75 VSS VSS VSS VSS nfet_03v3 L=2u W=0.5u nf=1
MDNS76 VSS VSS VSS VSS nfet_03v3 L=2u W=0.5u nf=1
MDNS77 VSS VSS VSS VSS nfet_03v3 L=2u W=0.5u nf=1
MDNS78 VSS VSS VSS VSS nfet_03v3 L=2u W=0.5u nf=1
MDNS79 VSS VSS VSS VSS nfet_03v3 L=2u W=0.5u nf=1
MDNS80 VSS VSS VSS VSS nfet_03v3 L=2u W=0.5u nf=1
MDNS81 VSS VSS VSS VSS nfet_03v3 L=2u W=0.5u nf=1
MDNS82 VSS VSS VSS VSS nfet_03v3 L=2u W=0.5u nf=1
MDNS83 VSS VSS VSS VSS nfet_03v3 L=2u W=0.5u nf=1
MDNS84 VSS VSS VSS VSS nfet_03v3 L=2u W=0.5u nf=1
MDNS85 VSS VSS VSS VSS nfet_03v3 L=2u W=0.5u nf=1
MDNS86 VSS VSS VSS VSS nfet_03v3 L=2u W=0.5u nf=1
MDNS87 VSS VSS VSS VSS nfet_03v3 L=2u W=0.5u nf=1
MDNS88 VSS VSS VSS VSS nfet_03v3 L=2u W=0.5u nf=1
MDNS89 VSS VSS VSS VSS nfet_03v3 L=2u W=0.5u nf=1
MDNS90 VSS VSS VSS VSS nfet_03v3 L=2u W=0.5u nf=1
MDNS91 VSS VSS VSS VSS nfet_03v3 L=2u W=0.5u nf=1
MDNS92 VSS VSS VSS VSS nfet_03v3 L=2u W=0.5u nf=1
MDNS93 VSS VSS VSS VSS nfet_03v3 L=2u W=0.5u nf=1
MDNS94 VSS VSS VSS VSS nfet_03v3 L=2u W=0.5u nf=1
MDNS95 VSS VSS VSS VSS nfet_03v3 L=2u W=0.5u nf=1
MDNS96 VSS VSS VSS VSS nfet_03v3 L=2u W=0.5u nf=1
MDNS97 VSS VSS VSS VSS nfet_03v3 L=2u W=0.5u nf=1
MDNS98 VSS VSS VSS VSS nfet_03v3 L=2u W=0.5u nf=1
MDNS99 VSS VSS VSS VSS nfet_03v3 L=2u W=0.5u nf=1
MDNS100 VSS VSS VSS VSS nfet_03v3 L=2u W=0.5u nf=1
MDNS101 VSS VSS VSS VSS nfet_03v3 L=2u W=0.5u nf=1
MDNS102 VSS VSS VSS VSS nfet_03v3 L=2u W=0.5u nf=1
MDNS103 VSS VSS VSS VSS nfet_03v3 L=2u W=0.5u nf=1
MDNS104 VSS VSS VSS VSS nfet_03v3 L=2u W=0.5u nf=1
MDNS105 VSS VSS VSS VSS nfet_03v3 L=2u W=0.5u nf=1
MDNS106 VSS VSS VSS VSS nfet_03v3 L=2u W=0.5u nf=1
MDNS107 VSS VSS VSS VSS nfet_03v3 L=2u W=0.5u nf=1
MDNS108 VSS VSS VSS VSS nfet_03v3 L=2u W=0.5u nf=1
MDNS109 VSS VSS VSS VSS nfet_03v3 L=2u W=0.5u nf=1
MDNS110 VSS VSS VSS VSS nfet_03v3 L=2u W=0.5u nf=1
MDNW0 VSS VSS VSS VSS nfet_03v3 L=2u W=10u nf=1
MDNE0 VSS VSS VSS VSS nfet_03v3 L=2u W=10u nf=1
MDPN0 VDD VDD VDD VDD pfet_03v3 L=2u W=0.5u nf=1
MDPN1 VDD VDD VDD VDD pfet_03v3 L=2u W=0.5u nf=1
MDPN2 VDD VDD VDD VDD pfet_03v3 L=2u W=0.5u nf=1
MDPN3 VDD VDD VDD VDD pfet_03v3 L=2u W=0.5u nf=1
MDPN4 VDD VDD VDD VDD pfet_03v3 L=2u W=0.5u nf=1
MDPN5 VDD VDD VDD VDD pfet_03v3 L=2u W=0.5u nf=1
MDPN6 VDD VDD VDD VDD pfet_03v3 L=2u W=0.5u nf=1
MDPN7 VDD VDD VDD VDD pfet_03v3 L=2u W=0.5u nf=1
MDPN8 VDD VDD VDD VDD pfet_03v3 L=2u W=0.5u nf=1
MDPN9 VDD VDD VDD VDD pfet_03v3 L=2u W=0.5u nf=1
MDPN10 VDD VDD VDD VDD pfet_03v3 L=2u W=0.5u nf=1
MDPN11 VDD VDD VDD VDD pfet_03v3 L=2u W=0.5u nf=1
MDPN12 VDD VDD VDD VDD pfet_03v3 L=2u W=0.5u nf=1
MDPN13 VDD VDD VDD VDD pfet_03v3 L=2u W=0.5u nf=1
MDPN14 VDD VDD VDD VDD pfet_03v3 L=2u W=0.5u nf=1
MDPN15 VDD VDD VDD VDD pfet_03v3 L=2u W=0.5u nf=1
MDPN16 VDD VDD VDD VDD pfet_03v3 L=2u W=0.5u nf=1
MDPN17 VDD VDD VDD VDD pfet_03v3 L=2u W=0.5u nf=1
MDPN18 VDD VDD VDD VDD pfet_03v3 L=2u W=0.5u nf=1
MDPN19 VDD VDD VDD VDD pfet_03v3 L=2u W=0.5u nf=1
MDPN20 VDD VDD VDD VDD pfet_03v3 L=2u W=0.5u nf=1
MDPN21 VDD VDD VDD VDD pfet_03v3 L=2u W=0.5u nf=1
MDPN22 VDD VDD VDD VDD pfet_03v3 L=2u W=0.5u nf=1
MDPN23 VDD VDD VDD VDD pfet_03v3 L=2u W=0.5u nf=1
MDPN24 VDD VDD VDD VDD pfet_03v3 L=2u W=0.5u nf=1
MDPN25 VDD VDD VDD VDD pfet_03v3 L=2u W=0.5u nf=1
MDPN26 VDD VDD VDD VDD pfet_03v3 L=2u W=0.5u nf=1
MDPN27 VDD VDD VDD VDD pfet_03v3 L=2u W=0.5u nf=1
MDPN28 VDD VDD VDD VDD pfet_03v3 L=2u W=0.5u nf=1
MDPN29 VDD VDD VDD VDD pfet_03v3 L=2u W=0.5u nf=1
MDPN30 VDD VDD VDD VDD pfet_03v3 L=2u W=0.5u nf=1
MDPN31 VDD VDD VDD VDD pfet_03v3 L=2u W=0.5u nf=1
MDPN32 VDD VDD VDD VDD pfet_03v3 L=2u W=0.5u nf=1
MDPN33 VDD VDD VDD VDD pfet_03v3 L=2u W=0.5u nf=1
MDPN34 VDD VDD VDD VDD pfet_03v3 L=2u W=0.5u nf=1
MDPN35 VDD VDD VDD VDD pfet_03v3 L=2u W=0.5u nf=1
MDPN36 VDD VDD VDD VDD pfet_03v3 L=2u W=0.5u nf=1
MDPN37 VDD VDD VDD VDD pfet_03v3 L=2u W=0.5u nf=1
MDPN38 VDD VDD VDD VDD pfet_03v3 L=2u W=0.5u nf=1
MDPN39 VDD VDD VDD VDD pfet_03v3 L=2u W=0.5u nf=1
MDPN40 VDD VDD VDD VDD pfet_03v3 L=2u W=0.5u nf=1
MDPN41 VDD VDD VDD VDD pfet_03v3 L=2u W=0.5u nf=1
MDPN42 VDD VDD VDD VDD pfet_03v3 L=2u W=0.5u nf=1
MDPN43 VDD VDD VDD VDD pfet_03v3 L=2u W=0.5u nf=1
MDPN44 VDD VDD VDD VDD pfet_03v3 L=2u W=0.5u nf=1
MDPN45 VDD VDD VDD VDD pfet_03v3 L=2u W=0.5u nf=1
MDPN46 VDD VDD VDD VDD pfet_03v3 L=2u W=0.5u nf=1
MDPN47 VDD VDD VDD VDD pfet_03v3 L=2u W=0.5u nf=1
MDPN48 VDD VDD VDD VDD pfet_03v3 L=2u W=0.5u nf=1
MDPN49 VDD VDD VDD VDD pfet_03v3 L=2u W=0.5u nf=1
MDPN50 VDD VDD VDD VDD pfet_03v3 L=2u W=0.5u nf=1
MDPN51 VDD VDD VDD VDD pfet_03v3 L=2u W=0.5u nf=1
MDPN52 VDD VDD VDD VDD pfet_03v3 L=2u W=0.5u nf=1
MDPN53 VDD VDD VDD VDD pfet_03v3 L=2u W=0.5u nf=1
MDPN54 VDD VDD VDD VDD pfet_03v3 L=2u W=0.5u nf=1
MDPN55 VDD VDD VDD VDD pfet_03v3 L=2u W=0.5u nf=1
MDPN56 VDD VDD VDD VDD pfet_03v3 L=2u W=0.5u nf=1
MDPN57 VDD VDD VDD VDD pfet_03v3 L=2u W=0.5u nf=1
MDPN58 VDD VDD VDD VDD pfet_03v3 L=2u W=0.5u nf=1
MDPN59 VDD VDD VDD VDD pfet_03v3 L=2u W=0.5u nf=1
MDPN60 VDD VDD VDD VDD pfet_03v3 L=2u W=0.5u nf=1
MDPN61 VDD VDD VDD VDD pfet_03v3 L=2u W=0.5u nf=1
MDPN62 VDD VDD VDD VDD pfet_03v3 L=2u W=0.5u nf=1
MDPN63 VDD VDD VDD VDD pfet_03v3 L=2u W=0.5u nf=1
MDPN64 VDD VDD VDD VDD pfet_03v3 L=2u W=0.5u nf=1
MDPN65 VDD VDD VDD VDD pfet_03v3 L=2u W=0.5u nf=1
MDPN66 VDD VDD VDD VDD pfet_03v3 L=2u W=0.5u nf=1
MDPN67 VDD VDD VDD VDD pfet_03v3 L=2u W=0.5u nf=1
MDPN68 VDD VDD VDD VDD pfet_03v3 L=2u W=0.5u nf=1
MDPN69 VDD VDD VDD VDD pfet_03v3 L=2u W=0.5u nf=1
MDPN70 VDD VDD VDD VDD pfet_03v3 L=2u W=0.5u nf=1
MDPN71 VDD VDD VDD VDD pfet_03v3 L=2u W=0.5u nf=1
MDPN72 VDD VDD VDD VDD pfet_03v3 L=2u W=0.5u nf=1
MDPN73 VDD VDD VDD VDD pfet_03v3 L=2u W=0.5u nf=1
MDPN74 VDD VDD VDD VDD pfet_03v3 L=2u W=0.5u nf=1
MDPN75 VDD VDD VDD VDD pfet_03v3 L=2u W=0.5u nf=1
MDPN76 VDD VDD VDD VDD pfet_03v3 L=2u W=0.5u nf=1
MDPN77 VDD VDD VDD VDD pfet_03v3 L=2u W=0.5u nf=1
MDPN78 VDD VDD VDD VDD pfet_03v3 L=2u W=0.5u nf=1
MDPN79 VDD VDD VDD VDD pfet_03v3 L=2u W=0.5u nf=1
MDPN80 VDD VDD VDD VDD pfet_03v3 L=2u W=0.5u nf=1
MDPN81 VDD VDD VDD VDD pfet_03v3 L=2u W=0.5u nf=1
MDPN82 VDD VDD VDD VDD pfet_03v3 L=2u W=0.5u nf=1
MDPN83 VDD VDD VDD VDD pfet_03v3 L=2u W=0.5u nf=1
MDPN84 VDD VDD VDD VDD pfet_03v3 L=2u W=0.5u nf=1
MDPN85 VDD VDD VDD VDD pfet_03v3 L=2u W=0.5u nf=1
MDPN86 VDD VDD VDD VDD pfet_03v3 L=2u W=0.5u nf=1
MDPN87 VDD VDD VDD VDD pfet_03v3 L=2u W=0.5u nf=1
MDPN88 VDD VDD VDD VDD pfet_03v3 L=2u W=0.5u nf=1
MDPN89 VDD VDD VDD VDD pfet_03v3 L=2u W=0.5u nf=1
MDPN90 VDD VDD VDD VDD pfet_03v3 L=2u W=0.5u nf=1
MDPN91 VDD VDD VDD VDD pfet_03v3 L=2u W=0.5u nf=1
MDPN92 VDD VDD VDD VDD pfet_03v3 L=2u W=0.5u nf=1
MDPN93 VDD VDD VDD VDD pfet_03v3 L=2u W=0.5u nf=1
MDPN94 VDD VDD VDD VDD pfet_03v3 L=2u W=0.5u nf=1
MDPN95 VDD VDD VDD VDD pfet_03v3 L=2u W=0.5u nf=1
MDPN96 VDD VDD VDD VDD pfet_03v3 L=2u W=0.5u nf=1
MDPN97 VDD VDD VDD VDD pfet_03v3 L=2u W=0.5u nf=1
MDPN98 VDD VDD VDD VDD pfet_03v3 L=2u W=0.5u nf=1
MDPN99 VDD VDD VDD VDD pfet_03v3 L=2u W=0.5u nf=1
MDPS0 VDD VDD VDD VDD pfet_03v3 L=2u W=0.5u nf=1
MDPS1 VDD VDD VDD VDD pfet_03v3 L=2u W=0.5u nf=1
MDPS2 VDD VDD VDD VDD pfet_03v3 L=2u W=0.5u nf=1
MDPS3 VDD VDD VDD VDD pfet_03v3 L=2u W=0.5u nf=1
MDPS4 VDD VDD VDD VDD pfet_03v3 L=2u W=0.5u nf=1
MDPS5 VDD VDD VDD VDD pfet_03v3 L=2u W=0.5u nf=1
MDPS6 VDD VDD VDD VDD pfet_03v3 L=2u W=0.5u nf=1
MDPS7 VDD VDD VDD VDD pfet_03v3 L=2u W=0.5u nf=1
MDPS8 VDD VDD VDD VDD pfet_03v3 L=2u W=0.5u nf=1
MDPS9 VDD VDD VDD VDD pfet_03v3 L=2u W=0.5u nf=1
MDPS10 VDD VDD VDD VDD pfet_03v3 L=2u W=0.5u nf=1
MDPS11 VDD VDD VDD VDD pfet_03v3 L=2u W=0.5u nf=1
MDPS12 VDD VDD VDD VDD pfet_03v3 L=2u W=0.5u nf=1
MDPS13 VDD VDD VDD VDD pfet_03v3 L=2u W=0.5u nf=1
MDPS14 VDD VDD VDD VDD pfet_03v3 L=2u W=0.5u nf=1
MDPS15 VDD VDD VDD VDD pfet_03v3 L=2u W=0.5u nf=1
MDPS16 VDD VDD VDD VDD pfet_03v3 L=2u W=0.5u nf=1
MDPS17 VDD VDD VDD VDD pfet_03v3 L=2u W=0.5u nf=1
MDPS18 VDD VDD VDD VDD pfet_03v3 L=2u W=0.5u nf=1
MDPS19 VDD VDD VDD VDD pfet_03v3 L=2u W=0.5u nf=1
MDPS20 VDD VDD VDD VDD pfet_03v3 L=2u W=0.5u nf=1
MDPS21 VDD VDD VDD VDD pfet_03v3 L=2u W=0.5u nf=1
MDPS22 VDD VDD VDD VDD pfet_03v3 L=2u W=0.5u nf=1
MDPS23 VDD VDD VDD VDD pfet_03v3 L=2u W=0.5u nf=1
MDPS24 VDD VDD VDD VDD pfet_03v3 L=2u W=0.5u nf=1
MDPS25 VDD VDD VDD VDD pfet_03v3 L=2u W=0.5u nf=1
MDPS26 VDD VDD VDD VDD pfet_03v3 L=2u W=0.5u nf=1
MDPS27 VDD VDD VDD VDD pfet_03v3 L=2u W=0.5u nf=1
MDPS28 VDD VDD VDD VDD pfet_03v3 L=2u W=0.5u nf=1
MDPS29 VDD VDD VDD VDD pfet_03v3 L=2u W=0.5u nf=1
MDPS30 VDD VDD VDD VDD pfet_03v3 L=2u W=0.5u nf=1
MDPS31 VDD VDD VDD VDD pfet_03v3 L=2u W=0.5u nf=1
MDPS32 VDD VDD VDD VDD pfet_03v3 L=2u W=0.5u nf=1
MDPS33 VDD VDD VDD VDD pfet_03v3 L=2u W=0.5u nf=1
MDPS34 VDD VDD VDD VDD pfet_03v3 L=2u W=0.5u nf=1
MDPS35 VDD VDD VDD VDD pfet_03v3 L=2u W=0.5u nf=1
MDPS36 VDD VDD VDD VDD pfet_03v3 L=2u W=0.5u nf=1
MDPS37 VDD VDD VDD VDD pfet_03v3 L=2u W=0.5u nf=1
MDPS38 VDD VDD VDD VDD pfet_03v3 L=2u W=0.5u nf=1
MDPS39 VDD VDD VDD VDD pfet_03v3 L=2u W=0.5u nf=1
MDPS40 VDD VDD VDD VDD pfet_03v3 L=2u W=0.5u nf=1
MDPS41 VDD VDD VDD VDD pfet_03v3 L=2u W=0.5u nf=1
MDPS42 VDD VDD VDD VDD pfet_03v3 L=2u W=0.5u nf=1
MDPS43 VDD VDD VDD VDD pfet_03v3 L=2u W=0.5u nf=1
MDPS44 VDD VDD VDD VDD pfet_03v3 L=2u W=0.5u nf=1
MDPS45 VDD VDD VDD VDD pfet_03v3 L=2u W=0.5u nf=1
MDPS46 VDD VDD VDD VDD pfet_03v3 L=2u W=0.5u nf=1
MDPS47 VDD VDD VDD VDD pfet_03v3 L=2u W=0.5u nf=1
MDPS48 VDD VDD VDD VDD pfet_03v3 L=2u W=0.5u nf=1
MDPS49 VDD VDD VDD VDD pfet_03v3 L=2u W=0.5u nf=1
MDPS50 VDD VDD VDD VDD pfet_03v3 L=2u W=0.5u nf=1
MDPS51 VDD VDD VDD VDD pfet_03v3 L=2u W=0.5u nf=1
MDPS52 VDD VDD VDD VDD pfet_03v3 L=2u W=0.5u nf=1
MDPS53 VDD VDD VDD VDD pfet_03v3 L=2u W=0.5u nf=1
MDPS54 VDD VDD VDD VDD pfet_03v3 L=2u W=0.5u nf=1
MDPS55 VDD VDD VDD VDD pfet_03v3 L=2u W=0.5u nf=1
MDPS56 VDD VDD VDD VDD pfet_03v3 L=2u W=0.5u nf=1
MDPS57 VDD VDD VDD VDD pfet_03v3 L=2u W=0.5u nf=1
MDPS58 VDD VDD VDD VDD pfet_03v3 L=2u W=0.5u nf=1
MDPS59 VDD VDD VDD VDD pfet_03v3 L=2u W=0.5u nf=1
MDPS60 VDD VDD VDD VDD pfet_03v3 L=2u W=0.5u nf=1
MDPS61 VDD VDD VDD VDD pfet_03v3 L=2u W=0.5u nf=1
MDPS62 VDD VDD VDD VDD pfet_03v3 L=2u W=0.5u nf=1
MDPS63 VDD VDD VDD VDD pfet_03v3 L=2u W=0.5u nf=1
MDPS64 VDD VDD VDD VDD pfet_03v3 L=2u W=0.5u nf=1
MDPS65 VDD VDD VDD VDD pfet_03v3 L=2u W=0.5u nf=1
MDPS66 VDD VDD VDD VDD pfet_03v3 L=2u W=0.5u nf=1
MDPS67 VDD VDD VDD VDD pfet_03v3 L=2u W=0.5u nf=1
MDPS68 VDD VDD VDD VDD pfet_03v3 L=2u W=0.5u nf=1
MDPS69 VDD VDD VDD VDD pfet_03v3 L=2u W=0.5u nf=1
MDPS70 VDD VDD VDD VDD pfet_03v3 L=2u W=0.5u nf=1
MDPS71 VDD VDD VDD VDD pfet_03v3 L=2u W=0.5u nf=1
MDPS72 VDD VDD VDD VDD pfet_03v3 L=2u W=0.5u nf=1
MDPS73 VDD VDD VDD VDD pfet_03v3 L=2u W=0.5u nf=1
MDPS74 VDD VDD VDD VDD pfet_03v3 L=2u W=0.5u nf=1
MDPS75 VDD VDD VDD VDD pfet_03v3 L=2u W=0.5u nf=1
MDPS76 VDD VDD VDD VDD pfet_03v3 L=2u W=0.5u nf=1
MDPS77 VDD VDD VDD VDD pfet_03v3 L=2u W=0.5u nf=1
MDPS78 VDD VDD VDD VDD pfet_03v3 L=2u W=0.5u nf=1
MDPS79 VDD VDD VDD VDD pfet_03v3 L=2u W=0.5u nf=1
MDPS80 VDD VDD VDD VDD pfet_03v3 L=2u W=0.5u nf=1
MDPS81 VDD VDD VDD VDD pfet_03v3 L=2u W=0.5u nf=1
MDPS82 VDD VDD VDD VDD pfet_03v3 L=2u W=0.5u nf=1
MDPS83 VDD VDD VDD VDD pfet_03v3 L=2u W=0.5u nf=1
MDPS84 VDD VDD VDD VDD pfet_03v3 L=2u W=0.5u nf=1
MDPS85 VDD VDD VDD VDD pfet_03v3 L=2u W=0.5u nf=1
MDPS86 VDD VDD VDD VDD pfet_03v3 L=2u W=0.5u nf=1
MDPS87 VDD VDD VDD VDD pfet_03v3 L=2u W=0.5u nf=1
MDPS88 VDD VDD VDD VDD pfet_03v3 L=2u W=0.5u nf=1
MDPS89 VDD VDD VDD VDD pfet_03v3 L=2u W=0.5u nf=1
MDPS90 VDD VDD VDD VDD pfet_03v3 L=2u W=0.5u nf=1
MDPS91 VDD VDD VDD VDD pfet_03v3 L=2u W=0.5u nf=1
MDPS92 VDD VDD VDD VDD pfet_03v3 L=2u W=0.5u nf=1
MDPS93 VDD VDD VDD VDD pfet_03v3 L=2u W=0.5u nf=1
MDPS94 VDD VDD VDD VDD pfet_03v3 L=2u W=0.5u nf=1
MDPS95 VDD VDD VDD VDD pfet_03v3 L=2u W=0.5u nf=1
MDPS96 VDD VDD VDD VDD pfet_03v3 L=2u W=0.5u nf=1
MDPS97 VDD VDD VDD VDD pfet_03v3 L=2u W=0.5u nf=1
MDPS98 VDD VDD VDD VDD pfet_03v3 L=2u W=0.5u nf=1
MDPS99 VDD VDD VDD VDD pfet_03v3 L=2u W=0.5u nf=1
MDPW0 VDD VDD VDD VDD pfet_03v3 L=2u W=12.94u nf=1
MDPE0 VDD VDD VDD VDD pfet_03v3 L=2u W=12.94u nf=1
.ends
