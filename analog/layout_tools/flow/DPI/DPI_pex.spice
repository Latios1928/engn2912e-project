* NGSPICE file created from DPI_flat.ext - technology: gf180mcuD

.subckt DPI_flat Vthr Isum Isyn VT VSS VDD
X0 VDD.t8 VDD.t6 VDD.t8 VDD.t7 pfet_03v3 ad=0.14p pd=1.06u as=0 ps=0 w=0.5u l=2u
X1 Isum.t25 Isum.t23 Isum.t25 Isum.t24 nfet_03v3 ad=0.14p pd=1.06u as=0 ps=0 w=0.5u l=2u
X2 Isum.t37 Isum.t36 Isum.t37 Isum.t9 nfet_03v3 ad=0.14p pd=1.06u as=0 ps=0 w=0.5u l=2u
X3 VDD.t0 Vthr.t0 Isum.t1 Isum.t0 nfet_03v3 ad=2.4p pd=9.2u as=2.4p ps=9.2u w=4u l=5.12u
X4 VDD.t14 VDD.t12 VDD.t14 VDD.t13 pfet_03v3 ad=0.14p pd=1.06u as=0 ps=0 w=0.5u l=2u
X5 VDD.t11 VDD.t9 VDD.t11 VDD.t10 pfet_03v3 ad=0.14p pd=1.06u as=0 ps=0 w=0.5u l=2u
X6 Isum.t13 Isum.t11 Isum.t13 Isum.t12 nfet_03v3 ad=0.14p pd=1.06u as=0 ps=0 w=0.5u l=2u
X7 VDD.t32 VDD.t30 VDD.t32 VDD.t31 pfet_03v3 ad=2.4p pd=9.2u as=0 ps=0 w=4u l=2u
X8 VDD.t48 VDD.t47 VDD.t48 VDD.t25 pfet_03v3 ad=0.14p pd=1.06u as=0 ps=0 w=0.5u l=2u
X9 Isum.t47 Isum.t46 Isum.t47 Isum.t24 nfet_03v3 ad=0.14p pd=1.06u as=0 ps=0 w=0.5u l=2u
X10 VDD.t46 VDD.t45 VDD.t46 VDD.t22 pfet_03v3 ad=0.14p pd=1.06u as=0 ps=0 w=0.5u l=2u
X11 VDD.t29 VDD.t27 VDD.t29 VDD.t28 pfet_03v3 ad=2.4p pd=9.2u as=0 ps=0 w=4u l=2u
X12 VDD.t20 VDD.t18 VDD.t20 VDD.t19 pfet_03v3 ad=0.14p pd=1.06u as=0 ps=0 w=0.5u l=2u
X13 Isum.t33 Isum.t32 Isum.t33 Isum.t3 nfet_03v3 ad=0.3p pd=2.2u as=0 ps=0 w=0.5u l=2u
X14 VDD.t17 VDD.t15 VDD.t17 VDD.t16 pfet_03v3 ad=0.14p pd=1.06u as=0 ps=0 w=0.5u l=2u
X15 Isum.t41 Isum.t40 Isum.t41 Isum.t15 nfet_03v3 ad=0.14p pd=1.06u as=0 ps=0 w=0.5u l=2u
X16 Isum.t16 Isum.t14 Isum.t16 Isum.t15 nfet_03v3 ad=0.14p pd=1.06u as=0 ps=0 w=0.5u l=2u
X17 Isum.t28 Isum.t26 Isum.t28 Isum.t27 nfet_03v3 ad=2.4p pd=9.2u as=0 ps=0 w=4u l=2u
X18 Isum.t31 Isum.t29 Isum.t31 Isum.t30 nfet_03v3 ad=2.4p pd=9.2u as=0 ps=0 w=4u l=2u
X19 Isum.t10 Isum.t8 Isum.t10 Isum.t9 nfet_03v3 ad=0.14p pd=1.06u as=0 ps=0 w=0.5u l=2u
X20 a_n100_5015# a_n100_5015# Isum.t49 Isum.t48 nfet_03v3 ad=2.4p pd=9.2u as=2.4p ps=9.2u w=4u l=5.12u
X21 VDD.t26 VDD.t24 VDD.t26 VDD.t25 pfet_03v3 ad=0.14p pd=1.06u as=0 ps=0 w=0.5u l=2u
X22 VDD.t34 VDD.t33 VDD.t34 VDD.t4 pfet_03v3 ad=0.3p pd=2.2u as=0 ps=0 w=0.5u l=2u
X23 VDD.t23 VDD.t21 VDD.t23 VDD.t22 pfet_03v3 ad=0.14p pd=1.06u as=0 ps=0 w=0.5u l=2u
X24 VDD.t36 VDD.t35 VDD.t36 VDD.t7 pfet_03v3 ad=0.14p pd=1.06u as=0 ps=0 w=0.5u l=2u
X25 Isum.t45 Isum.t44 Isum.t45 Isum.t21 nfet_03v3 ad=0.14p pd=1.06u as=0 ps=0 w=0.5u l=2u
X26 Isum.t22 Isum.t20 Isum.t22 Isum.t21 nfet_03v3 ad=0.14p pd=1.06u as=0 ps=0 w=0.5u l=2u
X27 Isum.t19 Isum.t17 Isum.t19 Isum.t18 nfet_03v3 ad=0.14p pd=1.06u as=0 ps=0 w=0.5u l=2u
X28 VDD.t40 VDD.t39 VDD.t40 VDD.t13 pfet_03v3 ad=0.14p pd=1.06u as=0 ps=0 w=0.5u l=2u
X29 VDD.t38 VDD.t37 VDD.t38 VDD.t10 pfet_03v3 ad=0.14p pd=1.06u as=0 ps=0 w=0.5u l=2u
X30 Isum.t7 Isum.t5 Isum.t7 Isum.t6 nfet_03v3 ad=0.14p pd=1.06u as=0 ps=0 w=0.5u l=2u
X31 Isum.t39 Isum.t38 Isum.t39 Isum.t12 nfet_03v3 ad=0.14p pd=1.06u as=0 ps=0 w=0.5u l=2u
X32 VDD.t2 VT.t0 a_n100_5015# VDD.t1 pfet_03v3 ad=2.4p pd=9.2u as=2.4p ps=9.2u w=4u l=5.12u
X33 Isum.t35 Isum.t34 Isum.t35 Isum.t6 nfet_03v3 ad=0.14p pd=1.06u as=0 ps=0 w=0.5u l=2u
X34 Isum.t43 Isum.t42 Isum.t43 Isum.t18 nfet_03v3 ad=0.14p pd=1.06u as=0 ps=0 w=0.5u l=2u
X35 VDD.t44 VDD.t43 VDD.t44 VDD.t19 pfet_03v3 ad=0.14p pd=1.06u as=0 ps=0 w=0.5u l=2u
X36 VDD.t51 a_n100_5015# cap_mim_2f0_m4m5_noshield c_width=22.18u c_length=22.18u
X37 VDD.t5 VDD.t3 VDD.t5 VDD.t4 pfet_03v3 ad=0.3p pd=2.2u as=0 ps=0 w=0.5u l=2u
X38 VDD.t50 a_n100_5015# Isyn.t0 VDD.t49 pfet_03v3 ad=2.4p pd=9.2u as=2.4p ps=9.2u w=4u l=5.12u
X39 VDD.t42 VDD.t41 VDD.t42 VDD.t16 pfet_03v3 ad=0.14p pd=1.06u as=0 ps=0 w=0.5u l=2u
X40 Isum.t4 Isum.t2 Isum.t4 Isum.t3 nfet_03v3 ad=0.3p pd=2.2u as=0 ps=0 w=0.5u l=2u
R0 Vthr Vthr.t0 18.625
R1 Isyn Isyn.t0 17.9906
R2 VT VT.t0 17.7754
R3 Isum.n431 Isum.n348 50500.6
R4 Isum.n347 Isum.n156 286.904
R5 Isum.n430 Isum.n152 286.904
R6 Isum.n430 Isum.n154 286.904
R7 Isum.n347 Isum.n157 286.904
R8 Isum.n331 Isum.n69 181.125
R9 Isum.n577 Isum.n38 181.125
R10 Isum.n331 Isum.n330 181.125
R11 Isum.n579 Isum.n38 181.125
R12 Isum.n348 Isum.n155 121.71
R13 Isum.n432 Isum.n431 106.02
R14 Isum.n164 Isum.n155 76.0684
R15 Isum.n340 Isum.n164 76.0684
R16 Isum.n340 Isum.n165 76.0684
R17 Isum.n334 Isum.n165 76.0684
R18 Isum.n334 Isum.n333 76.0684
R19 Isum.n329 Isum.n178 76.0684
R20 Isum.n329 Isum.n182 76.0684
R21 Isum.n260 Isum.n253 76.0684
R22 Isum.n260 Isum.n255 76.0684
R23 Isum.n270 Isum.n227 76.0684
R24 Isum.n278 Isum.n227 76.0684
R25 Isum.n290 Isum.n220 76.0684
R26 Isum.n290 Isum.n289 76.0684
R27 Isum.n299 Isum.n6 76.0684
R28 Isum.n605 Isum.n6 76.0684
R29 Isum.n605 Isum.n8 76.0684
R30 Isum.n599 Isum.n20 76.0684
R31 Isum.n378 Isum.n20 76.0684
R32 Isum.n386 Isum.n364 76.0684
R33 Isum.n398 Isum.n364 76.0684
R34 Isum.n407 Isum.n358 76.0684
R35 Isum.n408 Isum.n407 76.0684
R36 Isum.n578 Isum.n39 76.0684
R37 Isum.n578 Isum.n41 76.0684
R38 Isum.n441 Isum.n440 76.0684
R39 Isum.n440 Isum.n439 76.0684
R40 Isum.n439 Isum.n143 76.0684
R41 Isum.n433 Isum.n143 76.0684
R42 Isum.n433 Isum.n432 76.0684
R43 Isum.n289 Isum.t15 68.4616
R44 Isum.n599 Isum.t12 68.4616
R45 Isum.n332 Isum.n178 53.248
R46 Isum.n253 Isum.t24 53.248
R47 Isum.n278 Isum.t18 53.248
R48 Isum.n386 Isum.t9 53.248
R49 Isum.n408 Isum.t3 53.248
R50 Isum.n139 Isum.n41 53.248
R51 Isum.n323 Isum.t30 44.6904
R52 Isum.n449 Isum.t27 44.6904
R53 Isum.n255 Isum.t21 38.0344
R54 Isum.n270 Isum.t21 38.0344
R55 Isum.n398 Isum.t6 38.0344
R56 Isum.t6 Isum.n358 38.0344
R57 Isum.t30 Isum.n182 31.3785
R58 Isum.t27 Isum.n39 31.3785
R59 Isum.n333 Isum.n332 22.8209
R60 Isum.n323 Isum.t24 22.8209
R61 Isum.n449 Isum.t3 22.8209
R62 Isum.n441 Isum.n139 22.8209
R63 Isum.t48 Isum.n220 19.9683
R64 Isum.n378 Isum.t0 19.9683
R65 Isum.n572 Isum.t49 18.979
R66 Isum.n572 Isum.t1 17.6074
R67 Isum.n431 Isum.n430 15.784
R68 Isum.n166 Isum.n156 15.5561
R69 Isum.n339 Isum.n166 15.5561
R70 Isum.n339 Isum.n167 15.5561
R71 Isum.n335 Isum.n167 15.5561
R72 Isum.n335 Isum.n175 15.5561
R73 Isum.n183 Isum.n175 15.5561
R74 Isum.n328 Isum.n183 15.5561
R75 Isum.n328 Isum.n184 15.5561
R76 Isum.n324 Isum.n184 15.5561
R77 Isum.n324 Isum.n192 15.5561
R78 Isum.n259 Isum.n192 15.5561
R79 Isum.n259 Isum.n232 15.5561
R80 Isum.n271 Isum.n232 15.5561
R81 Isum.n271 Isum.n228 15.5561
R82 Isum.n277 Isum.n228 15.5561
R83 Isum.n277 Isum.n218 15.5561
R84 Isum.n291 Isum.n218 15.5561
R85 Isum.n291 Isum.n214 15.5561
R86 Isum.n298 Isum.n214 15.5561
R87 Isum.n298 Isum.n10 15.5561
R88 Isum.n604 Isum.n10 15.5561
R89 Isum.n604 Isum.n11 15.5561
R90 Isum.n600 Isum.n11 15.5561
R91 Isum.n600 Isum.n17 15.5561
R92 Isum.n379 Isum.n17 15.5561
R93 Isum.n385 Isum.n379 15.5561
R94 Isum.n385 Isum.n363 15.5561
R95 Isum.n399 Isum.n363 15.5561
R96 Isum.n399 Isum.n359 15.5561
R97 Isum.n406 Isum.n359 15.5561
R98 Isum.n406 Isum.n130 15.5561
R99 Isum.n448 Isum.n130 15.5561
R100 Isum.n448 Isum.n131 15.5561
R101 Isum.n131 Isum.n40 15.5561
R102 Isum.n443 Isum.n40 15.5561
R103 Isum.n443 Isum.n442 15.5561
R104 Isum.n442 Isum.n138 15.5561
R105 Isum.n438 Isum.n138 15.5561
R106 Isum.n438 Isum.n144 15.5561
R107 Isum.n434 Isum.n144 15.5561
R108 Isum.n434 Isum.n152 15.5561
R109 Isum.n160 Isum.n157 15.5561
R110 Isum.n341 Isum.n160 15.5561
R111 Isum.n341 Isum.n163 15.5561
R112 Isum.n176 Isum.n163 15.5561
R113 Isum.n177 Isum.n176 15.5561
R114 Isum.n244 Isum.n177 15.5561
R115 Isum.n244 Isum.n181 15.5561
R116 Isum.n236 Isum.n181 15.5561
R117 Isum.n236 Isum.n194 15.5561
R118 Isum.n252 Isum.n194 15.5561
R119 Isum.n261 Isum.n252 15.5561
R120 Isum.n261 Isum.n233 15.5561
R121 Isum.n269 Isum.n233 15.5561
R122 Isum.n269 Isum.n225 15.5561
R123 Isum.n279 Isum.n225 15.5561
R124 Isum.n280 Isum.n279 15.5561
R125 Isum.n280 Isum.n221 15.5561
R126 Isum.n288 Isum.n221 15.5561
R127 Isum.n288 Isum.n213 15.5561
R128 Isum.n213 Isum.n4 15.5561
R129 Isum.n606 Isum.n4 15.5561
R130 Isum.n606 Isum.n5 15.5561
R131 Isum.n19 Isum.n5 15.5561
R132 Isum.n375 Isum.n19 15.5561
R133 Isum.n376 Isum.n375 15.5561
R134 Isum.n387 Isum.n376 15.5561
R135 Isum.n387 Isum.n366 15.5561
R136 Isum.n396 Isum.n366 15.5561
R137 Isum.n396 Isum.n367 15.5561
R138 Isum.n367 Isum.n357 15.5561
R139 Isum.n409 Isum.n357 15.5561
R140 Isum.n409 Isum.n128 15.5561
R141 Isum.n412 Isum.n128 15.5561
R142 Isum.n412 Isum.n42 15.5561
R143 Isum.n417 Isum.n42 15.5561
R144 Isum.n417 Isum.n140 15.5561
R145 Isum.n141 Isum.n140 15.5561
R146 Isum.n142 Isum.n141 15.5561
R147 Isum.n424 Isum.n142 15.5561
R148 Isum.n424 Isum.n153 15.5561
R149 Isum.n154 Isum.n153 15.5561
R150 Isum.n70 Isum.n69 15.5561
R151 Isum.n193 Isum.n70 15.5561
R152 Isum.n193 Isum.n75 15.5561
R153 Isum.n76 Isum.n75 15.5561
R154 Isum.n254 Isum.n76 15.5561
R155 Isum.n254 Isum.n83 15.5561
R156 Isum.n84 Isum.n83 15.5561
R157 Isum.n85 Isum.n84 15.5561
R158 Isum.n219 Isum.n85 15.5561
R159 Isum.n219 Isum.n94 15.5561
R160 Isum.n95 Isum.n94 15.5561
R161 Isum.n212 Isum.n95 15.5561
R162 Isum.n212 Isum.n102 15.5561
R163 Isum.n102 Isum.n7 15.5561
R164 Isum.n103 Isum.n7 15.5561
R165 Isum.n103 Isum.n18 15.5561
R166 Isum.n110 Isum.n18 15.5561
R167 Isum.n377 Isum.n110 15.5561
R168 Isum.n377 Isum.n117 15.5561
R169 Isum.n118 Isum.n117 15.5561
R170 Isum.n365 Isum.n118 15.5561
R171 Isum.n365 Isum.n125 15.5561
R172 Isum.n126 Isum.n125 15.5561
R173 Isum.n127 Isum.n126 15.5561
R174 Isum.n450 Isum.n127 15.5561
R175 Isum.n450 Isum.n43 15.5561
R176 Isum.n577 Isum.n43 15.5561
R177 Isum.n330 Isum.n179 15.5561
R178 Isum.n322 Isum.n179 15.5561
R179 Isum.n322 Isum.n195 15.5561
R180 Isum.n201 Isum.n195 15.5561
R181 Isum.n202 Isum.n201 15.5561
R182 Isum.n203 Isum.n202 15.5561
R183 Isum.n226 Isum.n203 15.5561
R184 Isum.n226 Isum.n206 15.5561
R185 Isum.n207 Isum.n206 15.5561
R186 Isum.n208 Isum.n207 15.5561
R187 Isum.n211 Isum.n208 15.5561
R188 Isum.n300 Isum.n211 15.5561
R189 Isum.n301 Isum.n300 15.5561
R190 Isum.n301 Isum.n9 15.5561
R191 Isum.n21 Isum.n9 15.5561
R192 Isum.n598 Isum.n21 15.5561
R193 Isum.n598 Isum.n22 15.5561
R194 Isum.n27 Isum.n22 15.5561
R195 Isum.n28 Isum.n27 15.5561
R196 Isum.n29 Isum.n28 15.5561
R197 Isum.n397 Isum.n29 15.5561
R198 Isum.n397 Isum.n32 15.5561
R199 Isum.n33 Isum.n32 15.5561
R200 Isum.n34 Isum.n33 15.5561
R201 Isum.n129 Isum.n34 15.5561
R202 Isum.n129 Isum.n37 15.5561
R203 Isum.n579 Isum.n37 15.5561
R204 Isum.n567 Isum.t26 14.9553
R205 Isum.n512 Isum.t29 14.9553
R206 Isum.n502 Isum.n72 14.1851
R207 Isum.n465 Isum.n462 14.1851
R208 Isum.n562 Isum.n561 12.5005
R209 Isum.n51 Isum.n50 12.5005
R210 Isum.n554 Isum.n53 12.5005
R211 Isum.n556 Isum.n555 12.5005
R212 Isum.n552 Isum.n52 12.5005
R213 Isum.n550 Isum.n549 12.5005
R214 Isum.n548 Isum.n54 12.5005
R215 Isum.n539 Isum.n55 12.5005
R216 Isum.n541 Isum.n57 12.5005
R217 Isum.n543 Isum.n542 12.5005
R218 Isum.n538 Isum.n56 12.5005
R219 Isum.n537 Isum.n536 12.5005
R220 Isum.n535 Isum.n534 12.5005
R221 Isum.n533 Isum.n532 12.5005
R222 Isum.n531 Isum.n60 12.5005
R223 Isum.n530 Isum.n529 12.5005
R224 Isum.n527 Isum.n526 12.5005
R225 Isum.n525 Isum.n62 12.5005
R226 Isum.n524 Isum.n523 12.5005
R227 Isum.n521 Isum.n63 12.5005
R228 Isum.n466 Isum.n461 12.5005
R229 Isum.n460 Isum.n124 12.5005
R230 Isum.n470 Isum.n123 12.5005
R231 Isum.n471 Isum.n121 12.5005
R232 Isum.n472 Isum.n120 12.5005
R233 Isum.n475 Isum.n115 12.5005
R234 Isum.n476 Isum.n113 12.5005
R235 Isum.n477 Isum.n112 12.5005
R236 Isum.n480 Isum.n108 12.5005
R237 Isum.n481 Isum.n106 12.5005
R238 Isum.n482 Isum.n105 12.5005
R239 Isum.n485 Isum.n100 12.5005
R240 Isum.n486 Isum.n99 12.5005
R241 Isum.n487 Isum.n97 12.5005
R242 Isum.n490 Isum.n92 12.5005
R243 Isum.n491 Isum.n91 12.5005
R244 Isum.n492 Isum.n89 12.5005
R245 Isum.n88 Isum.n82 12.5005
R246 Isum.n496 Isum.n81 12.5005
R247 Isum.n497 Isum.n79 12.5005
R248 Isum.n498 Isum.n78 12.5005
R249 Isum.n501 Isum.n73 12.5005
R250 Isum.t4 Isum.n45 12.1268
R251 Isum.t25 Isum.n68 12.1268
R252 Isum.n574 Isum.n573 10.2173
R253 Isum.n521 Isum.n520 9.95036
R254 Isum.n563 Isum.n562 9.95036
R255 Isum.n105 Isum.n100 9.86111
R256 Isum.n542 Isum.n538 9.86111
R257 Isum.n518 Isum.t47 9.8285
R258 Isum.n565 Isum.t33 9.8285
R259 Isum.n97 Isum.n92 9.55788
R260 Isum.n112 Isum.n108 9.55788
R261 Isum.n534 Isum.n533 9.55788
R262 Isum.n539 Isum.n54 9.55788
R263 Isum.n459 Isum.n458 8.63568
R264 Isum.n456 Isum.n109 8.63568
R265 Isum.n454 Isum.n93 8.63568
R266 Isum.n452 Isum.n74 8.63568
R267 Isum.n560 Isum.n559 8.63568
R268 Isum.n547 Isum.n546 8.63568
R269 Isum.n514 Isum.n59 8.63568
R270 Isum.n517 Isum.n516 8.63568
R271 Isum.n457 Isum.n116 8.59884
R272 Isum.n455 Isum.n101 8.59884
R273 Isum.n453 Isum.n87 8.59884
R274 Isum.n558 Isum.n557 8.59884
R275 Isum.n545 Isum.n544 8.59884
R276 Isum.n515 Isum.n61 8.59884
R277 Isum.n78 Isum.n73 8.34496
R278 Isum.n89 Isum.n88 8.34496
R279 Isum.n120 Isum.n115 8.34496
R280 Isum.n461 Isum.n460 8.34496
R281 Isum.n529 Isum.n527 8.34496
R282 Isum.n555 Isum.n552 8.34496
R283 Isum.n299 Isum.t15 7.60729
R284 Isum.t12 Isum.n8 7.60729
R285 Isum.n346 Isum.n158 7.39502
R286 Isum.n346 Isum.n345 7.39502
R287 Isum.n429 Isum.n349 7.30695
R288 Isum.n429 Isum.n428 7.30695
R289 Isum.n79 Isum.n78 7.13204
R290 Isum.n88 Isum.n81 7.13204
R291 Isum.n121 Isum.n120 7.13204
R292 Isum.n460 Isum.n123 7.13204
R293 Isum.n523 Isum.n521 7.13204
R294 Isum.n527 Isum.n62 7.13204
R295 Isum.n555 Isum.n554 7.13204
R296 Isum.n562 Isum.n50 7.13204
R297 Isum.n46 Isum.n36 6.32942
R298 Isum.n198 Isum.n67 6.32942
R299 Isum.n571 Isum.n46 6.30962
R300 Isum.n508 Isum.n67 6.30962
R301 Isum.n92 Isum.n91 5.91912
R302 Isum.n113 Isum.n112 5.91912
R303 Isum.n533 Isum.n60 5.91912
R304 Isum.n550 Isum.n54 5.91912
R305 Isum.n564 Isum.n563 5.8218
R306 Isum.n520 Isum.n519 5.8218
R307 Isum.n100 Isum.n99 5.61588
R308 Isum.n106 Isum.n105 5.61588
R309 Isum.n538 Isum.n537 5.61588
R310 Isum.n542 Isum.n541 5.61588
R311 Isum.n427 Isum.n154 5.2005
R312 Isum.n432 Isum.n154 5.2005
R313 Isum.n426 Isum.n153 5.2005
R314 Isum.n433 Isum.n153 5.2005
R315 Isum.n425 Isum.n424 5.2005
R316 Isum.n424 Isum.n143 5.2005
R317 Isum.n351 Isum.n142 5.2005
R318 Isum.n439 Isum.n142 5.2005
R319 Isum.n420 Isum.n141 5.2005
R320 Isum.n440 Isum.n141 5.2005
R321 Isum.n419 Isum.n140 5.2005
R322 Isum.n441 Isum.n140 5.2005
R323 Isum.n418 Isum.n417 5.2005
R324 Isum.n417 Isum.n41 5.2005
R325 Isum.n353 Isum.n42 5.2005
R326 Isum.n578 Isum.n42 5.2005
R327 Isum.n413 Isum.n412 5.2005
R328 Isum.n412 Isum.n39 5.2005
R329 Isum.n411 Isum.n128 5.2005
R330 Isum.n449 Isum.n128 5.2005
R331 Isum.n410 Isum.n409 5.2005
R332 Isum.n409 Isum.n408 5.2005
R333 Isum.n357 Isum.n355 5.2005
R334 Isum.n407 Isum.n357 5.2005
R335 Isum.n394 Isum.n367 5.2005
R336 Isum.n367 Isum.n358 5.2005
R337 Isum.n396 Isum.n395 5.2005
R338 Isum.n398 Isum.n396 5.2005
R339 Isum.n368 Isum.n366 5.2005
R340 Isum.n366 Isum.n364 5.2005
R341 Isum.n388 Isum.n387 5.2005
R342 Isum.n387 Isum.n386 5.2005
R343 Isum.n376 Isum.n370 5.2005
R344 Isum.n378 Isum.n376 5.2005
R345 Isum.n375 Isum.n374 5.2005
R346 Isum.n375 Isum.n20 5.2005
R347 Isum.n371 Isum.n19 5.2005
R348 Isum.n599 Isum.n19 5.2005
R349 Isum.n5 Isum.n3 5.2005
R350 Isum.n8 Isum.n5 5.2005
R351 Isum.n607 Isum.n606 5.2005
R352 Isum.n606 Isum.n605 5.2005
R353 Isum.n4 Isum.n2 5.2005
R354 Isum.n6 Isum.n4 5.2005
R355 Isum.n286 Isum.n213 5.2005
R356 Isum.n299 Isum.n213 5.2005
R357 Isum.n288 Isum.n287 5.2005
R358 Isum.n289 Isum.n288 5.2005
R359 Isum.n222 Isum.n221 5.2005
R360 Isum.n290 Isum.n221 5.2005
R361 Isum.n281 Isum.n280 5.2005
R362 Isum.n280 Isum.n220 5.2005
R363 Isum.n279 Isum.n224 5.2005
R364 Isum.n279 Isum.n278 5.2005
R365 Isum.n267 Isum.n225 5.2005
R366 Isum.n227 Isum.n225 5.2005
R367 Isum.n269 Isum.n268 5.2005
R368 Isum.n270 Isum.n269 5.2005
R369 Isum.n234 Isum.n233 5.2005
R370 Isum.n255 Isum.n233 5.2005
R371 Isum.n262 Isum.n261 5.2005
R372 Isum.n261 Isum.n260 5.2005
R373 Isum.n252 Isum.n251 5.2005
R374 Isum.n253 Isum.n252 5.2005
R375 Isum.n250 Isum.n194 5.2005
R376 Isum.n323 Isum.n194 5.2005
R377 Isum.n237 Isum.n236 5.2005
R378 Isum.n236 Isum.n182 5.2005
R379 Isum.n246 Isum.n181 5.2005
R380 Isum.n329 Isum.n181 5.2005
R381 Isum.n245 Isum.n244 5.2005
R382 Isum.n244 Isum.n178 5.2005
R383 Isum.n243 Isum.n177 5.2005
R384 Isum.n333 Isum.n177 5.2005
R385 Isum.n239 Isum.n176 5.2005
R386 Isum.n334 Isum.n176 5.2005
R387 Isum.n163 Isum.n162 5.2005
R388 Isum.n165 Isum.n163 5.2005
R389 Isum.n342 Isum.n341 5.2005
R390 Isum.n341 Isum.n340 5.2005
R391 Isum.n343 Isum.n160 5.2005
R392 Isum.n164 Isum.n160 5.2005
R393 Isum.n344 Isum.n157 5.2005
R394 Isum.n157 Isum.n155 5.2005
R395 Isum.n168 Isum.n156 5.2005
R396 Isum.n156 Isum.n155 5.2005
R397 Isum.n169 Isum.n166 5.2005
R398 Isum.n166 Isum.n164 5.2005
R399 Isum.n339 Isum.n338 5.2005
R400 Isum.n340 Isum.n339 5.2005
R401 Isum.n337 Isum.n167 5.2005
R402 Isum.n167 Isum.n165 5.2005
R403 Isum.n336 Isum.n335 5.2005
R404 Isum.n335 Isum.n334 5.2005
R405 Isum.n175 Isum.n174 5.2005
R406 Isum.n333 Isum.n175 5.2005
R407 Isum.n185 Isum.n183 5.2005
R408 Isum.n183 Isum.n178 5.2005
R409 Isum.n328 Isum.n327 5.2005
R410 Isum.n329 Isum.n328 5.2005
R411 Isum.n326 Isum.n184 5.2005
R412 Isum.n184 Isum.n182 5.2005
R413 Isum.n325 Isum.n324 5.2005
R414 Isum.n324 Isum.n323 5.2005
R415 Isum.n192 Isum.n191 5.2005
R416 Isum.n253 Isum.n192 5.2005
R417 Isum.n259 Isum.n258 5.2005
R418 Isum.n260 Isum.n259 5.2005
R419 Isum.n232 Isum.n231 5.2005
R420 Isum.n255 Isum.n232 5.2005
R421 Isum.n272 Isum.n271 5.2005
R422 Isum.n271 Isum.n270 5.2005
R423 Isum.n229 Isum.n228 5.2005
R424 Isum.n228 Isum.n227 5.2005
R425 Isum.n277 Isum.n276 5.2005
R426 Isum.n278 Isum.n277 5.2005
R427 Isum.n218 Isum.n217 5.2005
R428 Isum.n220 Isum.n218 5.2005
R429 Isum.n292 Isum.n291 5.2005
R430 Isum.n291 Isum.n290 5.2005
R431 Isum.n215 Isum.n214 5.2005
R432 Isum.n289 Isum.n214 5.2005
R433 Isum.n298 Isum.n297 5.2005
R434 Isum.n299 Isum.n298 5.2005
R435 Isum.n12 Isum.n10 5.2005
R436 Isum.n10 Isum.n6 5.2005
R437 Isum.n604 Isum.n603 5.2005
R438 Isum.n605 Isum.n604 5.2005
R439 Isum.n602 Isum.n11 5.2005
R440 Isum.n11 Isum.n8 5.2005
R441 Isum.n601 Isum.n600 5.2005
R442 Isum.n600 Isum.n599 5.2005
R443 Isum.n17 Isum.n16 5.2005
R444 Isum.n20 Isum.n17 5.2005
R445 Isum.n380 Isum.n379 5.2005
R446 Isum.n379 Isum.n378 5.2005
R447 Isum.n385 Isum.n384 5.2005
R448 Isum.n386 Isum.n385 5.2005
R449 Isum.n363 Isum.n362 5.2005
R450 Isum.n364 Isum.n363 5.2005
R451 Isum.n400 Isum.n399 5.2005
R452 Isum.n399 Isum.n398 5.2005
R453 Isum.n360 Isum.n359 5.2005
R454 Isum.n359 Isum.n358 5.2005
R455 Isum.n406 Isum.n405 5.2005
R456 Isum.n407 Isum.n406 5.2005
R457 Isum.n132 Isum.n130 5.2005
R458 Isum.n408 Isum.n130 5.2005
R459 Isum.n448 Isum.n447 5.2005
R460 Isum.n449 Isum.n448 5.2005
R461 Isum.n446 Isum.n131 5.2005
R462 Isum.n131 Isum.n39 5.2005
R463 Isum.n445 Isum.n40 5.2005
R464 Isum.n578 Isum.n40 5.2005
R465 Isum.n444 Isum.n443 5.2005
R466 Isum.n443 Isum.n41 5.2005
R467 Isum.n442 Isum.n137 5.2005
R468 Isum.n442 Isum.n441 5.2005
R469 Isum.n145 Isum.n138 5.2005
R470 Isum.n440 Isum.n138 5.2005
R471 Isum.n438 Isum.n437 5.2005
R472 Isum.n439 Isum.n438 5.2005
R473 Isum.n436 Isum.n144 5.2005
R474 Isum.n144 Isum.n143 5.2005
R475 Isum.n435 Isum.n434 5.2005
R476 Isum.n434 Isum.n433 5.2005
R477 Isum.n152 Isum.n151 5.2005
R478 Isum.n432 Isum.n152 5.2005
R479 Isum.n577 Isum.n576 5.2005
R480 Isum.n578 Isum.n577 5.2005
R481 Isum.n44 Isum.n43 5.2005
R482 Isum.n43 Isum.n39 5.2005
R483 Isum.n451 Isum.n450 5.2005
R484 Isum.n450 Isum.n449 5.2005
R485 Isum.n467 Isum.n127 5.2005
R486 Isum.n408 Isum.n127 5.2005
R487 Isum.n468 Isum.n126 5.2005
R488 Isum.n407 Isum.n126 5.2005
R489 Isum.n469 Isum.n125 5.2005
R490 Isum.n358 Isum.n125 5.2005
R491 Isum.n365 Isum.n119 5.2005
R492 Isum.n398 Isum.n365 5.2005
R493 Isum.n473 Isum.n118 5.2005
R494 Isum.n364 Isum.n118 5.2005
R495 Isum.n474 Isum.n117 5.2005
R496 Isum.n386 Isum.n117 5.2005
R497 Isum.n377 Isum.n111 5.2005
R498 Isum.n378 Isum.n377 5.2005
R499 Isum.n478 Isum.n110 5.2005
R500 Isum.n110 Isum.n20 5.2005
R501 Isum.n479 Isum.n18 5.2005
R502 Isum.n599 Isum.n18 5.2005
R503 Isum.n104 Isum.n103 5.2005
R504 Isum.n103 Isum.n8 5.2005
R505 Isum.n483 Isum.n7 5.2005
R506 Isum.n605 Isum.n7 5.2005
R507 Isum.n484 Isum.n102 5.2005
R508 Isum.n102 Isum.n6 5.2005
R509 Isum.n212 Isum.n96 5.2005
R510 Isum.n299 Isum.n212 5.2005
R511 Isum.n488 Isum.n95 5.2005
R512 Isum.n289 Isum.n95 5.2005
R513 Isum.n489 Isum.n94 5.2005
R514 Isum.n290 Isum.n94 5.2005
R515 Isum.n219 Isum.n86 5.2005
R516 Isum.n220 Isum.n219 5.2005
R517 Isum.n493 Isum.n85 5.2005
R518 Isum.n278 Isum.n85 5.2005
R519 Isum.n494 Isum.n84 5.2005
R520 Isum.n227 Isum.n84 5.2005
R521 Isum.n495 Isum.n83 5.2005
R522 Isum.n270 Isum.n83 5.2005
R523 Isum.n254 Isum.n77 5.2005
R524 Isum.n255 Isum.n254 5.2005
R525 Isum.n499 Isum.n76 5.2005
R526 Isum.n260 Isum.n76 5.2005
R527 Isum.n500 Isum.n75 5.2005
R528 Isum.n253 Isum.n75 5.2005
R529 Isum.n193 Isum.n71 5.2005
R530 Isum.n323 Isum.n193 5.2005
R531 Isum.n505 Isum.n70 5.2005
R532 Isum.n182 Isum.n70 5.2005
R533 Isum.n506 Isum.n69 5.2005
R534 Isum.n329 Isum.n69 5.2005
R535 Isum.n580 Isum.n579 5.2005
R536 Isum.n579 Isum.n578 5.2005
R537 Isum.n581 Isum.n37 5.2005
R538 Isum.n39 Isum.n37 5.2005
R539 Isum.n129 Isum.n35 5.2005
R540 Isum.n449 Isum.n129 5.2005
R541 Isum.n585 Isum.n34 5.2005
R542 Isum.n408 Isum.n34 5.2005
R543 Isum.n586 Isum.n33 5.2005
R544 Isum.n407 Isum.n33 5.2005
R545 Isum.n587 Isum.n32 5.2005
R546 Isum.n358 Isum.n32 5.2005
R547 Isum.n397 Isum.n30 5.2005
R548 Isum.n398 Isum.n397 5.2005
R549 Isum.n591 Isum.n29 5.2005
R550 Isum.n364 Isum.n29 5.2005
R551 Isum.n592 Isum.n28 5.2005
R552 Isum.n386 Isum.n28 5.2005
R553 Isum.n593 Isum.n27 5.2005
R554 Isum.n378 Isum.n27 5.2005
R555 Isum.n24 Isum.n22 5.2005
R556 Isum.n22 Isum.n20 5.2005
R557 Isum.n598 Isum.n597 5.2005
R558 Isum.n599 Isum.n598 5.2005
R559 Isum.n23 Isum.n21 5.2005
R560 Isum.n21 Isum.n8 5.2005
R561 Isum.n303 Isum.n9 5.2005
R562 Isum.n605 Isum.n9 5.2005
R563 Isum.n304 Isum.n301 5.2005
R564 Isum.n301 Isum.n6 5.2005
R565 Isum.n305 Isum.n300 5.2005
R566 Isum.n300 Isum.n299 5.2005
R567 Isum.n211 Isum.n209 5.2005
R568 Isum.n289 Isum.n211 5.2005
R569 Isum.n309 Isum.n208 5.2005
R570 Isum.n290 Isum.n208 5.2005
R571 Isum.n310 Isum.n207 5.2005
R572 Isum.n220 Isum.n207 5.2005
R573 Isum.n311 Isum.n206 5.2005
R574 Isum.n278 Isum.n206 5.2005
R575 Isum.n226 Isum.n204 5.2005
R576 Isum.n227 Isum.n226 5.2005
R577 Isum.n315 Isum.n203 5.2005
R578 Isum.n270 Isum.n203 5.2005
R579 Isum.n316 Isum.n202 5.2005
R580 Isum.n255 Isum.n202 5.2005
R581 Isum.n317 Isum.n201 5.2005
R582 Isum.n260 Isum.n201 5.2005
R583 Isum.n197 Isum.n195 5.2005
R584 Isum.n253 Isum.n195 5.2005
R585 Isum.n322 Isum.n321 5.2005
R586 Isum.n323 Isum.n322 5.2005
R587 Isum.n196 Isum.n179 5.2005
R588 Isum.n182 Isum.n179 5.2005
R589 Isum.n330 Isum.n180 5.2005
R590 Isum.n330 Isum.n329 5.2005
R591 Isum.n98 Isum.n97 5.05435
R592 Isum.n108 Isum.n107 5.05435
R593 Isum.n534 Isum.n58 5.05435
R594 Isum.n540 Isum.n539 5.05435
R595 Isum.n518 Isum.n513 4.69811
R596 Isum.n566 Isum.n565 4.69811
R597 Isum.n168 Isum.n158 4.5005
R598 Isum.n170 Isum.n169 4.5005
R599 Isum.n338 Isum.n171 4.5005
R600 Isum.n337 Isum.n172 4.5005
R601 Isum.n336 Isum.n173 4.5005
R602 Isum.n186 Isum.n174 4.5005
R603 Isum.n187 Isum.n185 4.5005
R604 Isum.n327 Isum.n188 4.5005
R605 Isum.n326 Isum.n189 4.5005
R606 Isum.n325 Isum.n190 4.5005
R607 Isum.n256 Isum.n191 4.5005
R608 Isum.n258 Isum.n257 4.5005
R609 Isum.n231 Isum.n230 4.5005
R610 Isum.n273 Isum.n272 4.5005
R611 Isum.n274 Isum.n229 4.5005
R612 Isum.n276 Isum.n275 4.5005
R613 Isum.n217 Isum.n216 4.5005
R614 Isum.n293 Isum.n292 4.5005
R615 Isum.n294 Isum.n215 4.5005
R616 Isum.n297 Isum.n296 4.5005
R617 Isum.n295 Isum.n12 4.5005
R618 Isum.n603 Isum.n13 4.5005
R619 Isum.n602 Isum.n14 4.5005
R620 Isum.n601 Isum.n15 4.5005
R621 Isum.n381 Isum.n16 4.5005
R622 Isum.n382 Isum.n380 4.5005
R623 Isum.n384 Isum.n383 4.5005
R624 Isum.n362 Isum.n361 4.5005
R625 Isum.n401 Isum.n400 4.5005
R626 Isum.n402 Isum.n360 4.5005
R627 Isum.n405 Isum.n404 4.5005
R628 Isum.n403 Isum.n132 4.5005
R629 Isum.n447 Isum.n133 4.5005
R630 Isum.n446 Isum.n134 4.5005
R631 Isum.n445 Isum.n135 4.5005
R632 Isum.n444 Isum.n136 4.5005
R633 Isum.n146 Isum.n137 4.5005
R634 Isum.n147 Isum.n145 4.5005
R635 Isum.n437 Isum.n148 4.5005
R636 Isum.n436 Isum.n149 4.5005
R637 Isum.n435 Isum.n150 4.5005
R638 Isum.n349 Isum.n151 4.5005
R639 Isum.n343 Isum.n159 4.5005
R640 Isum.n342 Isum.n161 4.5005
R641 Isum.n240 Isum.n162 4.5005
R642 Isum.n241 Isum.n239 4.5005
R643 Isum.n243 Isum.n242 4.5005
R644 Isum.n245 Isum.n238 4.5005
R645 Isum.n247 Isum.n246 4.5005
R646 Isum.n248 Isum.n237 4.5005
R647 Isum.n250 Isum.n249 4.5005
R648 Isum.n251 Isum.n235 4.5005
R649 Isum.n263 Isum.n262 4.5005
R650 Isum.n264 Isum.n234 4.5005
R651 Isum.n268 Isum.n265 4.5005
R652 Isum.n267 Isum.n266 4.5005
R653 Isum.n224 Isum.n223 4.5005
R654 Isum.n282 Isum.n281 4.5005
R655 Isum.n283 Isum.n222 4.5005
R656 Isum.n287 Isum.n284 4.5005
R657 Isum.n286 Isum.n285 4.5005
R658 Isum.n2 Isum.n0 4.5005
R659 Isum.n608 Isum.n607 4.5005
R660 Isum.n3 Isum.n1 4.5005
R661 Isum.n372 Isum.n371 4.5005
R662 Isum.n374 Isum.n373 4.5005
R663 Isum.n370 Isum.n369 4.5005
R664 Isum.n389 Isum.n388 4.5005
R665 Isum.n390 Isum.n368 4.5005
R666 Isum.n395 Isum.n391 4.5005
R667 Isum.n394 Isum.n393 4.5005
R668 Isum.n392 Isum.n355 4.5005
R669 Isum.n410 Isum.n356 4.5005
R670 Isum.n411 Isum.n354 4.5005
R671 Isum.n414 Isum.n413 4.5005
R672 Isum.n415 Isum.n353 4.5005
R673 Isum.n418 Isum.n416 4.5005
R674 Isum.n419 Isum.n352 4.5005
R675 Isum.n421 Isum.n420 4.5005
R676 Isum.n422 Isum.n351 4.5005
R677 Isum.n425 Isum.n423 4.5005
R678 Isum.n426 Isum.n350 4.5005
R679 Isum.n428 Isum.n427 4.5005
R680 Isum.n345 Isum.n344 4.5005
R681 Isum.n199 Isum.n196 4.5005
R682 Isum.n321 Isum.n320 4.5005
R683 Isum.n319 Isum.n197 4.5005
R684 Isum.n318 Isum.n317 4.5005
R685 Isum.n316 Isum.n200 4.5005
R686 Isum.n315 Isum.n314 4.5005
R687 Isum.n313 Isum.n204 4.5005
R688 Isum.n312 Isum.n311 4.5005
R689 Isum.n310 Isum.n205 4.5005
R690 Isum.n309 Isum.n308 4.5005
R691 Isum.n307 Isum.n209 4.5005
R692 Isum.n306 Isum.n305 4.5005
R693 Isum.n304 Isum.n210 4.5005
R694 Isum.n303 Isum.n302 4.5005
R695 Isum.n25 Isum.n23 4.5005
R696 Isum.n597 Isum.n596 4.5005
R697 Isum.n595 Isum.n24 4.5005
R698 Isum.n594 Isum.n593 4.5005
R699 Isum.n592 Isum.n26 4.5005
R700 Isum.n591 Isum.n590 4.5005
R701 Isum.n589 Isum.n30 4.5005
R702 Isum.n588 Isum.n587 4.5005
R703 Isum.n586 Isum.n31 4.5005
R704 Isum.n585 Isum.n584 4.5005
R705 Isum.n583 Isum.n35 4.5005
R706 Isum.n582 Isum.n581 4.5005
R707 Isum.n580 Isum.n36 4.5005
R708 Isum.n198 Isum.n180 4.5005
R709 Isum.n565 Isum.n564 4.5005
R710 Isum.n519 Isum.n518 4.5005
R711 Isum.n505 Isum.n504 4.5005
R712 Isum.n502 Isum.n71 4.5005
R713 Isum.n501 Isum.n500 4.5005
R714 Isum.n499 Isum.n498 4.5005
R715 Isum.n497 Isum.n77 4.5005
R716 Isum.n496 Isum.n495 4.5005
R717 Isum.n494 Isum.n82 4.5005
R718 Isum.n493 Isum.n492 4.5005
R719 Isum.n491 Isum.n86 4.5005
R720 Isum.n490 Isum.n489 4.5005
R721 Isum.n488 Isum.n487 4.5005
R722 Isum.n486 Isum.n96 4.5005
R723 Isum.n485 Isum.n484 4.5005
R724 Isum.n483 Isum.n482 4.5005
R725 Isum.n481 Isum.n104 4.5005
R726 Isum.n480 Isum.n479 4.5005
R727 Isum.n478 Isum.n477 4.5005
R728 Isum.n476 Isum.n111 4.5005
R729 Isum.n475 Isum.n474 4.5005
R730 Isum.n473 Isum.n472 4.5005
R731 Isum.n471 Isum.n119 4.5005
R732 Isum.n470 Isum.n469 4.5005
R733 Isum.n468 Isum.n124 4.5005
R734 Isum.n467 Isum.n466 4.5005
R735 Isum.n465 Isum.n451 4.5005
R736 Isum.n463 Isum.n44 4.5005
R737 Isum.n576 Isum.n575 4.5005
R738 Isum.n507 Isum.n506 4.5005
R739 Isum.n73 Isum.n72 3.93127
R740 Isum.n90 Isum.n89 3.93127
R741 Isum.n115 Isum.n114 3.93127
R742 Isum.n462 Isum.n461 3.93127
R743 Isum.n529 Isum.n528 3.93127
R744 Isum.n552 Isum.n551 3.93127
R745 Isum.n458 Isum.t7 3.5285
R746 Isum.n458 Isum.t4 3.5285
R747 Isum.n457 Isum.t10 3.5285
R748 Isum.t7 Isum.n457 3.5285
R749 Isum.n456 Isum.t13 3.5285
R750 Isum.t10 Isum.n456 3.5285
R751 Isum.n455 Isum.t16 3.5285
R752 Isum.t13 Isum.n455 3.5285
R753 Isum.n454 Isum.t19 3.5285
R754 Isum.t16 Isum.n454 3.5285
R755 Isum.n453 Isum.t22 3.5285
R756 Isum.t19 Isum.n453 3.5285
R757 Isum.n452 Isum.t25 3.5285
R758 Isum.t22 Isum.n452 3.5285
R759 Isum.n559 Isum.t35 3.5285
R760 Isum.n559 Isum.t33 3.5285
R761 Isum.n558 Isum.t37 3.5285
R762 Isum.t35 Isum.n558 3.5285
R763 Isum.n546 Isum.t39 3.5285
R764 Isum.n546 Isum.t37 3.5285
R765 Isum.n545 Isum.t41 3.5285
R766 Isum.t39 Isum.n545 3.5285
R767 Isum.t43 Isum.n514 3.5285
R768 Isum.n514 Isum.t41 3.5285
R769 Isum.t45 Isum.n515 3.5285
R770 Isum.n515 Isum.t43 3.5285
R771 Isum.t47 Isum.n517 3.5285
R772 Isum.n517 Isum.t45 3.5285
R773 Isum.t18 Isum.t48 2.85305
R774 Isum.t0 Isum.t9 2.85305
R775 Isum.n80 Isum.n79 2.80819
R776 Isum.n81 Isum.n80 2.80819
R777 Isum.n122 Isum.n121 2.80819
R778 Isum.n123 Isum.n122 2.80819
R779 Isum.n523 Isum.n522 2.80819
R780 Isum.n522 Isum.n62 2.80819
R781 Isum.n554 Isum.n553 2.80819
R782 Isum.n553 Isum.n50 2.80819
R783 Isum.n520 Isum.t46 2.73469
R784 Isum.n563 Isum.t32 2.73469
R785 Isum.n511 Isum.n510 2.35281
R786 Isum.n569 Isum.n568 2.35281
R787 Isum.n570 Isum.t28 2.27503
R788 Isum.t31 Isum.n509 2.26755
R789 Isum.n573 Isum 1.7105
R790 Isum.n91 Isum.n90 1.68512
R791 Isum.n114 Isum.n113 1.68512
R792 Isum.n528 Isum.n60 1.68512
R793 Isum.n551 Isum.n550 1.68512
R794 Isum.n569 Isum.n48 1.66246
R795 Isum.n510 Isum.n66 1.65213
R796 Isum.n510 Isum.t31 1.3415
R797 Isum.t28 Isum.n569 1.3415
R798 Isum.n72 Isum.t23 0.913
R799 Isum.n80 Isum.t20 0.913
R800 Isum.n90 Isum.t17 0.913
R801 Isum.n98 Isum.t14 0.913
R802 Isum.n107 Isum.t11 0.913
R803 Isum.n114 Isum.t8 0.913
R804 Isum.n122 Isum.t5 0.913
R805 Isum.n462 Isum.t2 0.913
R806 Isum.n522 Isum.t44 0.913
R807 Isum.n528 Isum.t42 0.913
R808 Isum.n58 Isum.t40 0.913
R809 Isum.n540 Isum.t38 0.913
R810 Isum.n551 Isum.t36 0.913
R811 Isum.n553 Isum.t34 0.913
R812 Isum.n573 Isum.n572 0.7511
R813 Isum.n99 Isum.n98 0.562038
R814 Isum.n107 Isum.n106 0.562038
R815 Isum.n537 Isum.n58 0.562038
R816 Isum.n541 Isum.n540 0.562038
R817 Isum.n571 Isum.n570 0.462063
R818 Isum.n509 Isum.n508 0.437113
R819 Isum.n46 Isum.n38 0.168242
R820 Isum.n139 Isum.n38 0.168242
R821 Isum.n331 Isum.n67 0.168242
R822 Isum.n332 Isum.n331 0.168242
R823 Isum.n196 Isum.n180 0.1445
R824 Isum.n321 Isum.n196 0.1445
R825 Isum.n321 Isum.n197 0.1445
R826 Isum.n317 Isum.n197 0.1445
R827 Isum.n317 Isum.n316 0.1445
R828 Isum.n316 Isum.n315 0.1445
R829 Isum.n315 Isum.n204 0.1445
R830 Isum.n311 Isum.n204 0.1445
R831 Isum.n311 Isum.n310 0.1445
R832 Isum.n310 Isum.n309 0.1445
R833 Isum.n309 Isum.n209 0.1445
R834 Isum.n305 Isum.n209 0.1445
R835 Isum.n305 Isum.n304 0.1445
R836 Isum.n304 Isum.n303 0.1445
R837 Isum.n303 Isum.n23 0.1445
R838 Isum.n597 Isum.n23 0.1445
R839 Isum.n597 Isum.n24 0.1445
R840 Isum.n593 Isum.n24 0.1445
R841 Isum.n593 Isum.n592 0.1445
R842 Isum.n592 Isum.n591 0.1445
R843 Isum.n591 Isum.n30 0.1445
R844 Isum.n587 Isum.n30 0.1445
R845 Isum.n587 Isum.n586 0.1445
R846 Isum.n586 Isum.n585 0.1445
R847 Isum.n585 Isum.n35 0.1445
R848 Isum.n581 Isum.n35 0.1445
R849 Isum.n581 Isum.n580 0.1445
R850 Isum.n344 Isum.n343 0.1445
R851 Isum.n343 Isum.n342 0.1445
R852 Isum.n342 Isum.n162 0.1445
R853 Isum.n239 Isum.n162 0.1445
R854 Isum.n243 Isum.n239 0.1445
R855 Isum.n245 Isum.n243 0.1445
R856 Isum.n246 Isum.n245 0.1445
R857 Isum.n246 Isum.n237 0.1445
R858 Isum.n250 Isum.n237 0.1445
R859 Isum.n251 Isum.n250 0.1445
R860 Isum.n262 Isum.n251 0.1445
R861 Isum.n262 Isum.n234 0.1445
R862 Isum.n268 Isum.n234 0.1445
R863 Isum.n268 Isum.n267 0.1445
R864 Isum.n267 Isum.n224 0.1445
R865 Isum.n281 Isum.n224 0.1445
R866 Isum.n281 Isum.n222 0.1445
R867 Isum.n287 Isum.n222 0.1445
R868 Isum.n287 Isum.n286 0.1445
R869 Isum.n286 Isum.n2 0.1445
R870 Isum.n607 Isum.n2 0.1445
R871 Isum.n607 Isum.n3 0.1445
R872 Isum.n371 Isum.n3 0.1445
R873 Isum.n374 Isum.n371 0.1445
R874 Isum.n374 Isum.n370 0.1445
R875 Isum.n388 Isum.n370 0.1445
R876 Isum.n388 Isum.n368 0.1445
R877 Isum.n395 Isum.n368 0.1445
R878 Isum.n395 Isum.n394 0.1445
R879 Isum.n394 Isum.n355 0.1445
R880 Isum.n410 Isum.n355 0.1445
R881 Isum.n411 Isum.n410 0.1445
R882 Isum.n413 Isum.n411 0.1445
R883 Isum.n413 Isum.n353 0.1445
R884 Isum.n418 Isum.n353 0.1445
R885 Isum.n419 Isum.n418 0.1445
R886 Isum.n420 Isum.n419 0.1445
R887 Isum.n420 Isum.n351 0.1445
R888 Isum.n425 Isum.n351 0.1445
R889 Isum.n426 Isum.n425 0.1445
R890 Isum.n427 Isum.n426 0.1445
R891 Isum.n169 Isum.n168 0.1445
R892 Isum.n338 Isum.n169 0.1445
R893 Isum.n338 Isum.n337 0.1445
R894 Isum.n337 Isum.n336 0.1445
R895 Isum.n336 Isum.n174 0.1445
R896 Isum.n185 Isum.n174 0.1445
R897 Isum.n327 Isum.n185 0.1445
R898 Isum.n327 Isum.n326 0.1445
R899 Isum.n326 Isum.n325 0.1445
R900 Isum.n325 Isum.n191 0.1445
R901 Isum.n258 Isum.n191 0.1445
R902 Isum.n258 Isum.n231 0.1445
R903 Isum.n272 Isum.n231 0.1445
R904 Isum.n272 Isum.n229 0.1445
R905 Isum.n276 Isum.n229 0.1445
R906 Isum.n276 Isum.n217 0.1445
R907 Isum.n292 Isum.n217 0.1445
R908 Isum.n292 Isum.n215 0.1445
R909 Isum.n297 Isum.n215 0.1445
R910 Isum.n297 Isum.n12 0.1445
R911 Isum.n603 Isum.n12 0.1445
R912 Isum.n603 Isum.n602 0.1445
R913 Isum.n602 Isum.n601 0.1445
R914 Isum.n601 Isum.n16 0.1445
R915 Isum.n380 Isum.n16 0.1445
R916 Isum.n384 Isum.n380 0.1445
R917 Isum.n384 Isum.n362 0.1445
R918 Isum.n400 Isum.n362 0.1445
R919 Isum.n400 Isum.n360 0.1445
R920 Isum.n405 Isum.n360 0.1445
R921 Isum.n405 Isum.n132 0.1445
R922 Isum.n447 Isum.n132 0.1445
R923 Isum.n447 Isum.n446 0.1445
R924 Isum.n446 Isum.n445 0.1445
R925 Isum.n445 Isum.n444 0.1445
R926 Isum.n444 Isum.n137 0.1445
R927 Isum.n145 Isum.n137 0.1445
R928 Isum.n437 Isum.n145 0.1445
R929 Isum.n437 Isum.n436 0.1445
R930 Isum.n436 Isum.n435 0.1445
R931 Isum.n435 Isum.n151 0.1445
R932 Isum.n170 Isum.n158 0.1445
R933 Isum.n171 Isum.n170 0.1445
R934 Isum.n172 Isum.n171 0.1445
R935 Isum.n173 Isum.n172 0.1445
R936 Isum.n186 Isum.n173 0.1445
R937 Isum.n187 Isum.n186 0.1445
R938 Isum.n188 Isum.n187 0.1445
R939 Isum.n189 Isum.n188 0.1445
R940 Isum.n190 Isum.n189 0.1445
R941 Isum.n256 Isum.n190 0.1445
R942 Isum.n257 Isum.n256 0.1445
R943 Isum.n257 Isum.n230 0.1445
R944 Isum.n273 Isum.n230 0.1445
R945 Isum.n274 Isum.n273 0.1445
R946 Isum.n275 Isum.n274 0.1445
R947 Isum.n275 Isum.n216 0.1445
R948 Isum.n293 Isum.n216 0.1445
R949 Isum.n294 Isum.n293 0.1445
R950 Isum.n296 Isum.n294 0.1445
R951 Isum.n296 Isum.n295 0.1445
R952 Isum.n295 Isum.n13 0.1445
R953 Isum.n14 Isum.n13 0.1445
R954 Isum.n15 Isum.n14 0.1445
R955 Isum.n381 Isum.n15 0.1445
R956 Isum.n382 Isum.n381 0.1445
R957 Isum.n383 Isum.n382 0.1445
R958 Isum.n383 Isum.n361 0.1445
R959 Isum.n401 Isum.n361 0.1445
R960 Isum.n402 Isum.n401 0.1445
R961 Isum.n404 Isum.n402 0.1445
R962 Isum.n404 Isum.n403 0.1445
R963 Isum.n403 Isum.n133 0.1445
R964 Isum.n134 Isum.n133 0.1445
R965 Isum.n135 Isum.n134 0.1445
R966 Isum.n136 Isum.n135 0.1445
R967 Isum.n146 Isum.n136 0.1445
R968 Isum.n147 Isum.n146 0.1445
R969 Isum.n148 Isum.n147 0.1445
R970 Isum.n149 Isum.n148 0.1445
R971 Isum.n150 Isum.n149 0.1445
R972 Isum.n349 Isum.n150 0.1445
R973 Isum.n345 Isum.n159 0.1445
R974 Isum.n161 Isum.n159 0.1445
R975 Isum.n240 Isum.n161 0.1445
R976 Isum.n241 Isum.n240 0.1445
R977 Isum.n242 Isum.n241 0.1445
R978 Isum.n242 Isum.n238 0.1445
R979 Isum.n247 Isum.n238 0.1445
R980 Isum.n248 Isum.n247 0.1445
R981 Isum.n249 Isum.n248 0.1445
R982 Isum.n249 Isum.n235 0.1445
R983 Isum.n263 Isum.n235 0.1445
R984 Isum.n264 Isum.n263 0.1445
R985 Isum.n265 Isum.n264 0.1445
R986 Isum.n266 Isum.n265 0.1445
R987 Isum.n266 Isum.n223 0.1445
R988 Isum.n282 Isum.n223 0.1445
R989 Isum.n283 Isum.n282 0.1445
R990 Isum.n284 Isum.n283 0.1445
R991 Isum.n285 Isum.n284 0.1445
R992 Isum.n285 Isum.n0 0.1445
R993 Isum.n608 Isum.n1 0.1445
R994 Isum.n372 Isum.n1 0.1445
R995 Isum.n373 Isum.n372 0.1445
R996 Isum.n373 Isum.n369 0.1445
R997 Isum.n389 Isum.n369 0.1445
R998 Isum.n390 Isum.n389 0.1445
R999 Isum.n391 Isum.n390 0.1445
R1000 Isum.n393 Isum.n391 0.1445
R1001 Isum.n393 Isum.n392 0.1445
R1002 Isum.n392 Isum.n356 0.1445
R1003 Isum.n356 Isum.n354 0.1445
R1004 Isum.n414 Isum.n354 0.1445
R1005 Isum.n415 Isum.n414 0.1445
R1006 Isum.n416 Isum.n415 0.1445
R1007 Isum.n416 Isum.n352 0.1445
R1008 Isum.n421 Isum.n352 0.1445
R1009 Isum.n422 Isum.n421 0.1445
R1010 Isum.n423 Isum.n422 0.1445
R1011 Isum.n423 Isum.n350 0.1445
R1012 Isum.n428 Isum.n350 0.1445
R1013 Isum.n506 Isum.n505 0.1445
R1014 Isum.n505 Isum.n71 0.1445
R1015 Isum.n500 Isum.n71 0.1445
R1016 Isum.n500 Isum.n499 0.1445
R1017 Isum.n499 Isum.n77 0.1445
R1018 Isum.n495 Isum.n77 0.1445
R1019 Isum.n495 Isum.n494 0.1445
R1020 Isum.n494 Isum.n493 0.1445
R1021 Isum.n493 Isum.n86 0.1445
R1022 Isum.n489 Isum.n86 0.1445
R1023 Isum.n489 Isum.n488 0.1445
R1024 Isum.n488 Isum.n96 0.1445
R1025 Isum.n484 Isum.n96 0.1445
R1026 Isum.n484 Isum.n483 0.1445
R1027 Isum.n483 Isum.n104 0.1445
R1028 Isum.n479 Isum.n104 0.1445
R1029 Isum.n479 Isum.n478 0.1445
R1030 Isum.n478 Isum.n111 0.1445
R1031 Isum.n474 Isum.n111 0.1445
R1032 Isum.n474 Isum.n473 0.1445
R1033 Isum.n473 Isum.n119 0.1445
R1034 Isum.n469 Isum.n119 0.1445
R1035 Isum.n469 Isum.n468 0.1445
R1036 Isum.n468 Isum.n467 0.1445
R1037 Isum.n467 Isum.n451 0.1445
R1038 Isum.n451 Isum.n44 0.1445
R1039 Isum.n576 Isum.n44 0.1445
R1040 Isum.n199 Isum.n198 0.1445
R1041 Isum.n320 Isum.n199 0.1445
R1042 Isum.n320 Isum.n319 0.1445
R1043 Isum.n319 Isum.n318 0.1445
R1044 Isum.n318 Isum.n200 0.1445
R1045 Isum.n314 Isum.n200 0.1445
R1046 Isum.n314 Isum.n313 0.1445
R1047 Isum.n313 Isum.n312 0.1445
R1048 Isum.n312 Isum.n205 0.1445
R1049 Isum.n308 Isum.n205 0.1445
R1050 Isum.n308 Isum.n307 0.1445
R1051 Isum.n307 Isum.n306 0.1445
R1052 Isum.n306 Isum.n210 0.1445
R1053 Isum.n302 Isum.n210 0.1445
R1054 Isum.n302 Isum.n25 0.1445
R1055 Isum.n596 Isum.n25 0.1445
R1056 Isum.n596 Isum.n595 0.1445
R1057 Isum.n595 Isum.n594 0.1445
R1058 Isum.n594 Isum.n26 0.1445
R1059 Isum.n590 Isum.n26 0.1445
R1060 Isum.n590 Isum.n589 0.1445
R1061 Isum.n589 Isum.n588 0.1445
R1062 Isum.n588 Isum.n31 0.1445
R1063 Isum.n584 Isum.n31 0.1445
R1064 Isum.n584 Isum.n583 0.1445
R1065 Isum.n583 Isum.n582 0.1445
R1066 Isum.n582 Isum.n36 0.1445
R1067 Isum.n509 Isum.n65 0.107278
R1068 Isum.n347 Isum.n346 0.0950455
R1069 Isum.n348 Isum.n347 0.0950455
R1070 Isum.n430 Isum.n429 0.0950455
R1071 Isum.n570 Isum.n47 0.0922644
R1072 Isum.n503 Isum.n66 0.0847125
R1073 Isum.n464 Isum.n48 0.0779226
R1074 VSS Isum.n0 0.0725
R1075 VSS Isum.n608 0.0725
R1076 Isum.n568 Isum.n567 0.0572937
R1077 Isum.n512 Isum.n511 0.0572937
R1078 Isum.n567 Isum.n566 0.0552335
R1079 Isum.n513 Isum.n512 0.0552335
R1080 Isum.n48 Isum.n47 0.0430846
R1081 Isum.n66 Isum.n65 0.0367015
R1082 Isum.n568 Isum.n47 0.0277385
R1083 Isum.n511 Isum.n65 0.0277385
R1084 Isum.n524 Isum.n63 0.0203347
R1085 Isum.n525 Isum.n524 0.0203347
R1086 Isum.n526 Isum.n525 0.0203347
R1087 Isum.n531 Isum.n530 0.0203347
R1088 Isum.n532 Isum.n531 0.0203347
R1089 Isum.n536 Isum.n535 0.0203347
R1090 Isum.n536 Isum.n56 0.0203347
R1091 Isum.n543 Isum.n57 0.0203347
R1092 Isum.n57 Isum.n55 0.0203347
R1093 Isum.n549 Isum.n548 0.0203347
R1094 Isum.n549 Isum.n52 0.0203347
R1095 Isum.n556 Isum.n53 0.0203347
R1096 Isum.n53 Isum.n51 0.0203347
R1097 Isum.n561 Isum.n51 0.0203347
R1098 Isum.n566 Isum.n49 0.0186975
R1099 Isum.n513 Isum.n64 0.0186975
R1100 Isum.n530 Isum.n61 0.0183512
R1101 Isum.n557 Isum.n52 0.0183512
R1102 Isum.n502 Isum.n501 0.0167896
R1103 Isum.n498 Isum.n497 0.0167896
R1104 Isum.n497 Isum.n496 0.0167896
R1105 Isum.n496 Isum.n82 0.0167896
R1106 Isum.n492 Isum.n491 0.0167896
R1107 Isum.n491 Isum.n490 0.0167896
R1108 Isum.n487 Isum.n486 0.0167896
R1109 Isum.n486 Isum.n485 0.0167896
R1110 Isum.n482 Isum.n481 0.0167896
R1111 Isum.n481 Isum.n480 0.0167896
R1112 Isum.n477 Isum.n476 0.0167896
R1113 Isum.n476 Isum.n475 0.0167896
R1114 Isum.n472 Isum.n471 0.0167896
R1115 Isum.n471 Isum.n470 0.0167896
R1116 Isum.n470 Isum.n124 0.0167896
R1117 Isum.n466 Isum.n465 0.0167896
R1118 Isum.n501 Isum.n74 0.0151606
R1119 Isum.n492 Isum.n87 0.0151606
R1120 Isum.n475 Isum.n116 0.0151606
R1121 Isum.n466 Isum.n459 0.0151606
R1122 Isum.n504 Isum.n503 0.014448
R1123 Isum.n464 Isum.n463 0.014448
R1124 Isum.n535 Isum.n59 0.0143843
R1125 Isum.n547 Isum.n55 0.0143843
R1126 Isum.n564 Isum.n49 0.0119263
R1127 Isum.n519 Isum.n64 0.0119263
R1128 Isum.n507 Isum.n68 0.0119027
R1129 Isum.n487 Isum.n93 0.0119027
R1130 Isum.n480 Isum.n109 0.0119027
R1131 Isum.n575 Isum.n45 0.0119027
R1132 Isum.n544 Isum.n56 0.0104174
R1133 Isum.n544 Isum.n543 0.0104174
R1134 Isum.n485 Isum.n101 0.0086448
R1135 Isum.n482 Isum.n101 0.0086448
R1136 Isum.n532 Isum.n59 0.00645041
R1137 Isum.n548 Isum.n547 0.00645041
R1138 Isum.n504 Isum.n68 0.00538688
R1139 Isum.n490 Isum.n93 0.00538688
R1140 Isum.n477 Isum.n109 0.00538688
R1141 Isum.n463 Isum.n45 0.00538688
R1142 Isum.n503 Isum.n502 0.00284163
R1143 Isum.n465 Isum.n464 0.00284163
R1144 Isum.n508 Isum.n507 0.00273982
R1145 Isum.n516 Isum.n63 0.00248347
R1146 Isum.n526 Isum.n61 0.00248347
R1147 Isum.n557 Isum.n556 0.00248347
R1148 Isum.n561 Isum.n560 0.00248347
R1149 Isum.n574 Isum.n571 0.00233258
R1150 Isum.n498 Isum.n74 0.00212896
R1151 Isum.n87 Isum.n82 0.00212896
R1152 Isum.n472 Isum.n116 0.00212896
R1153 Isum.n459 Isum.n124 0.00212896
R1154 Isum.n516 Isum.n64 0.00149173
R1155 Isum.n560 Isum.n49 0.00149173
R1156 Isum.n575 Isum.n574 0.00090724
R1157 VDD.n387 VDD.n386 175.351
R1158 VDD.n452 VDD.n451 175.351
R1159 VDD.n388 VDD.n387 175.351
R1160 VDD.n451 VDD.n450 175.351
R1161 VDD.n231 VDD.n64 163.012
R1162 VDD.n508 VDD.n30 163.012
R1163 VDD.n506 VDD.n30 52.6716
R1164 VDD.n66 VDD.n64 52.6716
R1165 VDD.n230 VDD.n229 47.422
R1166 VDD.n143 VDD.n120 47.422
R1167 VDD.n143 VDD.n142 47.422
R1168 VDD.n157 VDD.n117 47.422
R1169 VDD.n158 VDD.n157 47.422
R1170 VDD.n161 VDD.n160 47.422
R1171 VDD.n160 VDD.n159 47.422
R1172 VDD.n208 VDD.n207 47.422
R1173 VDD.n207 VDD.n206 47.422
R1174 VDD.n206 VDD.n205 47.422
R1175 VDD.n204 VDD.n203 47.422
R1176 VDD.n203 VDD.n99 47.422
R1177 VDD.n193 VDD.n192 47.422
R1178 VDD.n192 VDD.n191 47.422
R1179 VDD.n190 VDD.n189 47.422
R1180 VDD.n189 VDD.n187 47.422
R1181 VDD.n507 VDD.n31 47.422
R1182 VDD.n159 VDD.t16 42.6798
R1183 VDD.t13 VDD.n204 42.6798
R1184 VDD.n120 VDD.t25 33.1955
R1185 VDD.t19 VDD.n158 33.1955
R1186 VDD.n193 VDD.t10 33.1955
R1187 VDD.n187 VDD.t4 33.1955
R1188 VDD.t31 VDD.n228 27.8606
R1189 VDD.n301 VDD.t28 27.8606
R1190 VDD.n142 VDD.t22 23.7112
R1191 VDD.t22 VDD.n117 23.7112
R1192 VDD.n191 VDD.t7 23.7112
R1193 VDD.t7 VDD.n190 23.7112
R1194 VDD.n229 VDD.t31 19.5619
R1195 VDD.t28 VDD.n31 19.5619
R1196 VDD.n500 VDD.t0 18.0519
R1197 VDD.n501 VDD.t2 17.528
R1198 VDD.n499 VDD.t50 17.528
R1199 VDD.n293 VDD.t27 14.9553
R1200 VDD.n238 VDD.t30 14.9553
R1201 VDD.n228 VDD.t25 14.2269
R1202 VDD.n301 VDD.t4 14.2269
R1203 VDD.n225 VDD.n73 14.1851
R1204 VDD.n298 VDD.n40 14.1851
R1205 VDD.n231 VDD.n65 14.0005
R1206 VDD.n227 VDD.n65 14.0005
R1207 VDD.n227 VDD.n69 14.0005
R1208 VDD.n144 VDD.n69 14.0005
R1209 VDD.n144 VDD.n119 14.0005
R1210 VDD.n155 VDD.n119 14.0005
R1211 VDD.n156 VDD.n155 14.0005
R1212 VDD.n156 VDD.n80 14.0005
R1213 VDD.n81 VDD.n80 14.0005
R1214 VDD.n82 VDD.n81 14.0005
R1215 VDD.n91 VDD.n82 14.0005
R1216 VDD.n209 VDD.n91 14.0005
R1217 VDD.n209 VDD.n92 14.0005
R1218 VDD.n92 VDD.n5 14.0005
R1219 VDD.n6 VDD.n5 14.0005
R1220 VDD.n7 VDD.n6 14.0005
R1221 VDD.n202 VDD.n7 14.0005
R1222 VDD.n202 VDD.n201 14.0005
R1223 VDD.n201 VDD.n194 14.0005
R1224 VDD.n194 VDD.n17 14.0005
R1225 VDD.n18 VDD.n17 14.0005
R1226 VDD.n19 VDD.n18 14.0005
R1227 VDD.n188 VDD.n19 14.0005
R1228 VDD.n188 VDD.n37 14.0005
R1229 VDD.n300 VDD.n37 14.0005
R1230 VDD.n300 VDD.n29 14.0005
R1231 VDD.n508 VDD.n29 14.0005
R1232 VDD.n126 VDD.n67 14.0005
R1233 VDD.n68 VDD.n67 14.0005
R1234 VDD.n132 VDD.n68 14.0005
R1235 VDD.n132 VDD.n121 14.0005
R1236 VDD.n141 VDD.n121 14.0005
R1237 VDD.n141 VDD.n122 14.0005
R1238 VDD.n122 VDD.n118 14.0005
R1239 VDD.n118 VDD.n115 14.0005
R1240 VDD.n162 VDD.n115 14.0005
R1241 VDD.n162 VDD.n116 14.0005
R1242 VDD.n116 VDD.n112 14.0005
R1243 VDD.n112 VDD.n93 14.0005
R1244 VDD.n94 VDD.n93 14.0005
R1245 VDD.n95 VDD.n94 14.0005
R1246 VDD.n96 VDD.n95 14.0005
R1247 VDD.n97 VDD.n96 14.0005
R1248 VDD.n98 VDD.n97 14.0005
R1249 VDD.n106 VDD.n98 14.0005
R1250 VDD.n106 VDD.n100 14.0005
R1251 VDD.n101 VDD.n100 14.0005
R1252 VDD.n102 VDD.n101 14.0005
R1253 VDD.n103 VDD.n102 14.0005
R1254 VDD.n186 VDD.n103 14.0005
R1255 VDD.n186 VDD.n36 14.0005
R1256 VDD.n302 VDD.n36 14.0005
R1257 VDD.n302 VDD.n32 14.0005
R1258 VDD.n505 VDD.n32 14.0005
R1259 VDD.n386 VDD.n383 14.0005
R1260 VDD.n383 VDD.n310 14.0005
R1261 VDD.n311 VDD.n310 14.0005
R1262 VDD.n312 VDD.n311 14.0005
R1263 VDD.n315 VDD.n312 14.0005
R1264 VDD.n316 VDD.n315 14.0005
R1265 VDD.n317 VDD.n316 14.0005
R1266 VDD.n318 VDD.n317 14.0005
R1267 VDD.n321 VDD.n318 14.0005
R1268 VDD.n322 VDD.n321 14.0005
R1269 VDD.n323 VDD.n322 14.0005
R1270 VDD.n324 VDD.n323 14.0005
R1271 VDD.n327 VDD.n324 14.0005
R1272 VDD.n328 VDD.n327 14.0005
R1273 VDD.n329 VDD.n328 14.0005
R1274 VDD.n330 VDD.n329 14.0005
R1275 VDD.n333 VDD.n330 14.0005
R1276 VDD.n334 VDD.n333 14.0005
R1277 VDD.n335 VDD.n334 14.0005
R1278 VDD.n336 VDD.n335 14.0005
R1279 VDD.n339 VDD.n336 14.0005
R1280 VDD.n340 VDD.n339 14.0005
R1281 VDD.n341 VDD.n340 14.0005
R1282 VDD.n342 VDD.n341 14.0005
R1283 VDD.n345 VDD.n342 14.0005
R1284 VDD.n346 VDD.n345 14.0005
R1285 VDD.n347 VDD.n346 14.0005
R1286 VDD.n348 VDD.n347 14.0005
R1287 VDD.n351 VDD.n348 14.0005
R1288 VDD.n452 VDD.n351 14.0005
R1289 VDD.n388 VDD.n380 14.0005
R1290 VDD.n394 VDD.n380 14.0005
R1291 VDD.n395 VDD.n394 14.0005
R1292 VDD.n396 VDD.n395 14.0005
R1293 VDD.n396 VDD.n376 14.0005
R1294 VDD.n402 VDD.n376 14.0005
R1295 VDD.n403 VDD.n402 14.0005
R1296 VDD.n404 VDD.n403 14.0005
R1297 VDD.n404 VDD.n372 14.0005
R1298 VDD.n410 VDD.n372 14.0005
R1299 VDD.n411 VDD.n410 14.0005
R1300 VDD.n412 VDD.n411 14.0005
R1301 VDD.n412 VDD.n368 14.0005
R1302 VDD.n418 VDD.n368 14.0005
R1303 VDD.n419 VDD.n418 14.0005
R1304 VDD.n420 VDD.n419 14.0005
R1305 VDD.n420 VDD.n364 14.0005
R1306 VDD.n426 VDD.n364 14.0005
R1307 VDD.n427 VDD.n426 14.0005
R1308 VDD.n428 VDD.n427 14.0005
R1309 VDD.n428 VDD.n360 14.0005
R1310 VDD.n434 VDD.n360 14.0005
R1311 VDD.n435 VDD.n434 14.0005
R1312 VDD.n436 VDD.n435 14.0005
R1313 VDD.n436 VDD.n356 14.0005
R1314 VDD.n442 VDD.n356 14.0005
R1315 VDD.n443 VDD.n442 14.0005
R1316 VDD.n444 VDD.n443 14.0005
R1317 VDD.n444 VDD.n352 14.0005
R1318 VDD.n450 VDD.n352 14.0005
R1319 VDD.n288 VDD.n287 12.5005
R1320 VDD.n45 VDD.n44 12.5005
R1321 VDD.n280 VDD.n47 12.5005
R1322 VDD.n282 VDD.n281 12.5005
R1323 VDD.n278 VDD.n46 12.5005
R1324 VDD.n276 VDD.n275 12.5005
R1325 VDD.n274 VDD.n48 12.5005
R1326 VDD.n265 VDD.n49 12.5005
R1327 VDD.n267 VDD.n51 12.5005
R1328 VDD.n269 VDD.n268 12.5005
R1329 VDD.n264 VDD.n50 12.5005
R1330 VDD.n263 VDD.n262 12.5005
R1331 VDD.n261 VDD.n260 12.5005
R1332 VDD.n259 VDD.n258 12.5005
R1333 VDD.n257 VDD.n54 12.5005
R1334 VDD.n256 VDD.n255 12.5005
R1335 VDD.n253 VDD.n252 12.5005
R1336 VDD.n251 VDD.n56 12.5005
R1337 VDD.n250 VDD.n249 12.5005
R1338 VDD.n247 VDD.n57 12.5005
R1339 VDD.n39 VDD.n25 12.5005
R1340 VDD.n514 VDD.n24 12.5005
R1341 VDD.n515 VDD.n23 12.5005
R1342 VDD.n21 VDD.n15 12.5005
R1343 VDD.n519 VDD.n14 12.5005
R1344 VDD.n196 VDD.n13 12.5005
R1345 VDD.n199 VDD.n198 12.5005
R1346 VDD.n195 VDD.n12 12.5005
R1347 VDD.n524 VDD.n11 12.5005
R1348 VDD.n9 VDD.n3 12.5005
R1349 VDD.n528 VDD.n2 12.5005
R1350 VDD.n89 VDD.n0 12.5005
R1351 VDD.n211 VDD.n90 12.5005
R1352 VDD.n212 VDD.n87 12.5005
R1353 VDD.n215 VDD.n86 12.5005
R1354 VDD.n85 VDD.n78 12.5005
R1355 VDD.n219 VDD.n77 12.5005
R1356 VDD.n151 VDD.n76 12.5005
R1357 VDD.n153 VDD.n152 12.5005
R1358 VDD.n149 VDD.n147 12.5005
R1359 VDD.n148 VDD.n75 12.5005
R1360 VDD.n224 VDD.n74 12.5005
R1361 VDD.n161 VDD.t49 12.4486
R1362 VDD.t1 VDD.n99 12.4486
R1363 VDD.t5 VDD.n511 11.4188
R1364 VDD.t26 VDD.n62 11.4188
R1365 VDD.n498 VDD.n497 10.4783
R1366 VDD.n502 VDD.n501 10.1327
R1367 VDD.n247 VDD.n246 9.95036
R1368 VDD.n289 VDD.n288 9.95036
R1369 VDD.n89 VDD.n2 9.86111
R1370 VDD.n268 VDD.n264 9.86111
R1371 VDD.n498 VDD.t51 9.83035
R1372 VDD.n87 VDD.n86 9.55788
R1373 VDD.n195 VDD.n11 9.55788
R1374 VDD.n260 VDD.n259 9.55788
R1375 VDD.n265 VDD.n48 9.55788
R1376 VDD.n244 VDD.t48 9.1205
R1377 VDD.n291 VDD.t34 9.1205
R1378 VDD.n148 VDD.n74 8.34496
R1379 VDD.n151 VDD.n77 8.34496
R1380 VDD.n196 VDD.n14 8.34496
R1381 VDD.n39 VDD.n24 8.34496
R1382 VDD.n255 VDD.n253 8.34496
R1383 VDD.n281 VDD.n278 8.34496
R1384 VDD.n513 VDD.n512 7.53568
R1385 VDD.n523 VDD.n522 7.53568
R1386 VDD.n214 VDD.n213 7.53568
R1387 VDD.n223 VDD.n222 7.53568
R1388 VDD.n286 VDD.n285 7.53568
R1389 VDD.n273 VDD.n272 7.53568
R1390 VDD.n240 VDD.n53 7.53568
R1391 VDD.n243 VDD.n242 7.53568
R1392 VDD.n521 VDD.n520 7.49884
R1393 VDD VDD.n1 7.49884
R1394 VDD.n221 VDD.n220 7.49884
R1395 VDD.n284 VDD.n283 7.49884
R1396 VDD.n271 VDD.n270 7.49884
R1397 VDD.n241 VDD.n55 7.49884
R1398 VDD.n149 VDD.n148 7.13204
R1399 VDD.n152 VDD.n151 7.13204
R1400 VDD.n21 VDD.n14 7.13204
R1401 VDD.n24 VDD.n23 7.13204
R1402 VDD.n249 VDD.n247 7.13204
R1403 VDD.n253 VDD.n56 7.13204
R1404 VDD.n281 VDD.n280 7.13204
R1405 VDD.n288 VDD.n44 7.13204
R1406 VDD.n454 VDD.n350 6.47119
R1407 VDD.n448 VDD.n350 6.47119
R1408 VDD.n390 VDD.n382 6.47119
R1409 VDD.n384 VDD.n382 6.47119
R1410 VDD.n128 VDD.n61 6.32942
R1411 VDD.n234 VDD.n61 6.30962
R1412 VDD.n232 VDD.n231 6.3005
R1413 VDD.n231 VDD.n230 6.3005
R1414 VDD.n65 VDD.n63 6.3005
R1415 VDD.n229 VDD.n65 6.3005
R1416 VDD.n227 VDD.n226 6.3005
R1417 VDD.n228 VDD.n227 6.3005
R1418 VDD.n70 VDD.n69 6.3005
R1419 VDD.n120 VDD.n69 6.3005
R1420 VDD.n145 VDD.n144 6.3005
R1421 VDD.n144 VDD.n143 6.3005
R1422 VDD.n146 VDD.n119 6.3005
R1423 VDD.n142 VDD.n119 6.3005
R1424 VDD.n155 VDD.n154 6.3005
R1425 VDD.n155 VDD.n117 6.3005
R1426 VDD.n156 VDD.n79 6.3005
R1427 VDD.n157 VDD.n156 6.3005
R1428 VDD.n218 VDD.n80 6.3005
R1429 VDD.n158 VDD.n80 6.3005
R1430 VDD.n217 VDD.n81 6.3005
R1431 VDD.n161 VDD.n81 6.3005
R1432 VDD.n216 VDD.n82 6.3005
R1433 VDD.n160 VDD.n82 6.3005
R1434 VDD.n91 VDD.n83 6.3005
R1435 VDD.n159 VDD.n91 6.3005
R1436 VDD.n210 VDD.n209 6.3005
R1437 VDD.n209 VDD.n208 6.3005
R1438 VDD.n92 VDD.n4 6.3005
R1439 VDD.n207 VDD.n92 6.3005
R1440 VDD.n527 VDD.n5 6.3005
R1441 VDD.n206 VDD.n5 6.3005
R1442 VDD.n526 VDD.n6 6.3005
R1443 VDD.n205 VDD.n6 6.3005
R1444 VDD.n525 VDD.n7 6.3005
R1445 VDD.n204 VDD.n7 6.3005
R1446 VDD.n202 VDD.n8 6.3005
R1447 VDD.n203 VDD.n202 6.3005
R1448 VDD.n201 VDD.n200 6.3005
R1449 VDD.n201 VDD.n99 6.3005
R1450 VDD.n194 VDD.n16 6.3005
R1451 VDD.n194 VDD.n193 6.3005
R1452 VDD.n518 VDD.n17 6.3005
R1453 VDD.n192 VDD.n17 6.3005
R1454 VDD.n517 VDD.n18 6.3005
R1455 VDD.n191 VDD.n18 6.3005
R1456 VDD.n516 VDD.n19 6.3005
R1457 VDD.n190 VDD.n19 6.3005
R1458 VDD.n188 VDD.n20 6.3005
R1459 VDD.n189 VDD.n188 6.3005
R1460 VDD.n38 VDD.n37 6.3005
R1461 VDD.n187 VDD.n37 6.3005
R1462 VDD.n300 VDD.n299 6.3005
R1463 VDD.n301 VDD.n300 6.3005
R1464 VDD.n29 VDD.n28 6.3005
R1465 VDD.n31 VDD.n29 6.3005
R1466 VDD.n509 VDD.n508 6.3005
R1467 VDD.n508 VDD.n507 6.3005
R1468 VDD.n505 VDD.n504 6.3005
R1469 VDD.n33 VDD.n32 6.3005
R1470 VDD.n32 VDD.n31 6.3005
R1471 VDD.n303 VDD.n302 6.3005
R1472 VDD.n302 VDD.n301 6.3005
R1473 VDD.n36 VDD.n35 6.3005
R1474 VDD.n187 VDD.n36 6.3005
R1475 VDD.n186 VDD.n185 6.3005
R1476 VDD.n189 VDD.n186 6.3005
R1477 VDD.n104 VDD.n103 6.3005
R1478 VDD.n190 VDD.n103 6.3005
R1479 VDD.n181 VDD.n102 6.3005
R1480 VDD.n191 VDD.n102 6.3005
R1481 VDD.n180 VDD.n101 6.3005
R1482 VDD.n192 VDD.n101 6.3005
R1483 VDD.n179 VDD.n100 6.3005
R1484 VDD.n193 VDD.n100 6.3005
R1485 VDD.n107 VDD.n106 6.3005
R1486 VDD.n106 VDD.n99 6.3005
R1487 VDD.n175 VDD.n98 6.3005
R1488 VDD.n203 VDD.n98 6.3005
R1489 VDD.n174 VDD.n97 6.3005
R1490 VDD.n204 VDD.n97 6.3005
R1491 VDD.n173 VDD.n96 6.3005
R1492 VDD.n205 VDD.n96 6.3005
R1493 VDD.n109 VDD.n95 6.3005
R1494 VDD.n206 VDD.n95 6.3005
R1495 VDD.n169 VDD.n94 6.3005
R1496 VDD.n207 VDD.n94 6.3005
R1497 VDD.n168 VDD.n93 6.3005
R1498 VDD.n208 VDD.n93 6.3005
R1499 VDD.n167 VDD.n112 6.3005
R1500 VDD.n159 VDD.n112 6.3005
R1501 VDD.n116 VDD.n111 6.3005
R1502 VDD.n160 VDD.n116 6.3005
R1503 VDD.n163 VDD.n162 6.3005
R1504 VDD.n162 VDD.n161 6.3005
R1505 VDD.n115 VDD.n114 6.3005
R1506 VDD.n158 VDD.n115 6.3005
R1507 VDD.n136 VDD.n118 6.3005
R1508 VDD.n157 VDD.n118 6.3005
R1509 VDD.n124 VDD.n122 6.3005
R1510 VDD.n122 VDD.n117 6.3005
R1511 VDD.n141 VDD.n140 6.3005
R1512 VDD.n142 VDD.n141 6.3005
R1513 VDD.n123 VDD.n121 6.3005
R1514 VDD.n143 VDD.n121 6.3005
R1515 VDD.n133 VDD.n132 6.3005
R1516 VDD.n132 VDD.n120 6.3005
R1517 VDD.n131 VDD.n68 6.3005
R1518 VDD.n228 VDD.n68 6.3005
R1519 VDD.n130 VDD.n67 6.3005
R1520 VDD.n229 VDD.n67 6.3005
R1521 VDD.n127 VDD.n126 6.3005
R1522 VDD.n453 VDD.n452 6.3005
R1523 VDD.n351 VDD.n349 6.3005
R1524 VDD.n457 VDD.n348 6.3005
R1525 VDD.n458 VDD.n347 6.3005
R1526 VDD.n459 VDD.n346 6.3005
R1527 VDD.n345 VDD.n343 6.3005
R1528 VDD.n463 VDD.n342 6.3005
R1529 VDD.n464 VDD.n341 6.3005
R1530 VDD.n465 VDD.n340 6.3005
R1531 VDD.n339 VDD.n337 6.3005
R1532 VDD.n469 VDD.n336 6.3005
R1533 VDD.n470 VDD.n335 6.3005
R1534 VDD.n471 VDD.n334 6.3005
R1535 VDD.n333 VDD.n331 6.3005
R1536 VDD.n475 VDD.n330 6.3005
R1537 VDD.n476 VDD.n329 6.3005
R1538 VDD.n477 VDD.n328 6.3005
R1539 VDD.n327 VDD.n325 6.3005
R1540 VDD.n481 VDD.n324 6.3005
R1541 VDD.n482 VDD.n323 6.3005
R1542 VDD.n483 VDD.n322 6.3005
R1543 VDD.n321 VDD.n319 6.3005
R1544 VDD.n487 VDD.n318 6.3005
R1545 VDD.n488 VDD.n317 6.3005
R1546 VDD.n489 VDD.n316 6.3005
R1547 VDD.n315 VDD.n313 6.3005
R1548 VDD.n493 VDD.n312 6.3005
R1549 VDD.n494 VDD.n311 6.3005
R1550 VDD.n495 VDD.n310 6.3005
R1551 VDD.n383 VDD.n309 6.3005
R1552 VDD.n386 VDD.n385 6.3005
R1553 VDD.n450 VDD.n449 6.3005
R1554 VDD.n353 VDD.n352 6.3005
R1555 VDD.n445 VDD.n444 6.3005
R1556 VDD.n443 VDD.n355 6.3005
R1557 VDD.n442 VDD.n441 6.3005
R1558 VDD.n357 VDD.n356 6.3005
R1559 VDD.n437 VDD.n436 6.3005
R1560 VDD.n435 VDD.n359 6.3005
R1561 VDD.n434 VDD.n433 6.3005
R1562 VDD.n361 VDD.n360 6.3005
R1563 VDD.n429 VDD.n428 6.3005
R1564 VDD.n427 VDD.n363 6.3005
R1565 VDD.n426 VDD.n425 6.3005
R1566 VDD.n365 VDD.n364 6.3005
R1567 VDD.n421 VDD.n420 6.3005
R1568 VDD.n419 VDD.n367 6.3005
R1569 VDD.n418 VDD.n417 6.3005
R1570 VDD.n369 VDD.n368 6.3005
R1571 VDD.n413 VDD.n412 6.3005
R1572 VDD.n411 VDD.n371 6.3005
R1573 VDD.n410 VDD.n409 6.3005
R1574 VDD.n373 VDD.n372 6.3005
R1575 VDD.n405 VDD.n404 6.3005
R1576 VDD.n403 VDD.n375 6.3005
R1577 VDD.n402 VDD.n401 6.3005
R1578 VDD.n377 VDD.n376 6.3005
R1579 VDD.n397 VDD.n396 6.3005
R1580 VDD.n395 VDD.n379 6.3005
R1581 VDD.n394 VDD.n393 6.3005
R1582 VDD.n381 VDD.n380 6.3005
R1583 VDD.n389 VDD.n388 6.3005
R1584 VDD.n306 VDD.n27 6.21664
R1585 VDD.n502 VDD.n306 6.07444
R1586 VDD.n86 VDD.n85 5.91912
R1587 VDD.n198 VDD.n195 5.91912
R1588 VDD.n259 VDD.n54 5.91912
R1589 VDD.n276 VDD.n48 5.91912
R1590 VDD.n290 VDD.n289 5.8218
R1591 VDD.n246 VDD.n245 5.8218
R1592 VDD.n90 VDD.n89 5.61588
R1593 VDD.n9 VDD.n2 5.61588
R1594 VDD.n264 VDD.n263 5.61588
R1595 VDD.n268 VDD.n267 5.61588
R1596 VDD.n88 VDD.n87 5.05435
R1597 VDD.n11 VDD.n10 5.05435
R1598 VDD.n260 VDD.n52 5.05435
R1599 VDD.n266 VDD.n265 5.05435
R1600 VDD.n208 VDD.t16 4.74265
R1601 VDD.n205 VDD.t13 4.74265
R1602 VDD.n244 VDD.n239 4.69811
R1603 VDD.n292 VDD.n291 4.69811
R1604 VDD.n391 VDD.n381 4.5005
R1605 VDD.n393 VDD.n392 4.5005
R1606 VDD.n379 VDD.n378 4.5005
R1607 VDD.n398 VDD.n397 4.5005
R1608 VDD.n399 VDD.n377 4.5005
R1609 VDD.n401 VDD.n400 4.5005
R1610 VDD.n375 VDD.n374 4.5005
R1611 VDD.n406 VDD.n405 4.5005
R1612 VDD.n407 VDD.n373 4.5005
R1613 VDD.n409 VDD.n408 4.5005
R1614 VDD.n371 VDD.n370 4.5005
R1615 VDD.n414 VDD.n413 4.5005
R1616 VDD.n415 VDD.n369 4.5005
R1617 VDD.n417 VDD.n416 4.5005
R1618 VDD.n367 VDD.n366 4.5005
R1619 VDD.n422 VDD.n421 4.5005
R1620 VDD.n423 VDD.n365 4.5005
R1621 VDD.n425 VDD.n424 4.5005
R1622 VDD.n363 VDD.n362 4.5005
R1623 VDD.n430 VDD.n429 4.5005
R1624 VDD.n431 VDD.n361 4.5005
R1625 VDD.n433 VDD.n432 4.5005
R1626 VDD.n359 VDD.n358 4.5005
R1627 VDD.n438 VDD.n437 4.5005
R1628 VDD.n439 VDD.n357 4.5005
R1629 VDD.n441 VDD.n440 4.5005
R1630 VDD.n355 VDD.n354 4.5005
R1631 VDD.n446 VDD.n445 4.5005
R1632 VDD.n447 VDD.n353 4.5005
R1633 VDD.n449 VDD.n448 4.5005
R1634 VDD.n390 VDD.n389 4.5005
R1635 VDD.n309 VDD.n307 4.5005
R1636 VDD.n496 VDD.n495 4.5005
R1637 VDD.n494 VDD.n308 4.5005
R1638 VDD.n493 VDD.n492 4.5005
R1639 VDD.n491 VDD.n313 4.5005
R1640 VDD.n490 VDD.n489 4.5005
R1641 VDD.n488 VDD.n314 4.5005
R1642 VDD.n487 VDD.n486 4.5005
R1643 VDD.n485 VDD.n319 4.5005
R1644 VDD.n484 VDD.n483 4.5005
R1645 VDD.n482 VDD.n320 4.5005
R1646 VDD.n481 VDD.n480 4.5005
R1647 VDD.n479 VDD.n325 4.5005
R1648 VDD.n478 VDD.n477 4.5005
R1649 VDD.n476 VDD.n326 4.5005
R1650 VDD.n475 VDD.n474 4.5005
R1651 VDD.n473 VDD.n331 4.5005
R1652 VDD.n472 VDD.n471 4.5005
R1653 VDD.n470 VDD.n332 4.5005
R1654 VDD.n469 VDD.n468 4.5005
R1655 VDD.n467 VDD.n337 4.5005
R1656 VDD.n466 VDD.n465 4.5005
R1657 VDD.n464 VDD.n338 4.5005
R1658 VDD.n463 VDD.n462 4.5005
R1659 VDD.n461 VDD.n343 4.5005
R1660 VDD.n460 VDD.n459 4.5005
R1661 VDD.n458 VDD.n344 4.5005
R1662 VDD.n457 VDD.n456 4.5005
R1663 VDD.n455 VDD.n349 4.5005
R1664 VDD.n454 VDD.n453 4.5005
R1665 VDD.n385 VDD.n384 4.5005
R1666 VDD.n130 VDD.n129 4.5005
R1667 VDD.n131 VDD.n125 4.5005
R1668 VDD.n134 VDD.n133 4.5005
R1669 VDD.n135 VDD.n123 4.5005
R1670 VDD.n140 VDD.n139 4.5005
R1671 VDD.n138 VDD.n124 4.5005
R1672 VDD.n137 VDD.n136 4.5005
R1673 VDD.n114 VDD.n113 4.5005
R1674 VDD.n164 VDD.n163 4.5005
R1675 VDD.n165 VDD.n111 4.5005
R1676 VDD.n167 VDD.n166 4.5005
R1677 VDD.n168 VDD.n110 4.5005
R1678 VDD.n170 VDD.n169 4.5005
R1679 VDD.n171 VDD.n109 4.5005
R1680 VDD.n173 VDD.n172 4.5005
R1681 VDD.n174 VDD.n108 4.5005
R1682 VDD.n176 VDD.n175 4.5005
R1683 VDD.n177 VDD.n107 4.5005
R1684 VDD.n179 VDD.n178 4.5005
R1685 VDD.n180 VDD.n105 4.5005
R1686 VDD.n182 VDD.n181 4.5005
R1687 VDD.n183 VDD.n104 4.5005
R1688 VDD.n185 VDD.n184 4.5005
R1689 VDD.n35 VDD.n34 4.5005
R1690 VDD.n304 VDD.n303 4.5005
R1691 VDD.n305 VDD.n33 4.5005
R1692 VDD.n504 VDD.n503 4.5005
R1693 VDD.n128 VDD.n127 4.5005
R1694 VDD.n291 VDD.n290 4.5005
R1695 VDD.n245 VDD.n244 4.5005
R1696 VDD.n233 VDD.n232 4.5005
R1697 VDD.n71 VDD.n63 4.5005
R1698 VDD.n226 VDD.n225 4.5005
R1699 VDD.n224 VDD.n70 4.5005
R1700 VDD.n145 VDD.n75 4.5005
R1701 VDD.n147 VDD.n146 4.5005
R1702 VDD.n154 VDD.n153 4.5005
R1703 VDD.n79 VDD.n76 4.5005
R1704 VDD.n219 VDD.n218 4.5005
R1705 VDD.n217 VDD.n78 4.5005
R1706 VDD.n216 VDD.n215 4.5005
R1707 VDD.n212 VDD.n83 4.5005
R1708 VDD.n211 VDD.n210 4.5005
R1709 VDD.n4 VDD.n0 4.5005
R1710 VDD.n528 VDD.n527 4.5005
R1711 VDD.n526 VDD.n3 4.5005
R1712 VDD.n525 VDD.n524 4.5005
R1713 VDD.n12 VDD.n8 4.5005
R1714 VDD.n200 VDD.n199 4.5005
R1715 VDD.n16 VDD.n13 4.5005
R1716 VDD.n519 VDD.n518 4.5005
R1717 VDD.n517 VDD.n15 4.5005
R1718 VDD.n516 VDD.n515 4.5005
R1719 VDD.n514 VDD.n20 4.5005
R1720 VDD.n38 VDD.n25 4.5005
R1721 VDD.n299 VDD.n298 4.5005
R1722 VDD.n28 VDD.n26 4.5005
R1723 VDD.n510 VDD.n509 4.5005
R1724 VDD.n506 VDD.n505 4.10674
R1725 VDD.n126 VDD.n66 4.10674
R1726 VDD.n74 VDD.n73 3.93127
R1727 VDD.n84 VDD.n77 3.93127
R1728 VDD.n197 VDD.n196 3.93127
R1729 VDD.n40 VDD.n39 3.93127
R1730 VDD.n255 VDD.n254 3.93127
R1731 VDD.n278 VDD.n277 3.93127
R1732 VDD.n512 VDD.t8 3.9205
R1733 VDD.n512 VDD.t5 3.9205
R1734 VDD.t11 VDD.n521 3.9205
R1735 VDD.n521 VDD.t8 3.9205
R1736 VDD.n522 VDD.t14 3.9205
R1737 VDD.n522 VDD.t11 3.9205
R1738 VDD.t17 VDD.n1 3.9205
R1739 VDD.t14 VDD.n1 3.9205
R1740 VDD.n213 VDD.t20 3.9205
R1741 VDD.n213 VDD.t17 3.9205
R1742 VDD.t23 VDD.n221 3.9205
R1743 VDD.n221 VDD.t20 3.9205
R1744 VDD.n222 VDD.t26 3.9205
R1745 VDD.n222 VDD.t23 3.9205
R1746 VDD.n285 VDD.t36 3.9205
R1747 VDD.n285 VDD.t34 3.9205
R1748 VDD.n284 VDD.t38 3.9205
R1749 VDD.t36 VDD.n284 3.9205
R1750 VDD.n272 VDD.t40 3.9205
R1751 VDD.n272 VDD.t38 3.9205
R1752 VDD.n271 VDD.t42 3.9205
R1753 VDD.t40 VDD.n271 3.9205
R1754 VDD.t44 VDD.n240 3.9205
R1755 VDD.n240 VDD.t42 3.9205
R1756 VDD.t46 VDD.n241 3.9205
R1757 VDD.n241 VDD.t44 3.9205
R1758 VDD.t48 VDD.n243 3.9205
R1759 VDD.n243 VDD.t46 3.9205
R1760 VDD.n150 VDD.n149 2.80819
R1761 VDD.n152 VDD.n150 2.80819
R1762 VDD.n22 VDD.n21 2.80819
R1763 VDD.n23 VDD.n22 2.80819
R1764 VDD.n249 VDD.n248 2.80819
R1765 VDD.n248 VDD.n56 2.80819
R1766 VDD.n280 VDD.n279 2.80819
R1767 VDD.n279 VDD.n44 2.80819
R1768 VDD.n246 VDD.t47 2.73469
R1769 VDD.n289 VDD.t33 2.73469
R1770 VDD.n237 VDD.n236 2.35281
R1771 VDD.n294 VDD.n41 2.35281
R1772 VDD.n42 VDD.t29 2.16689
R1773 VDD.t32 VDD.n235 2.1594
R1774 VDD.n230 VDD.n66 2.03658
R1775 VDD.n507 VDD.n506 2.03658
R1776 VDD.n499 VDD.n498 1.9265
R1777 VDD.t49 VDD.t19 1.7788
R1778 VDD.t10 VDD.t1 1.7788
R1779 VDD.n85 VDD.n84 1.68512
R1780 VDD.n198 VDD.n197 1.68512
R1781 VDD.n254 VDD.n54 1.68512
R1782 VDD.n277 VDD.n276 1.68512
R1783 VDD.n296 VDD.n41 1.66246
R1784 VDD.n236 VDD.n60 1.65213
R1785 VDD.n236 VDD.t32 1.23336
R1786 VDD.t29 VDD.n41 1.23336
R1787 VDD.n501 VDD.n500 1.1759
R1788 VDD.n73 VDD.t24 0.913
R1789 VDD.n150 VDD.t21 0.913
R1790 VDD.n84 VDD.t18 0.913
R1791 VDD.n88 VDD.t15 0.913
R1792 VDD.n10 VDD.t12 0.913
R1793 VDD.n197 VDD.t9 0.913
R1794 VDD.n22 VDD.t6 0.913
R1795 VDD.n40 VDD.t3 0.913
R1796 VDD.n248 VDD.t45 0.913
R1797 VDD.n254 VDD.t43 0.913
R1798 VDD.n52 VDD.t41 0.913
R1799 VDD.n266 VDD.t39 0.913
R1800 VDD.n277 VDD.t37 0.913
R1801 VDD.n279 VDD.t35 0.913
R1802 VDD.n90 VDD.n88 0.562038
R1803 VDD.n10 VDD.n9 0.562038
R1804 VDD.n263 VDD.n52 0.562038
R1805 VDD.n267 VDD.n266 0.562038
R1806 VDD.n42 VDD.n27 0.462063
R1807 VDD.n235 VDD.n234 0.437113
R1808 VDD.n306 VDD.n30 0.203726
R1809 VDD.n64 VDD.n61 0.203726
R1810 VDD.n500 VDD.n499 0.1967
R1811 VDD.n451 VDD.n350 0.1755
R1812 VDD.n387 VDD.n382 0.1755
R1813 VDD.n503 VDD.n502 0.1625
R1814 VDD.n130 VDD.n127 0.1445
R1815 VDD.n131 VDD.n130 0.1445
R1816 VDD.n133 VDD.n131 0.1445
R1817 VDD.n133 VDD.n123 0.1445
R1818 VDD.n140 VDD.n123 0.1445
R1819 VDD.n140 VDD.n124 0.1445
R1820 VDD.n136 VDD.n124 0.1445
R1821 VDD.n136 VDD.n114 0.1445
R1822 VDD.n163 VDD.n114 0.1445
R1823 VDD.n163 VDD.n111 0.1445
R1824 VDD.n167 VDD.n111 0.1445
R1825 VDD.n168 VDD.n167 0.1445
R1826 VDD.n169 VDD.n168 0.1445
R1827 VDD.n169 VDD.n109 0.1445
R1828 VDD.n173 VDD.n109 0.1445
R1829 VDD.n174 VDD.n173 0.1445
R1830 VDD.n175 VDD.n174 0.1445
R1831 VDD.n175 VDD.n107 0.1445
R1832 VDD.n179 VDD.n107 0.1445
R1833 VDD.n180 VDD.n179 0.1445
R1834 VDD.n181 VDD.n180 0.1445
R1835 VDD.n181 VDD.n104 0.1445
R1836 VDD.n185 VDD.n104 0.1445
R1837 VDD.n185 VDD.n35 0.1445
R1838 VDD.n303 VDD.n35 0.1445
R1839 VDD.n303 VDD.n33 0.1445
R1840 VDD.n504 VDD.n33 0.1445
R1841 VDD.n232 VDD.n63 0.1445
R1842 VDD.n226 VDD.n63 0.1445
R1843 VDD.n226 VDD.n70 0.1445
R1844 VDD.n145 VDD.n70 0.1445
R1845 VDD.n146 VDD.n145 0.1445
R1846 VDD.n154 VDD.n146 0.1445
R1847 VDD.n154 VDD.n79 0.1445
R1848 VDD.n218 VDD.n79 0.1445
R1849 VDD.n218 VDD.n217 0.1445
R1850 VDD.n217 VDD.n216 0.1445
R1851 VDD.n216 VDD.n83 0.1445
R1852 VDD.n210 VDD.n83 0.1445
R1853 VDD.n210 VDD.n4 0.1445
R1854 VDD.n527 VDD.n4 0.1445
R1855 VDD.n527 VDD.n526 0.1445
R1856 VDD.n526 VDD.n525 0.1445
R1857 VDD.n525 VDD.n8 0.1445
R1858 VDD.n200 VDD.n8 0.1445
R1859 VDD.n200 VDD.n16 0.1445
R1860 VDD.n518 VDD.n16 0.1445
R1861 VDD.n518 VDD.n517 0.1445
R1862 VDD.n517 VDD.n516 0.1445
R1863 VDD.n516 VDD.n20 0.1445
R1864 VDD.n38 VDD.n20 0.1445
R1865 VDD.n299 VDD.n38 0.1445
R1866 VDD.n299 VDD.n28 0.1445
R1867 VDD.n509 VDD.n28 0.1445
R1868 VDD.n389 VDD.n381 0.1445
R1869 VDD.n393 VDD.n381 0.1445
R1870 VDD.n393 VDD.n379 0.1445
R1871 VDD.n397 VDD.n379 0.1445
R1872 VDD.n397 VDD.n377 0.1445
R1873 VDD.n401 VDD.n377 0.1445
R1874 VDD.n401 VDD.n375 0.1445
R1875 VDD.n405 VDD.n375 0.1445
R1876 VDD.n405 VDD.n373 0.1445
R1877 VDD.n409 VDD.n373 0.1445
R1878 VDD.n409 VDD.n371 0.1445
R1879 VDD.n413 VDD.n371 0.1445
R1880 VDD.n413 VDD.n369 0.1445
R1881 VDD.n417 VDD.n369 0.1445
R1882 VDD.n417 VDD.n367 0.1445
R1883 VDD.n421 VDD.n367 0.1445
R1884 VDD.n421 VDD.n365 0.1445
R1885 VDD.n425 VDD.n365 0.1445
R1886 VDD.n425 VDD.n363 0.1445
R1887 VDD.n429 VDD.n363 0.1445
R1888 VDD.n429 VDD.n361 0.1445
R1889 VDD.n433 VDD.n361 0.1445
R1890 VDD.n433 VDD.n359 0.1445
R1891 VDD.n437 VDD.n359 0.1445
R1892 VDD.n437 VDD.n357 0.1445
R1893 VDD.n441 VDD.n357 0.1445
R1894 VDD.n441 VDD.n355 0.1445
R1895 VDD.n445 VDD.n355 0.1445
R1896 VDD.n445 VDD.n353 0.1445
R1897 VDD.n449 VDD.n353 0.1445
R1898 VDD.n385 VDD.n309 0.1445
R1899 VDD.n495 VDD.n309 0.1445
R1900 VDD.n495 VDD.n494 0.1445
R1901 VDD.n494 VDD.n493 0.1445
R1902 VDD.n493 VDD.n313 0.1445
R1903 VDD.n489 VDD.n313 0.1445
R1904 VDD.n489 VDD.n488 0.1445
R1905 VDD.n488 VDD.n487 0.1445
R1906 VDD.n487 VDD.n319 0.1445
R1907 VDD.n483 VDD.n319 0.1445
R1908 VDD.n483 VDD.n482 0.1445
R1909 VDD.n482 VDD.n481 0.1445
R1910 VDD.n481 VDD.n325 0.1445
R1911 VDD.n477 VDD.n325 0.1445
R1912 VDD.n477 VDD.n476 0.1445
R1913 VDD.n476 VDD.n475 0.1445
R1914 VDD.n475 VDD.n331 0.1445
R1915 VDD.n471 VDD.n331 0.1445
R1916 VDD.n471 VDD.n470 0.1445
R1917 VDD.n470 VDD.n469 0.1445
R1918 VDD.n469 VDD.n337 0.1445
R1919 VDD.n465 VDD.n337 0.1445
R1920 VDD.n465 VDD.n464 0.1445
R1921 VDD.n464 VDD.n463 0.1445
R1922 VDD.n463 VDD.n343 0.1445
R1923 VDD.n459 VDD.n343 0.1445
R1924 VDD.n459 VDD.n458 0.1445
R1925 VDD.n458 VDD.n457 0.1445
R1926 VDD.n457 VDD.n349 0.1445
R1927 VDD.n453 VDD.n349 0.1445
R1928 VDD.n391 VDD.n390 0.1445
R1929 VDD.n392 VDD.n391 0.1445
R1930 VDD.n392 VDD.n378 0.1445
R1931 VDD.n398 VDD.n378 0.1445
R1932 VDD.n399 VDD.n398 0.1445
R1933 VDD.n400 VDD.n399 0.1445
R1934 VDD.n400 VDD.n374 0.1445
R1935 VDD.n406 VDD.n374 0.1445
R1936 VDD.n407 VDD.n406 0.1445
R1937 VDD.n408 VDD.n407 0.1445
R1938 VDD.n408 VDD.n370 0.1445
R1939 VDD.n414 VDD.n370 0.1445
R1940 VDD.n415 VDD.n414 0.1445
R1941 VDD.n416 VDD.n415 0.1445
R1942 VDD.n416 VDD.n366 0.1445
R1943 VDD.n422 VDD.n366 0.1445
R1944 VDD.n423 VDD.n422 0.1445
R1945 VDD.n424 VDD.n423 0.1445
R1946 VDD.n424 VDD.n362 0.1445
R1947 VDD.n430 VDD.n362 0.1445
R1948 VDD.n431 VDD.n430 0.1445
R1949 VDD.n432 VDD.n431 0.1445
R1950 VDD.n432 VDD.n358 0.1445
R1951 VDD.n438 VDD.n358 0.1445
R1952 VDD.n439 VDD.n438 0.1445
R1953 VDD.n440 VDD.n439 0.1445
R1954 VDD.n440 VDD.n354 0.1445
R1955 VDD.n446 VDD.n354 0.1445
R1956 VDD.n447 VDD.n446 0.1445
R1957 VDD.n448 VDD.n447 0.1445
R1958 VDD.n384 VDD.n307 0.1445
R1959 VDD.n496 VDD.n308 0.1445
R1960 VDD.n492 VDD.n308 0.1445
R1961 VDD.n492 VDD.n491 0.1445
R1962 VDD.n491 VDD.n490 0.1445
R1963 VDD.n490 VDD.n314 0.1445
R1964 VDD.n486 VDD.n314 0.1445
R1965 VDD.n486 VDD.n485 0.1445
R1966 VDD.n485 VDD.n484 0.1445
R1967 VDD.n484 VDD.n320 0.1445
R1968 VDD.n480 VDD.n320 0.1445
R1969 VDD.n480 VDD.n479 0.1445
R1970 VDD.n479 VDD.n478 0.1445
R1971 VDD.n478 VDD.n326 0.1445
R1972 VDD.n474 VDD.n326 0.1445
R1973 VDD.n474 VDD.n473 0.1445
R1974 VDD.n473 VDD.n472 0.1445
R1975 VDD.n472 VDD.n332 0.1445
R1976 VDD.n468 VDD.n332 0.1445
R1977 VDD.n468 VDD.n467 0.1445
R1978 VDD.n467 VDD.n466 0.1445
R1979 VDD.n466 VDD.n338 0.1445
R1980 VDD.n462 VDD.n338 0.1445
R1981 VDD.n462 VDD.n461 0.1445
R1982 VDD.n461 VDD.n460 0.1445
R1983 VDD.n460 VDD.n344 0.1445
R1984 VDD.n456 VDD.n344 0.1445
R1985 VDD.n456 VDD.n455 0.1445
R1986 VDD.n455 VDD.n454 0.1445
R1987 VDD.n129 VDD.n128 0.1445
R1988 VDD.n129 VDD.n125 0.1445
R1989 VDD.n134 VDD.n125 0.1445
R1990 VDD.n135 VDD.n134 0.1445
R1991 VDD.n139 VDD.n135 0.1445
R1992 VDD.n139 VDD.n138 0.1445
R1993 VDD.n138 VDD.n137 0.1445
R1994 VDD.n137 VDD.n113 0.1445
R1995 VDD.n164 VDD.n113 0.1445
R1996 VDD.n165 VDD.n164 0.1445
R1997 VDD.n166 VDD.n165 0.1445
R1998 VDD.n166 VDD.n110 0.1445
R1999 VDD.n170 VDD.n110 0.1445
R2000 VDD.n171 VDD.n170 0.1445
R2001 VDD.n172 VDD.n171 0.1445
R2002 VDD.n172 VDD.n108 0.1445
R2003 VDD.n176 VDD.n108 0.1445
R2004 VDD.n177 VDD.n176 0.1445
R2005 VDD.n178 VDD.n177 0.1445
R2006 VDD.n178 VDD.n105 0.1445
R2007 VDD.n182 VDD.n105 0.1445
R2008 VDD.n183 VDD.n182 0.1445
R2009 VDD.n184 VDD.n183 0.1445
R2010 VDD.n184 VDD.n34 0.1445
R2011 VDD.n304 VDD.n34 0.1445
R2012 VDD.n305 VDD.n304 0.1445
R2013 VDD.n503 VDD.n305 0.1445
R2014 VDD.n235 VDD.n59 0.107278
R2015 VDD.n295 VDD.n42 0.0922644
R2016 VDD.n72 VDD.n60 0.0847125
R2017 VDD.n297 VDD.n296 0.0779226
R2018 VDD.n497 VDD.n496 0.0761
R2019 VDD.n497 VDD.n307 0.0689
R2020 VDD.n294 VDD.n293 0.0572937
R2021 VDD.n238 VDD.n237 0.0572937
R2022 VDD.n293 VDD.n292 0.0552335
R2023 VDD.n239 VDD.n238 0.0552335
R2024 VDD.n296 VDD.n295 0.0430846
R2025 VDD.n60 VDD.n59 0.0367015
R2026 VDD.n295 VDD.n294 0.0277385
R2027 VDD.n237 VDD.n59 0.0277385
R2028 VDD.n250 VDD.n57 0.0203347
R2029 VDD.n251 VDD.n250 0.0203347
R2030 VDD.n252 VDD.n251 0.0203347
R2031 VDD.n257 VDD.n256 0.0203347
R2032 VDD.n258 VDD.n257 0.0203347
R2033 VDD.n262 VDD.n261 0.0203347
R2034 VDD.n262 VDD.n50 0.0203347
R2035 VDD.n269 VDD.n51 0.0203347
R2036 VDD.n51 VDD.n49 0.0203347
R2037 VDD.n275 VDD.n274 0.0203347
R2038 VDD.n275 VDD.n46 0.0203347
R2039 VDD.n282 VDD.n47 0.0203347
R2040 VDD.n47 VDD.n45 0.0203347
R2041 VDD.n287 VDD.n45 0.0203347
R2042 VDD.n292 VDD.n43 0.0186975
R2043 VDD.n239 VDD.n58 0.0186975
R2044 VDD.n256 VDD.n55 0.0183512
R2045 VDD.n283 VDD.n46 0.0183512
R2046 VDD.n225 VDD.n224 0.0167896
R2047 VDD.n147 VDD.n75 0.0167896
R2048 VDD.n153 VDD.n147 0.0167896
R2049 VDD.n153 VDD.n76 0.0167896
R2050 VDD.n219 VDD.n78 0.0167896
R2051 VDD.n215 VDD.n78 0.0167896
R2052 VDD.n212 VDD.n211 0.0167896
R2053 VDD.n211 VDD.n0 0.0167896
R2054 VDD.n528 VDD.n3 0.0167896
R2055 VDD.n524 VDD.n3 0.0167896
R2056 VDD.n199 VDD.n12 0.0167896
R2057 VDD.n199 VDD.n13 0.0167896
R2058 VDD.n519 VDD.n15 0.0167896
R2059 VDD.n515 VDD.n15 0.0167896
R2060 VDD.n515 VDD.n514 0.0167896
R2061 VDD.n298 VDD.n25 0.0167896
R2062 VDD.n224 VDD.n223 0.0151606
R2063 VDD.n220 VDD.n219 0.0151606
R2064 VDD.n520 VDD.n13 0.0151606
R2065 VDD.n513 VDD.n25 0.0151606
R2066 VDD.n72 VDD.n71 0.014448
R2067 VDD.n297 VDD.n26 0.014448
R2068 VDD.n261 VDD.n53 0.0143843
R2069 VDD.n273 VDD.n49 0.0143843
R2070 VDD.n290 VDD.n43 0.0119263
R2071 VDD.n245 VDD.n58 0.0119263
R2072 VDD.n233 VDD.n62 0.0119027
R2073 VDD.n214 VDD.n212 0.0119027
R2074 VDD.n524 VDD.n523 0.0119027
R2075 VDD.n511 VDD.n510 0.0119027
R2076 VDD.n270 VDD.n50 0.0104174
R2077 VDD.n270 VDD.n269 0.0104174
R2078 VDD VDD.n0 0.0086448
R2079 VDD VDD.n528 0.0086448
R2080 VDD.n258 VDD.n53 0.00645041
R2081 VDD.n274 VDD.n273 0.00645041
R2082 VDD.n71 VDD.n62 0.00538688
R2083 VDD.n215 VDD.n214 0.00538688
R2084 VDD.n523 VDD.n12 0.00538688
R2085 VDD.n511 VDD.n26 0.00538688
R2086 VDD.n225 VDD.n72 0.00284163
R2087 VDD.n298 VDD.n297 0.00284163
R2088 VDD.n234 VDD.n233 0.00273982
R2089 VDD.n510 VDD.n27 0.00273982
R2090 VDD.n242 VDD.n57 0.00248347
R2091 VDD.n252 VDD.n55 0.00248347
R2092 VDD.n283 VDD.n282 0.00248347
R2093 VDD.n287 VDD.n286 0.00248347
R2094 VDD.n223 VDD.n75 0.00212896
R2095 VDD.n220 VDD.n76 0.00212896
R2096 VDD.n520 VDD.n519 0.00212896
R2097 VDD.n514 VDD.n513 0.00212896
R2098 VDD.n242 VDD.n58 0.00149173
R2099 VDD.n286 VDD.n43 0.00149173
R2100 VSS.n503 VSS.n502 50500.6
R2101 VSS.n501 VSS.n88 286.904
R2102 VSS.n86 VSS.n84 286.904
R2103 VSS.n501 VSS.n89 286.904
R2104 VSS.n505 VSS.n84 286.904
R2105 VSS.n422 VSS.n159 181.125
R2106 VSS.n422 VSS.n421 181.125
R2107 VSS.n36 VSS.n31 181.125
R2108 VSS.n561 VSS.n31 181.125
R2109 VSS.n502 VSS.n87 121.71
R2110 VSS.n504 VSS.n503 106.02
R2111 VSS.n109 VSS.n87 76.0684
R2112 VSS.n110 VSS.n109 76.0684
R2113 VSS.n112 VSS.n110 76.0684
R2114 VSS.n112 VSS.n97 76.0684
R2115 VSS.n489 VSS.n97 76.0684
R2116 VSS.n560 VSS.n33 76.0684
R2117 VSS.n560 VSS.n35 76.0684
R2118 VSS.n287 VSS.n35 76.0684
R2119 VSS.n287 VSS.n271 76.0684
R2120 VSS.n295 VSS.n271 76.0684
R2121 VSS.n295 VSS.n259 76.0684
R2122 VSS.n307 VSS.n259 76.0684
R2123 VSS.n307 VSS.n252 76.0684
R2124 VSS.n315 VSS.n252 76.0684
R2125 VSS.n315 VSS.n235 76.0684
R2126 VSS.n333 VSS.n235 76.0684
R2127 VSS.n333 VSS.n228 76.0684
R2128 VSS.n341 VSS.n228 76.0684
R2129 VSS.n341 VSS.n219 76.0684
R2130 VSS.n352 VSS.n219 76.0684
R2131 VSS.n352 VSS.n212 76.0684
R2132 VSS.n360 VSS.n212 76.0684
R2133 VSS.n360 VSS.n201 76.0684
R2134 VSS.n373 VSS.n201 76.0684
R2135 VSS.n373 VSS.n194 76.0684
R2136 VSS.n381 VSS.n194 76.0684
R2137 VSS.n381 VSS.n184 76.0684
R2138 VSS.n393 VSS.n184 76.0684
R2139 VSS.n393 VSS.n176 76.0684
R2140 VSS.n406 VSS.n176 76.0684
R2141 VSS.n406 VSS.n163 76.0684
R2142 VSS.n418 VSS.n163 76.0684
R2143 VSS.n420 VSS.n418 76.0684
R2144 VSS.n420 VSS.n158 76.0684
R2145 VSS.n426 VSS.n425 76.0684
R2146 VSS.n427 VSS.n426 76.0684
R2147 VSS.n428 VSS.n427 76.0684
R2148 VSS.n428 VSS.n85 76.0684
R2149 VSS.n504 VSS.n85 76.0684
R2150 VSS.n488 VSS.n33 53.248
R2151 VSS.n423 VSS.n158 53.248
R2152 VSS.n489 VSS.n488 22.8209
R2153 VSS.n425 VSS.n423 22.8209
R2154 VSS.n503 VSS.n84 15.784
R2155 VSS.n278 VSS.n36 15.5561
R2156 VSS.n288 VSS.n278 15.5561
R2157 VSS.n288 VSS.n272 15.5561
R2158 VSS.n294 VSS.n272 15.5561
R2159 VSS.n294 VSS.n257 15.5561
R2160 VSS.n308 VSS.n257 15.5561
R2161 VSS.n308 VSS.n253 15.5561
R2162 VSS.n314 VSS.n253 15.5561
R2163 VSS.n314 VSS.n233 15.5561
R2164 VSS.n334 VSS.n233 15.5561
R2165 VSS.n334 VSS.n229 15.5561
R2166 VSS.n340 VSS.n229 15.5561
R2167 VSS.n340 VSS.n217 15.5561
R2168 VSS.n353 VSS.n217 15.5561
R2169 VSS.n353 VSS.n213 15.5561
R2170 VSS.n359 VSS.n213 15.5561
R2171 VSS.n359 VSS.n199 15.5561
R2172 VSS.n374 VSS.n199 15.5561
R2173 VSS.n374 VSS.n195 15.5561
R2174 VSS.n380 VSS.n195 15.5561
R2175 VSS.n380 VSS.n182 15.5561
R2176 VSS.n394 VSS.n182 15.5561
R2177 VSS.n394 VSS.n177 15.5561
R2178 VSS.n405 VSS.n177 15.5561
R2179 VSS.n405 VSS.n178 15.5561
R2180 VSS.n178 VSS.n160 15.5561
R2181 VSS.n421 VSS.n160 15.5561
R2182 VSS.n561 VSS.n32 15.5561
R2183 VSS.n286 VSS.n32 15.5561
R2184 VSS.n286 VSS.n269 15.5561
R2185 VSS.n296 VSS.n269 15.5561
R2186 VSS.n296 VSS.n260 15.5561
R2187 VSS.n306 VSS.n260 15.5561
R2188 VSS.n306 VSS.n250 15.5561
R2189 VSS.n316 VSS.n250 15.5561
R2190 VSS.n316 VSS.n236 15.5561
R2191 VSS.n332 VSS.n236 15.5561
R2192 VSS.n332 VSS.n226 15.5561
R2193 VSS.n342 VSS.n226 15.5561
R2194 VSS.n342 VSS.n220 15.5561
R2195 VSS.n351 VSS.n220 15.5561
R2196 VSS.n351 VSS.n210 15.5561
R2197 VSS.n361 VSS.n210 15.5561
R2198 VSS.n361 VSS.n202 15.5561
R2199 VSS.n372 VSS.n202 15.5561
R2200 VSS.n372 VSS.n192 15.5561
R2201 VSS.n382 VSS.n192 15.5561
R2202 VSS.n382 VSS.n185 15.5561
R2203 VSS.n392 VSS.n185 15.5561
R2204 VSS.n392 VSS.n174 15.5561
R2205 VSS.n407 VSS.n174 15.5561
R2206 VSS.n407 VSS.n164 15.5561
R2207 VSS.n417 VSS.n164 15.5561
R2208 VSS.n417 VSS.n159 15.5561
R2209 VSS.n108 VSS.n88 15.5561
R2210 VSS.n108 VSS.n104 15.5561
R2211 VSS.n113 VSS.n104 15.5561
R2212 VSS.n113 VSS.n98 15.5561
R2213 VSS.n487 VSS.n98 15.5561
R2214 VSS.n487 VSS.n99 15.5561
R2215 VSS.n99 VSS.n34 15.5561
R2216 VSS.n118 VSS.n34 15.5561
R2217 VSS.n119 VSS.n118 15.5561
R2218 VSS.n270 VSS.n119 15.5561
R2219 VSS.n270 VSS.n122 15.5561
R2220 VSS.n123 VSS.n122 15.5561
R2221 VSS.n124 VSS.n123 15.5561
R2222 VSS.n251 VSS.n124 15.5561
R2223 VSS.n251 VSS.n127 15.5561
R2224 VSS.n128 VSS.n127 15.5561
R2225 VSS.n129 VSS.n128 15.5561
R2226 VSS.n227 VSS.n129 15.5561
R2227 VSS.n227 VSS.n132 15.5561
R2228 VSS.n133 VSS.n132 15.5561
R2229 VSS.n134 VSS.n133 15.5561
R2230 VSS.n211 VSS.n134 15.5561
R2231 VSS.n211 VSS.n137 15.5561
R2232 VSS.n138 VSS.n137 15.5561
R2233 VSS.n139 VSS.n138 15.5561
R2234 VSS.n193 VSS.n139 15.5561
R2235 VSS.n193 VSS.n142 15.5561
R2236 VSS.n143 VSS.n142 15.5561
R2237 VSS.n144 VSS.n143 15.5561
R2238 VSS.n175 VSS.n144 15.5561
R2239 VSS.n175 VSS.n147 15.5561
R2240 VSS.n148 VSS.n147 15.5561
R2241 VSS.n149 VSS.n148 15.5561
R2242 VSS.n419 VSS.n149 15.5561
R2243 VSS.n419 VSS.n152 15.5561
R2244 VSS.n153 VSS.n152 15.5561
R2245 VSS.n154 VSS.n153 15.5561
R2246 VSS.n157 VSS.n154 15.5561
R2247 VSS.n429 VSS.n157 15.5561
R2248 VSS.n430 VSS.n429 15.5561
R2249 VSS.n430 VSS.n86 15.5561
R2250 VSS.n92 VSS.n89 15.5561
R2251 VSS.n93 VSS.n92 15.5561
R2252 VSS.n111 VSS.n93 15.5561
R2253 VSS.n111 VSS.n96 15.5561
R2254 VSS.n490 VSS.n96 15.5561
R2255 VSS.n490 VSS.n37 15.5561
R2256 VSS.n559 VSS.n37 15.5561
R2257 VSS.n559 VSS.n38 15.5561
R2258 VSS.n43 VSS.n38 15.5561
R2259 VSS.n44 VSS.n43 15.5561
R2260 VSS.n45 VSS.n44 15.5561
R2261 VSS.n258 VSS.n45 15.5561
R2262 VSS.n258 VSS.n48 15.5561
R2263 VSS.n49 VSS.n48 15.5561
R2264 VSS.n50 VSS.n49 15.5561
R2265 VSS.n234 VSS.n50 15.5561
R2266 VSS.n234 VSS.n53 15.5561
R2267 VSS.n54 VSS.n53 15.5561
R2268 VSS.n55 VSS.n54 15.5561
R2269 VSS.n218 VSS.n55 15.5561
R2270 VSS.n218 VSS.n58 15.5561
R2271 VSS.n59 VSS.n58 15.5561
R2272 VSS.n60 VSS.n59 15.5561
R2273 VSS.n200 VSS.n60 15.5561
R2274 VSS.n200 VSS.n63 15.5561
R2275 VSS.n64 VSS.n63 15.5561
R2276 VSS.n65 VSS.n64 15.5561
R2277 VSS.n183 VSS.n65 15.5561
R2278 VSS.n183 VSS.n68 15.5561
R2279 VSS.n69 VSS.n68 15.5561
R2280 VSS.n70 VSS.n69 15.5561
R2281 VSS.n162 VSS.n70 15.5561
R2282 VSS.n162 VSS.n73 15.5561
R2283 VSS.n74 VSS.n73 15.5561
R2284 VSS.n75 VSS.n74 15.5561
R2285 VSS.n424 VSS.n75 15.5561
R2286 VSS.n424 VSS.n78 15.5561
R2287 VSS.n79 VSS.n78 15.5561
R2288 VSS.n80 VSS.n79 15.5561
R2289 VSS.n83 VSS.n80 15.5561
R2290 VSS.n505 VSS.n83 15.5561
R2291 VSS.n636 VSS.n4 14.9553
R2292 VSS.n570 VSS.n569 14.9553
R2293 VSS.n284 VSS.n282 14.1851
R2294 VSS.n172 VSS.n171 14.1851
R2295 VSS.n630 VSS.n629 12.5005
R2296 VSS.n8 VSS.n7 12.5005
R2297 VSS.n621 VSS.n11 12.5005
R2298 VSS.n623 VSS.n622 12.5005
R2299 VSS.n618 VSS.n10 12.5005
R2300 VSS.n616 VSS.n615 12.5005
R2301 VSS.n614 VSS.n13 12.5005
R2302 VSS.n604 VSS.n14 12.5005
R2303 VSS.n606 VSS.n17 12.5005
R2304 VSS.n608 VSS.n607 12.5005
R2305 VSS.n602 VSS.n16 12.5005
R2306 VSS.n601 VSS.n600 12.5005
R2307 VSS.n599 VSS.n598 12.5005
R2308 VSS.n597 VSS.n596 12.5005
R2309 VSS.n595 VSS.n21 12.5005
R2310 VSS.n594 VSS.n593 12.5005
R2311 VSS.n590 VSS.n589 12.5005
R2312 VSS.n588 VSS.n23 12.5005
R2313 VSS.n587 VSS.n586 12.5005
R2314 VSS.n583 VSS.n24 12.5005
R2315 VSS.n409 VSS.n169 12.5005
R2316 VSS.n388 VSS.n168 12.5005
R2317 VSS.n390 VSS.n389 12.5005
R2318 VSS.n386 VSS.n187 12.5005
R2319 VSS.n385 VSS.n384 12.5005
R2320 VSS.n369 VSS.n189 12.5005
R2321 VSS.n370 VSS.n368 12.5005
R2322 VSS.n365 VSS.n204 12.5005
R2323 VSS.n364 VSS.n363 12.5005
R2324 VSS.n347 VSS.n207 12.5005
R2325 VSS.n349 VSS.n348 12.5005
R2326 VSS.n346 VSS.n345 12.5005
R2327 VSS.n344 VSS.n223 12.5005
R2328 VSS.n241 VSS.n224 12.5005
R2329 VSS.n330 VSS.n242 12.5005
R2330 VSS.n246 VSS.n238 12.5005
R2331 VSS.n318 VSS.n248 12.5005
R2332 VSS.n302 VSS.n244 12.5005
R2333 VSS.n304 VSS.n303 12.5005
R2334 VSS.n300 VSS.n262 12.5005
R2335 VSS.n299 VSS.n298 12.5005
R2336 VSS.n283 VSS.n264 12.5005
R2337 VSS.n413 VSS.n412 12.1268
R2338 VSS.n265 VSS.n29 12.1268
R2339 Isum VSS.n642 11.9273
R2340 VSS.n583 VSS.n582 9.95036
R2341 VSS.n632 VSS.n630 9.95036
R2342 VSS.n348 VSS.n346 9.86111
R2343 VSS.n607 VSS.n602 9.86111
R2344 VSS.n579 VSS.n578 9.8285
R2345 VSS.n634 VSS.n6 9.8285
R2346 VSS.n242 VSS.n241 9.55788
R2347 VSS.n365 VSS.n364 9.55788
R2348 VSS.n598 VSS.n597 9.55788
R2349 VSS.n604 VSS.n13 9.55788
R2350 VSS.n411 VSS.n410 8.63568
R2351 VSS.n324 VSS.n208 8.63568
R2352 VSS.n329 VSS.n328 8.63568
R2353 VSS.n267 VSS.n266 8.63568
R2354 VSS.n628 VSS.n627 8.63568
R2355 VSS.n613 VSS.n612 8.63568
R2356 VSS.n572 VSS.n20 8.63568
R2357 VSS.n577 VSS.n576 8.63568
R2358 VSS.n322 VSS.n190 8.59884
R2359 VSS.n326 VSS.n222 8.59884
R2360 VSS.n320 VSS.n319 8.59884
R2361 VSS.n625 VSS.n624 8.59884
R2362 VSS.n610 VSS.n609 8.59884
R2363 VSS.n574 VSS.n22 8.59884
R2364 VSS.n299 VSS.n264 8.34496
R2365 VSS.n302 VSS.n248 8.34496
R2366 VSS.n385 VSS.n189 8.34496
R2367 VSS.n388 VSS.n169 8.34496
R2368 VSS.n593 VSS.n590 8.34496
R2369 VSS.n622 VSS.n618 8.34496
R2370 VSS.n500 VSS.n90 7.39502
R2371 VSS.n500 VSS.n499 7.39502
R2372 VSS.n507 VSS.n82 7.30695
R2373 VSS.n431 VSS.n82 7.30695
R2374 VSS.n300 VSS.n299 7.13204
R2375 VSS.n303 VSS.n302 7.13204
R2376 VSS.n386 VSS.n385 7.13204
R2377 VSS.n389 VSS.n388 7.13204
R2378 VSS.n586 VSS.n583 7.13204
R2379 VSS.n590 VSS.n23 7.13204
R2380 VSS.n622 VSS.n621 7.13204
R2381 VSS.n630 VSS.n7 7.13204
R2382 VSS.n400 VSS.n1 6.32942
R2383 VSS.n275 VSS.n28 6.32942
R2384 VSS.n641 VSS.n1 6.30962
R2385 VSS.n564 VSS.n28 6.30962
R2386 VSS.n246 VSS.n242 5.91912
R2387 VSS.n368 VSS.n365 5.91912
R2388 VSS.n597 VSS.n21 5.91912
R2389 VSS.n616 VSS.n13 5.91912
R2390 VSS.n633 VSS.n632 5.8218
R2391 VSS.n582 VSS.n580 5.8218
R2392 VSS.n346 VSS.n223 5.61588
R2393 VSS.n348 VSS.n347 5.61588
R2394 VSS.n602 VSS.n601 5.61588
R2395 VSS.n607 VSS.n606 5.61588
R2396 VSS.n415 VSS.n159 5.2005
R2397 VSS.n420 VSS.n159 5.2005
R2398 VSS.n417 VSS.n416 5.2005
R2399 VSS.n418 VSS.n417 5.2005
R2400 VSS.n165 VSS.n164 5.2005
R2401 VSS.n164 VSS.n163 5.2005
R2402 VSS.n408 VSS.n407 5.2005
R2403 VSS.n407 VSS.n406 5.2005
R2404 VSS.n174 VSS.n173 5.2005
R2405 VSS.n176 VSS.n174 5.2005
R2406 VSS.n392 VSS.n391 5.2005
R2407 VSS.n393 VSS.n392 5.2005
R2408 VSS.n186 VSS.n185 5.2005
R2409 VSS.n185 VSS.n184 5.2005
R2410 VSS.n383 VSS.n382 5.2005
R2411 VSS.n382 VSS.n381 5.2005
R2412 VSS.n192 VSS.n191 5.2005
R2413 VSS.n194 VSS.n192 5.2005
R2414 VSS.n372 VSS.n371 5.2005
R2415 VSS.n373 VSS.n372 5.2005
R2416 VSS.n203 VSS.n202 5.2005
R2417 VSS.n202 VSS.n201 5.2005
R2418 VSS.n362 VSS.n361 5.2005
R2419 VSS.n361 VSS.n360 5.2005
R2420 VSS.n210 VSS.n209 5.2005
R2421 VSS.n212 VSS.n210 5.2005
R2422 VSS.n351 VSS.n350 5.2005
R2423 VSS.n352 VSS.n351 5.2005
R2424 VSS.n221 VSS.n220 5.2005
R2425 VSS.n220 VSS.n219 5.2005
R2426 VSS.n343 VSS.n342 5.2005
R2427 VSS.n342 VSS.n341 5.2005
R2428 VSS.n226 VSS.n225 5.2005
R2429 VSS.n228 VSS.n226 5.2005
R2430 VSS.n332 VSS.n331 5.2005
R2431 VSS.n333 VSS.n332 5.2005
R2432 VSS.n237 VSS.n236 5.2005
R2433 VSS.n236 VSS.n235 5.2005
R2434 VSS.n317 VSS.n316 5.2005
R2435 VSS.n316 VSS.n315 5.2005
R2436 VSS.n250 VSS.n249 5.2005
R2437 VSS.n252 VSS.n250 5.2005
R2438 VSS.n306 VSS.n305 5.2005
R2439 VSS.n307 VSS.n306 5.2005
R2440 VSS.n261 VSS.n260 5.2005
R2441 VSS.n260 VSS.n259 5.2005
R2442 VSS.n297 VSS.n296 5.2005
R2443 VSS.n296 VSS.n295 5.2005
R2444 VSS.n269 VSS.n268 5.2005
R2445 VSS.n271 VSS.n269 5.2005
R2446 VSS.n286 VSS.n285 5.2005
R2447 VSS.n287 VSS.n286 5.2005
R2448 VSS.n32 VSS.n30 5.2005
R2449 VSS.n35 VSS.n32 5.2005
R2450 VSS.n562 VSS.n561 5.2005
R2451 VSS.n561 VSS.n560 5.2005
R2452 VSS.n421 VSS.n161 5.2005
R2453 VSS.n421 VSS.n420 5.2005
R2454 VSS.n402 VSS.n160 5.2005
R2455 VSS.n418 VSS.n160 5.2005
R2456 VSS.n403 VSS.n178 5.2005
R2457 VSS.n178 VSS.n163 5.2005
R2458 VSS.n405 VSS.n404 5.2005
R2459 VSS.n406 VSS.n405 5.2005
R2460 VSS.n179 VSS.n177 5.2005
R2461 VSS.n177 VSS.n176 5.2005
R2462 VSS.n395 VSS.n394 5.2005
R2463 VSS.n394 VSS.n393 5.2005
R2464 VSS.n182 VSS.n181 5.2005
R2465 VSS.n184 VSS.n182 5.2005
R2466 VSS.n380 VSS.n379 5.2005
R2467 VSS.n381 VSS.n380 5.2005
R2468 VSS.n196 VSS.n195 5.2005
R2469 VSS.n195 VSS.n194 5.2005
R2470 VSS.n375 VSS.n374 5.2005
R2471 VSS.n374 VSS.n373 5.2005
R2472 VSS.n199 VSS.n198 5.2005
R2473 VSS.n201 VSS.n199 5.2005
R2474 VSS.n359 VSS.n358 5.2005
R2475 VSS.n360 VSS.n359 5.2005
R2476 VSS.n214 VSS.n213 5.2005
R2477 VSS.n213 VSS.n212 5.2005
R2478 VSS.n354 VSS.n353 5.2005
R2479 VSS.n353 VSS.n352 5.2005
R2480 VSS.n217 VSS.n216 5.2005
R2481 VSS.n219 VSS.n217 5.2005
R2482 VSS.n340 VSS.n339 5.2005
R2483 VSS.n341 VSS.n340 5.2005
R2484 VSS.n230 VSS.n229 5.2005
R2485 VSS.n229 VSS.n228 5.2005
R2486 VSS.n335 VSS.n334 5.2005
R2487 VSS.n334 VSS.n333 5.2005
R2488 VSS.n233 VSS.n232 5.2005
R2489 VSS.n235 VSS.n233 5.2005
R2490 VSS.n314 VSS.n313 5.2005
R2491 VSS.n315 VSS.n314 5.2005
R2492 VSS.n254 VSS.n253 5.2005
R2493 VSS.n253 VSS.n252 5.2005
R2494 VSS.n309 VSS.n308 5.2005
R2495 VSS.n308 VSS.n307 5.2005
R2496 VSS.n257 VSS.n256 5.2005
R2497 VSS.n259 VSS.n257 5.2005
R2498 VSS.n294 VSS.n293 5.2005
R2499 VSS.n295 VSS.n294 5.2005
R2500 VSS.n273 VSS.n272 5.2005
R2501 VSS.n272 VSS.n271 5.2005
R2502 VSS.n289 VSS.n288 5.2005
R2503 VSS.n288 VSS.n287 5.2005
R2504 VSS.n278 VSS.n277 5.2005
R2505 VSS.n278 VSS.n35 5.2005
R2506 VSS.n276 VSS.n36 5.2005
R2507 VSS.n560 VSS.n36 5.2005
R2508 VSS.n105 VSS.n88 5.2005
R2509 VSS.n88 VSS.n87 5.2005
R2510 VSS.n108 VSS.n107 5.2005
R2511 VSS.n109 VSS.n108 5.2005
R2512 VSS.n104 VSS.n103 5.2005
R2513 VSS.n110 VSS.n104 5.2005
R2514 VSS.n114 VSS.n113 5.2005
R2515 VSS.n113 VSS.n112 5.2005
R2516 VSS.n100 VSS.n98 5.2005
R2517 VSS.n98 VSS.n97 5.2005
R2518 VSS.n487 VSS.n486 5.2005
R2519 VSS.n489 VSS.n487 5.2005
R2520 VSS.n101 VSS.n99 5.2005
R2521 VSS.n99 VSS.n33 5.2005
R2522 VSS.n482 VSS.n34 5.2005
R2523 VSS.n560 VSS.n34 5.2005
R2524 VSS.n481 VSS.n118 5.2005
R2525 VSS.n118 VSS.n35 5.2005
R2526 VSS.n480 VSS.n119 5.2005
R2527 VSS.n287 VSS.n119 5.2005
R2528 VSS.n270 VSS.n120 5.2005
R2529 VSS.n271 VSS.n270 5.2005
R2530 VSS.n476 VSS.n122 5.2005
R2531 VSS.n295 VSS.n122 5.2005
R2532 VSS.n475 VSS.n123 5.2005
R2533 VSS.n259 VSS.n123 5.2005
R2534 VSS.n474 VSS.n124 5.2005
R2535 VSS.n307 VSS.n124 5.2005
R2536 VSS.n251 VSS.n125 5.2005
R2537 VSS.n252 VSS.n251 5.2005
R2538 VSS.n470 VSS.n127 5.2005
R2539 VSS.n315 VSS.n127 5.2005
R2540 VSS.n469 VSS.n128 5.2005
R2541 VSS.n235 VSS.n128 5.2005
R2542 VSS.n468 VSS.n129 5.2005
R2543 VSS.n333 VSS.n129 5.2005
R2544 VSS.n227 VSS.n130 5.2005
R2545 VSS.n228 VSS.n227 5.2005
R2546 VSS.n464 VSS.n132 5.2005
R2547 VSS.n341 VSS.n132 5.2005
R2548 VSS.n463 VSS.n133 5.2005
R2549 VSS.n219 VSS.n133 5.2005
R2550 VSS.n462 VSS.n134 5.2005
R2551 VSS.n352 VSS.n134 5.2005
R2552 VSS.n211 VSS.n135 5.2005
R2553 VSS.n212 VSS.n211 5.2005
R2554 VSS.n458 VSS.n137 5.2005
R2555 VSS.n360 VSS.n137 5.2005
R2556 VSS.n457 VSS.n138 5.2005
R2557 VSS.n201 VSS.n138 5.2005
R2558 VSS.n456 VSS.n139 5.2005
R2559 VSS.n373 VSS.n139 5.2005
R2560 VSS.n193 VSS.n140 5.2005
R2561 VSS.n194 VSS.n193 5.2005
R2562 VSS.n452 VSS.n142 5.2005
R2563 VSS.n381 VSS.n142 5.2005
R2564 VSS.n451 VSS.n143 5.2005
R2565 VSS.n184 VSS.n143 5.2005
R2566 VSS.n450 VSS.n144 5.2005
R2567 VSS.n393 VSS.n144 5.2005
R2568 VSS.n175 VSS.n145 5.2005
R2569 VSS.n176 VSS.n175 5.2005
R2570 VSS.n446 VSS.n147 5.2005
R2571 VSS.n406 VSS.n147 5.2005
R2572 VSS.n445 VSS.n148 5.2005
R2573 VSS.n163 VSS.n148 5.2005
R2574 VSS.n444 VSS.n149 5.2005
R2575 VSS.n418 VSS.n149 5.2005
R2576 VSS.n419 VSS.n150 5.2005
R2577 VSS.n420 VSS.n419 5.2005
R2578 VSS.n440 VSS.n152 5.2005
R2579 VSS.n158 VSS.n152 5.2005
R2580 VSS.n439 VSS.n153 5.2005
R2581 VSS.n425 VSS.n153 5.2005
R2582 VSS.n438 VSS.n154 5.2005
R2583 VSS.n426 VSS.n154 5.2005
R2584 VSS.n157 VSS.n155 5.2005
R2585 VSS.n427 VSS.n157 5.2005
R2586 VSS.n434 VSS.n429 5.2005
R2587 VSS.n429 VSS.n428 5.2005
R2588 VSS.n433 VSS.n430 5.2005
R2589 VSS.n430 VSS.n85 5.2005
R2590 VSS.n432 VSS.n86 5.2005
R2591 VSS.n504 VSS.n86 5.2005
R2592 VSS.n506 VSS.n505 5.2005
R2593 VSS.n505 VSS.n504 5.2005
R2594 VSS.n83 VSS.n81 5.2005
R2595 VSS.n85 VSS.n83 5.2005
R2596 VSS.n510 VSS.n80 5.2005
R2597 VSS.n428 VSS.n80 5.2005
R2598 VSS.n511 VSS.n79 5.2005
R2599 VSS.n427 VSS.n79 5.2005
R2600 VSS.n512 VSS.n78 5.2005
R2601 VSS.n426 VSS.n78 5.2005
R2602 VSS.n424 VSS.n76 5.2005
R2603 VSS.n425 VSS.n424 5.2005
R2604 VSS.n516 VSS.n75 5.2005
R2605 VSS.n158 VSS.n75 5.2005
R2606 VSS.n517 VSS.n74 5.2005
R2607 VSS.n420 VSS.n74 5.2005
R2608 VSS.n518 VSS.n73 5.2005
R2609 VSS.n418 VSS.n73 5.2005
R2610 VSS.n162 VSS.n71 5.2005
R2611 VSS.n163 VSS.n162 5.2005
R2612 VSS.n522 VSS.n70 5.2005
R2613 VSS.n406 VSS.n70 5.2005
R2614 VSS.n523 VSS.n69 5.2005
R2615 VSS.n176 VSS.n69 5.2005
R2616 VSS.n524 VSS.n68 5.2005
R2617 VSS.n393 VSS.n68 5.2005
R2618 VSS.n183 VSS.n66 5.2005
R2619 VSS.n184 VSS.n183 5.2005
R2620 VSS.n528 VSS.n65 5.2005
R2621 VSS.n381 VSS.n65 5.2005
R2622 VSS.n529 VSS.n64 5.2005
R2623 VSS.n194 VSS.n64 5.2005
R2624 VSS.n530 VSS.n63 5.2005
R2625 VSS.n373 VSS.n63 5.2005
R2626 VSS.n200 VSS.n61 5.2005
R2627 VSS.n201 VSS.n200 5.2005
R2628 VSS.n534 VSS.n60 5.2005
R2629 VSS.n360 VSS.n60 5.2005
R2630 VSS.n535 VSS.n59 5.2005
R2631 VSS.n212 VSS.n59 5.2005
R2632 VSS.n536 VSS.n58 5.2005
R2633 VSS.n352 VSS.n58 5.2005
R2634 VSS.n218 VSS.n56 5.2005
R2635 VSS.n219 VSS.n218 5.2005
R2636 VSS.n540 VSS.n55 5.2005
R2637 VSS.n341 VSS.n55 5.2005
R2638 VSS.n541 VSS.n54 5.2005
R2639 VSS.n228 VSS.n54 5.2005
R2640 VSS.n542 VSS.n53 5.2005
R2641 VSS.n333 VSS.n53 5.2005
R2642 VSS.n234 VSS.n51 5.2005
R2643 VSS.n235 VSS.n234 5.2005
R2644 VSS.n546 VSS.n50 5.2005
R2645 VSS.n315 VSS.n50 5.2005
R2646 VSS.n547 VSS.n49 5.2005
R2647 VSS.n252 VSS.n49 5.2005
R2648 VSS.n548 VSS.n48 5.2005
R2649 VSS.n307 VSS.n48 5.2005
R2650 VSS.n258 VSS.n46 5.2005
R2651 VSS.n259 VSS.n258 5.2005
R2652 VSS.n552 VSS.n45 5.2005
R2653 VSS.n295 VSS.n45 5.2005
R2654 VSS.n553 VSS.n44 5.2005
R2655 VSS.n271 VSS.n44 5.2005
R2656 VSS.n554 VSS.n43 5.2005
R2657 VSS.n287 VSS.n43 5.2005
R2658 VSS.n40 VSS.n38 5.2005
R2659 VSS.n38 VSS.n35 5.2005
R2660 VSS.n559 VSS.n558 5.2005
R2661 VSS.n560 VSS.n559 5.2005
R2662 VSS.n39 VSS.n37 5.2005
R2663 VSS.n37 VSS.n33 5.2005
R2664 VSS.n491 VSS.n490 5.2005
R2665 VSS.n490 VSS.n489 5.2005
R2666 VSS.n492 VSS.n96 5.2005
R2667 VSS.n97 VSS.n96 5.2005
R2668 VSS.n111 VSS.n94 5.2005
R2669 VSS.n112 VSS.n111 5.2005
R2670 VSS.n496 VSS.n93 5.2005
R2671 VSS.n110 VSS.n93 5.2005
R2672 VSS.n497 VSS.n92 5.2005
R2673 VSS.n109 VSS.n92 5.2005
R2674 VSS.n498 VSS.n89 5.2005
R2675 VSS.n89 VSS.n87 5.2005
R2676 VSS.n241 VSS.n240 5.05435
R2677 VSS.n364 VSS.n206 5.05435
R2678 VSS.n598 VSS.n19 5.05435
R2679 VSS.n605 VSS.n604 5.05435
R2680 VSS.n579 VSS.n571 4.69811
R2681 VSS.n635 VSS.n634 4.69811
R2682 VSS.n277 VSS.n274 4.5005
R2683 VSS.n290 VSS.n289 4.5005
R2684 VSS.n291 VSS.n273 4.5005
R2685 VSS.n293 VSS.n292 4.5005
R2686 VSS.n256 VSS.n255 4.5005
R2687 VSS.n310 VSS.n309 4.5005
R2688 VSS.n311 VSS.n254 4.5005
R2689 VSS.n313 VSS.n312 4.5005
R2690 VSS.n232 VSS.n231 4.5005
R2691 VSS.n336 VSS.n335 4.5005
R2692 VSS.n337 VSS.n230 4.5005
R2693 VSS.n339 VSS.n338 4.5005
R2694 VSS.n216 VSS.n215 4.5005
R2695 VSS.n355 VSS.n354 4.5005
R2696 VSS.n356 VSS.n214 4.5005
R2697 VSS.n358 VSS.n357 4.5005
R2698 VSS.n198 VSS.n197 4.5005
R2699 VSS.n376 VSS.n375 4.5005
R2700 VSS.n377 VSS.n196 4.5005
R2701 VSS.n379 VSS.n378 4.5005
R2702 VSS.n181 VSS.n180 4.5005
R2703 VSS.n396 VSS.n395 4.5005
R2704 VSS.n397 VSS.n179 4.5005
R2705 VSS.n404 VSS.n398 4.5005
R2706 VSS.n403 VSS.n399 4.5005
R2707 VSS.n402 VSS.n401 4.5005
R2708 VSS.n400 VSS.n161 4.5005
R2709 VSS.n276 VSS.n275 4.5005
R2710 VSS.n634 VSS.n633 4.5005
R2711 VSS.n580 VSS.n579 4.5005
R2712 VSS.n279 VSS.n30 4.5005
R2713 VSS.n285 VSS.n284 4.5005
R2714 VSS.n283 VSS.n268 4.5005
R2715 VSS.n298 VSS.n297 4.5005
R2716 VSS.n262 VSS.n261 4.5005
R2717 VSS.n305 VSS.n304 4.5005
R2718 VSS.n249 VSS.n244 4.5005
R2719 VSS.n318 VSS.n317 4.5005
R2720 VSS.n238 VSS.n237 4.5005
R2721 VSS.n331 VSS.n330 4.5005
R2722 VSS.n225 VSS.n224 4.5005
R2723 VSS.n344 VSS.n343 4.5005
R2724 VSS.n345 VSS.n221 4.5005
R2725 VSS.n350 VSS.n349 4.5005
R2726 VSS.n209 VSS.n207 4.5005
R2727 VSS.n363 VSS.n362 4.5005
R2728 VSS.n204 VSS.n203 4.5005
R2729 VSS.n371 VSS.n370 4.5005
R2730 VSS.n369 VSS.n191 4.5005
R2731 VSS.n384 VSS.n383 4.5005
R2732 VSS.n187 VSS.n186 4.5005
R2733 VSS.n391 VSS.n390 4.5005
R2734 VSS.n173 VSS.n168 4.5005
R2735 VSS.n409 VSS.n408 4.5005
R2736 VSS.n172 VSS.n165 4.5005
R2737 VSS.n416 VSS.n414 4.5005
R2738 VSS.n415 VSS.n0 4.5005
R2739 VSS.n563 VSS.n562 4.5005
R2740 VSS.n105 VSS.n90 4.5005
R2741 VSS.n107 VSS.n106 4.5005
R2742 VSS.n103 VSS.n102 4.5005
R2743 VSS.n115 VSS.n114 4.5005
R2744 VSS.n116 VSS.n100 4.5005
R2745 VSS.n486 VSS.n485 4.5005
R2746 VSS.n484 VSS.n101 4.5005
R2747 VSS.n483 VSS.n482 4.5005
R2748 VSS.n481 VSS.n117 4.5005
R2749 VSS.n480 VSS.n479 4.5005
R2750 VSS.n478 VSS.n120 4.5005
R2751 VSS.n477 VSS.n476 4.5005
R2752 VSS.n475 VSS.n121 4.5005
R2753 VSS.n474 VSS.n473 4.5005
R2754 VSS.n472 VSS.n125 4.5005
R2755 VSS.n471 VSS.n470 4.5005
R2756 VSS.n469 VSS.n126 4.5005
R2757 VSS.n468 VSS.n467 4.5005
R2758 VSS.n466 VSS.n130 4.5005
R2759 VSS.n465 VSS.n464 4.5005
R2760 VSS.n463 VSS.n131 4.5005
R2761 VSS.n462 VSS.n461 4.5005
R2762 VSS.n460 VSS.n135 4.5005
R2763 VSS.n459 VSS.n458 4.5005
R2764 VSS.n457 VSS.n136 4.5005
R2765 VSS.n456 VSS.n455 4.5005
R2766 VSS.n454 VSS.n140 4.5005
R2767 VSS.n453 VSS.n452 4.5005
R2768 VSS.n451 VSS.n141 4.5005
R2769 VSS.n450 VSS.n449 4.5005
R2770 VSS.n448 VSS.n145 4.5005
R2771 VSS.n447 VSS.n446 4.5005
R2772 VSS.n445 VSS.n146 4.5005
R2773 VSS.n444 VSS.n443 4.5005
R2774 VSS.n442 VSS.n150 4.5005
R2775 VSS.n441 VSS.n440 4.5005
R2776 VSS.n439 VSS.n151 4.5005
R2777 VSS.n438 VSS.n437 4.5005
R2778 VSS.n436 VSS.n155 4.5005
R2779 VSS.n435 VSS.n434 4.5005
R2780 VSS.n433 VSS.n156 4.5005
R2781 VSS.n432 VSS.n431 4.5005
R2782 VSS.n497 VSS.n91 4.5005
R2783 VSS.n496 VSS.n495 4.5005
R2784 VSS.n494 VSS.n94 4.5005
R2785 VSS.n493 VSS.n492 4.5005
R2786 VSS.n491 VSS.n95 4.5005
R2787 VSS.n41 VSS.n39 4.5005
R2788 VSS.n558 VSS.n557 4.5005
R2789 VSS.n556 VSS.n40 4.5005
R2790 VSS.n555 VSS.n554 4.5005
R2791 VSS.n553 VSS.n42 4.5005
R2792 VSS.n552 VSS.n551 4.5005
R2793 VSS.n550 VSS.n46 4.5005
R2794 VSS.n549 VSS.n548 4.5005
R2795 VSS.n547 VSS.n47 4.5005
R2796 VSS.n546 VSS.n545 4.5005
R2797 VSS.n544 VSS.n51 4.5005
R2798 VSS.n543 VSS.n542 4.5005
R2799 VSS.n541 VSS.n52 4.5005
R2800 VSS.n540 VSS.n539 4.5005
R2801 VSS.n538 VSS.n56 4.5005
R2802 VSS.n537 VSS.n536 4.5005
R2803 VSS.n535 VSS.n57 4.5005
R2804 VSS.n534 VSS.n533 4.5005
R2805 VSS.n532 VSS.n61 4.5005
R2806 VSS.n531 VSS.n530 4.5005
R2807 VSS.n529 VSS.n62 4.5005
R2808 VSS.n528 VSS.n527 4.5005
R2809 VSS.n526 VSS.n66 4.5005
R2810 VSS.n525 VSS.n524 4.5005
R2811 VSS.n523 VSS.n67 4.5005
R2812 VSS.n522 VSS.n521 4.5005
R2813 VSS.n520 VSS.n71 4.5005
R2814 VSS.n519 VSS.n518 4.5005
R2815 VSS.n517 VSS.n72 4.5005
R2816 VSS.n516 VSS.n515 4.5005
R2817 VSS.n514 VSS.n76 4.5005
R2818 VSS.n513 VSS.n512 4.5005
R2819 VSS.n511 VSS.n77 4.5005
R2820 VSS.n510 VSS.n509 4.5005
R2821 VSS.n508 VSS.n81 4.5005
R2822 VSS.n507 VSS.n506 4.5005
R2823 VSS.n499 VSS.n498 4.5005
R2824 VSS.n282 VSS.n264 3.93127
R2825 VSS.n248 VSS.n247 3.93127
R2826 VSS.n367 VSS.n189 3.93127
R2827 VSS.n171 VSS.n169 3.93127
R2828 VSS.n593 VSS.n592 3.93127
R2829 VSS.n618 VSS.n617 3.93127
R2830 VSS.n411 VSS.n167 3.5285
R2831 VSS.n412 VSS.n411 3.5285
R2832 VSS.n323 VSS.n322 3.5285
R2833 VSS.n322 VSS.n167 3.5285
R2834 VSS.n325 VSS.n324 3.5285
R2835 VSS.n324 VSS.n323 3.5285
R2836 VSS.n327 VSS.n326 3.5285
R2837 VSS.n326 VSS.n325 3.5285
R2838 VSS.n328 VSS.n321 3.5285
R2839 VSS.n328 VSS.n327 3.5285
R2840 VSS.n320 VSS.n243 3.5285
R2841 VSS.n321 VSS.n320 3.5285
R2842 VSS.n266 VSS.n265 3.5285
R2843 VSS.n266 VSS.n243 3.5285
R2844 VSS.n627 VSS.n626 3.5285
R2845 VSS.n627 VSS.n6 3.5285
R2846 VSS.n625 VSS.n9 3.5285
R2847 VSS.n626 VSS.n625 3.5285
R2848 VSS.n612 VSS.n611 3.5285
R2849 VSS.n612 VSS.n9 3.5285
R2850 VSS.n610 VSS.n15 3.5285
R2851 VSS.n611 VSS.n610 3.5285
R2852 VSS.n573 VSS.n572 3.5285
R2853 VSS.n572 VSS.n15 3.5285
R2854 VSS.n575 VSS.n574 3.5285
R2855 VSS.n574 VSS.n573 3.5285
R2856 VSS.n578 VSS.n577 3.5285
R2857 VSS.n577 VSS.n575 3.5285
R2858 VSS.n301 VSS.n300 2.80819
R2859 VSS.n303 VSS.n301 2.80819
R2860 VSS.n387 VSS.n386 2.80819
R2861 VSS.n389 VSS.n387 2.80819
R2862 VSS.n586 VSS.n585 2.80819
R2863 VSS.n585 VSS.n23 2.80819
R2864 VSS.n621 VSS.n620 2.80819
R2865 VSS.n620 VSS.n7 2.80819
R2866 VSS.n582 VSS.n581 2.73469
R2867 VSS.n632 VSS.n631 2.73469
R2868 VSS.n568 VSS.n567 2.35281
R2869 VSS.n638 VSS.n637 2.35281
R2870 VSS.n640 VSS.n639 2.27503
R2871 VSS.n566 VSS.n565 2.26755
R2872 VSS.n247 VSS.n246 1.68512
R2873 VSS.n368 VSS.n367 1.68512
R2874 VSS.n592 VSS.n21 1.68512
R2875 VSS.n617 VSS.n616 1.68512
R2876 VSS.n638 VSS.n3 1.66246
R2877 VSS.n567 VSS.n27 1.65213
R2878 VSS.n567 VSS.n566 1.3415
R2879 VSS.n639 VSS.n638 1.3415
R2880 VSS.n282 VSS.n281 0.913
R2881 VSS.n301 VSS.n263 0.913
R2882 VSS.n247 VSS.n245 0.913
R2883 VSS.n240 VSS.n239 0.913
R2884 VSS.n206 VSS.n205 0.913
R2885 VSS.n367 VSS.n366 0.913
R2886 VSS.n387 VSS.n188 0.913
R2887 VSS.n171 VSS.n170 0.913
R2888 VSS.n585 VSS.n584 0.913
R2889 VSS.n592 VSS.n591 0.913
R2890 VSS.n19 VSS.n18 0.913
R2891 VSS.n605 VSS.n603 0.913
R2892 VSS.n617 VSS.n12 0.913
R2893 VSS.n620 VSS.n619 0.913
R2894 VSS.n240 VSS.n223 0.562038
R2895 VSS.n347 VSS.n206 0.562038
R2896 VSS.n601 VSS.n19 0.562038
R2897 VSS.n606 VSS.n605 0.562038
R2898 VSS.n641 VSS.n640 0.462063
R2899 VSS.n565 VSS.n564 0.437113
R2900 VSS.n31 VSS.n28 0.168242
R2901 VSS.n488 VSS.n31 0.168242
R2902 VSS.n422 VSS.n1 0.168242
R2903 VSS.n423 VSS.n422 0.168242
R2904 VSS.n498 VSS.n497 0.1445
R2905 VSS.n497 VSS.n496 0.1445
R2906 VSS.n496 VSS.n94 0.1445
R2907 VSS.n492 VSS.n94 0.1445
R2908 VSS.n492 VSS.n491 0.1445
R2909 VSS.n491 VSS.n39 0.1445
R2910 VSS.n558 VSS.n39 0.1445
R2911 VSS.n558 VSS.n40 0.1445
R2912 VSS.n554 VSS.n40 0.1445
R2913 VSS.n554 VSS.n553 0.1445
R2914 VSS.n553 VSS.n552 0.1445
R2915 VSS.n552 VSS.n46 0.1445
R2916 VSS.n548 VSS.n46 0.1445
R2917 VSS.n548 VSS.n547 0.1445
R2918 VSS.n547 VSS.n546 0.1445
R2919 VSS.n546 VSS.n51 0.1445
R2920 VSS.n542 VSS.n51 0.1445
R2921 VSS.n542 VSS.n541 0.1445
R2922 VSS.n541 VSS.n540 0.1445
R2923 VSS.n540 VSS.n56 0.1445
R2924 VSS.n536 VSS.n56 0.1445
R2925 VSS.n536 VSS.n535 0.1445
R2926 VSS.n535 VSS.n534 0.1445
R2927 VSS.n534 VSS.n61 0.1445
R2928 VSS.n530 VSS.n61 0.1445
R2929 VSS.n530 VSS.n529 0.1445
R2930 VSS.n529 VSS.n528 0.1445
R2931 VSS.n528 VSS.n66 0.1445
R2932 VSS.n524 VSS.n66 0.1445
R2933 VSS.n524 VSS.n523 0.1445
R2934 VSS.n523 VSS.n522 0.1445
R2935 VSS.n522 VSS.n71 0.1445
R2936 VSS.n518 VSS.n71 0.1445
R2937 VSS.n518 VSS.n517 0.1445
R2938 VSS.n517 VSS.n516 0.1445
R2939 VSS.n516 VSS.n76 0.1445
R2940 VSS.n512 VSS.n76 0.1445
R2941 VSS.n512 VSS.n511 0.1445
R2942 VSS.n511 VSS.n510 0.1445
R2943 VSS.n510 VSS.n81 0.1445
R2944 VSS.n506 VSS.n81 0.1445
R2945 VSS.n277 VSS.n276 0.1445
R2946 VSS.n289 VSS.n277 0.1445
R2947 VSS.n289 VSS.n273 0.1445
R2948 VSS.n293 VSS.n273 0.1445
R2949 VSS.n293 VSS.n256 0.1445
R2950 VSS.n309 VSS.n256 0.1445
R2951 VSS.n309 VSS.n254 0.1445
R2952 VSS.n313 VSS.n254 0.1445
R2953 VSS.n313 VSS.n232 0.1445
R2954 VSS.n335 VSS.n232 0.1445
R2955 VSS.n335 VSS.n230 0.1445
R2956 VSS.n339 VSS.n230 0.1445
R2957 VSS.n339 VSS.n216 0.1445
R2958 VSS.n354 VSS.n216 0.1445
R2959 VSS.n354 VSS.n214 0.1445
R2960 VSS.n358 VSS.n214 0.1445
R2961 VSS.n358 VSS.n198 0.1445
R2962 VSS.n375 VSS.n198 0.1445
R2963 VSS.n375 VSS.n196 0.1445
R2964 VSS.n379 VSS.n196 0.1445
R2965 VSS.n379 VSS.n181 0.1445
R2966 VSS.n395 VSS.n181 0.1445
R2967 VSS.n395 VSS.n179 0.1445
R2968 VSS.n404 VSS.n179 0.1445
R2969 VSS.n404 VSS.n403 0.1445
R2970 VSS.n403 VSS.n402 0.1445
R2971 VSS.n402 VSS.n161 0.1445
R2972 VSS.n275 VSS.n274 0.1445
R2973 VSS.n290 VSS.n274 0.1445
R2974 VSS.n291 VSS.n290 0.1445
R2975 VSS.n292 VSS.n291 0.1445
R2976 VSS.n292 VSS.n255 0.1445
R2977 VSS.n310 VSS.n255 0.1445
R2978 VSS.n311 VSS.n310 0.1445
R2979 VSS.n312 VSS.n311 0.1445
R2980 VSS.n312 VSS.n231 0.1445
R2981 VSS.n336 VSS.n231 0.1445
R2982 VSS.n337 VSS.n336 0.1445
R2983 VSS.n338 VSS.n337 0.1445
R2984 VSS.n338 VSS.n215 0.1445
R2985 VSS.n355 VSS.n215 0.1445
R2986 VSS.n356 VSS.n355 0.1445
R2987 VSS.n357 VSS.n356 0.1445
R2988 VSS.n357 VSS.n197 0.1445
R2989 VSS.n376 VSS.n197 0.1445
R2990 VSS.n377 VSS.n376 0.1445
R2991 VSS.n378 VSS.n377 0.1445
R2992 VSS.n378 VSS.n180 0.1445
R2993 VSS.n396 VSS.n180 0.1445
R2994 VSS.n397 VSS.n396 0.1445
R2995 VSS.n398 VSS.n397 0.1445
R2996 VSS.n399 VSS.n398 0.1445
R2997 VSS.n401 VSS.n399 0.1445
R2998 VSS.n401 VSS.n400 0.1445
R2999 VSS.n562 VSS.n30 0.1445
R3000 VSS.n285 VSS.n30 0.1445
R3001 VSS.n285 VSS.n268 0.1445
R3002 VSS.n297 VSS.n268 0.1445
R3003 VSS.n297 VSS.n261 0.1445
R3004 VSS.n305 VSS.n261 0.1445
R3005 VSS.n305 VSS.n249 0.1445
R3006 VSS.n317 VSS.n249 0.1445
R3007 VSS.n317 VSS.n237 0.1445
R3008 VSS.n331 VSS.n237 0.1445
R3009 VSS.n331 VSS.n225 0.1445
R3010 VSS.n343 VSS.n225 0.1445
R3011 VSS.n343 VSS.n221 0.1445
R3012 VSS.n350 VSS.n221 0.1445
R3013 VSS.n350 VSS.n209 0.1445
R3014 VSS.n362 VSS.n209 0.1445
R3015 VSS.n362 VSS.n203 0.1445
R3016 VSS.n371 VSS.n203 0.1445
R3017 VSS.n371 VSS.n191 0.1445
R3018 VSS.n383 VSS.n191 0.1445
R3019 VSS.n383 VSS.n186 0.1445
R3020 VSS.n391 VSS.n186 0.1445
R3021 VSS.n391 VSS.n173 0.1445
R3022 VSS.n408 VSS.n173 0.1445
R3023 VSS.n408 VSS.n165 0.1445
R3024 VSS.n416 VSS.n165 0.1445
R3025 VSS.n416 VSS.n415 0.1445
R3026 VSS.n107 VSS.n105 0.1445
R3027 VSS.n107 VSS.n103 0.1445
R3028 VSS.n114 VSS.n103 0.1445
R3029 VSS.n114 VSS.n100 0.1445
R3030 VSS.n486 VSS.n100 0.1445
R3031 VSS.n486 VSS.n101 0.1445
R3032 VSS.n482 VSS.n101 0.1445
R3033 VSS.n482 VSS.n481 0.1445
R3034 VSS.n481 VSS.n480 0.1445
R3035 VSS.n480 VSS.n120 0.1445
R3036 VSS.n476 VSS.n120 0.1445
R3037 VSS.n476 VSS.n475 0.1445
R3038 VSS.n475 VSS.n474 0.1445
R3039 VSS.n474 VSS.n125 0.1445
R3040 VSS.n470 VSS.n125 0.1445
R3041 VSS.n470 VSS.n469 0.1445
R3042 VSS.n469 VSS.n468 0.1445
R3043 VSS.n468 VSS.n130 0.1445
R3044 VSS.n464 VSS.n130 0.1445
R3045 VSS.n464 VSS.n463 0.1445
R3046 VSS.n463 VSS.n462 0.1445
R3047 VSS.n462 VSS.n135 0.1445
R3048 VSS.n458 VSS.n135 0.1445
R3049 VSS.n458 VSS.n457 0.1445
R3050 VSS.n457 VSS.n456 0.1445
R3051 VSS.n456 VSS.n140 0.1445
R3052 VSS.n452 VSS.n140 0.1445
R3053 VSS.n452 VSS.n451 0.1445
R3054 VSS.n451 VSS.n450 0.1445
R3055 VSS.n450 VSS.n145 0.1445
R3056 VSS.n446 VSS.n145 0.1445
R3057 VSS.n446 VSS.n445 0.1445
R3058 VSS.n445 VSS.n444 0.1445
R3059 VSS.n444 VSS.n150 0.1445
R3060 VSS.n440 VSS.n150 0.1445
R3061 VSS.n440 VSS.n439 0.1445
R3062 VSS.n439 VSS.n438 0.1445
R3063 VSS.n438 VSS.n155 0.1445
R3064 VSS.n434 VSS.n155 0.1445
R3065 VSS.n434 VSS.n433 0.1445
R3066 VSS.n433 VSS.n432 0.1445
R3067 VSS.n106 VSS.n90 0.1445
R3068 VSS.n106 VSS.n102 0.1445
R3069 VSS.n115 VSS.n102 0.1445
R3070 VSS.n116 VSS.n115 0.1445
R3071 VSS.n485 VSS.n116 0.1445
R3072 VSS.n485 VSS.n484 0.1445
R3073 VSS.n484 VSS.n483 0.1445
R3074 VSS.n483 VSS.n117 0.1445
R3075 VSS.n479 VSS.n117 0.1445
R3076 VSS.n479 VSS.n478 0.1445
R3077 VSS.n478 VSS.n477 0.1445
R3078 VSS.n477 VSS.n121 0.1445
R3079 VSS.n473 VSS.n121 0.1445
R3080 VSS.n473 VSS.n472 0.1445
R3081 VSS.n472 VSS.n471 0.1445
R3082 VSS.n471 VSS.n126 0.1445
R3083 VSS.n467 VSS.n126 0.1445
R3084 VSS.n467 VSS.n466 0.1445
R3085 VSS.n466 VSS.n465 0.1445
R3086 VSS.n465 VSS.n131 0.1445
R3087 VSS.n461 VSS.n131 0.1445
R3088 VSS.n461 VSS.n460 0.1445
R3089 VSS.n460 VSS.n459 0.1445
R3090 VSS.n459 VSS.n136 0.1445
R3091 VSS.n455 VSS.n136 0.1445
R3092 VSS.n455 VSS.n454 0.1445
R3093 VSS.n454 VSS.n453 0.1445
R3094 VSS.n453 VSS.n141 0.1445
R3095 VSS.n449 VSS.n141 0.1445
R3096 VSS.n449 VSS.n448 0.1445
R3097 VSS.n448 VSS.n447 0.1445
R3098 VSS.n447 VSS.n146 0.1445
R3099 VSS.n443 VSS.n146 0.1445
R3100 VSS.n443 VSS.n442 0.1445
R3101 VSS.n442 VSS.n441 0.1445
R3102 VSS.n441 VSS.n151 0.1445
R3103 VSS.n437 VSS.n151 0.1445
R3104 VSS.n437 VSS.n436 0.1445
R3105 VSS.n436 VSS.n435 0.1445
R3106 VSS.n435 VSS.n156 0.1445
R3107 VSS.n431 VSS.n156 0.1445
R3108 VSS.n499 VSS.n91 0.1445
R3109 VSS.n495 VSS.n91 0.1445
R3110 VSS.n495 VSS.n494 0.1445
R3111 VSS.n494 VSS.n493 0.1445
R3112 VSS.n493 VSS.n95 0.1445
R3113 VSS.n95 VSS.n41 0.1445
R3114 VSS.n557 VSS.n41 0.1445
R3115 VSS.n557 VSS.n556 0.1445
R3116 VSS.n556 VSS.n555 0.1445
R3117 VSS.n555 VSS.n42 0.1445
R3118 VSS.n551 VSS.n42 0.1445
R3119 VSS.n551 VSS.n550 0.1445
R3120 VSS.n550 VSS.n549 0.1445
R3121 VSS.n549 VSS.n47 0.1445
R3122 VSS.n545 VSS.n47 0.1445
R3123 VSS.n545 VSS.n544 0.1445
R3124 VSS.n544 VSS.n543 0.1445
R3125 VSS.n543 VSS.n52 0.1445
R3126 VSS.n539 VSS.n52 0.1445
R3127 VSS.n539 VSS.n538 0.1445
R3128 VSS.n537 VSS.n57 0.1445
R3129 VSS.n533 VSS.n57 0.1445
R3130 VSS.n533 VSS.n532 0.1445
R3131 VSS.n532 VSS.n531 0.1445
R3132 VSS.n531 VSS.n62 0.1445
R3133 VSS.n527 VSS.n62 0.1445
R3134 VSS.n527 VSS.n526 0.1445
R3135 VSS.n526 VSS.n525 0.1445
R3136 VSS.n525 VSS.n67 0.1445
R3137 VSS.n521 VSS.n67 0.1445
R3138 VSS.n521 VSS.n520 0.1445
R3139 VSS.n520 VSS.n519 0.1445
R3140 VSS.n519 VSS.n72 0.1445
R3141 VSS.n515 VSS.n72 0.1445
R3142 VSS.n515 VSS.n514 0.1445
R3143 VSS.n514 VSS.n513 0.1445
R3144 VSS.n513 VSS.n77 0.1445
R3145 VSS.n509 VSS.n77 0.1445
R3146 VSS.n509 VSS.n508 0.1445
R3147 VSS.n508 VSS.n507 0.1445
R3148 VSS.n565 VSS.n26 0.107278
R3149 VSS.n84 VSS.n82 0.0950455
R3150 VSS.n501 VSS.n500 0.0950455
R3151 VSS.n502 VSS.n501 0.0950455
R3152 VSS.n640 VSS.n2 0.0922644
R3153 VSS.n280 VSS.n27 0.0847125
R3154 VSS.n166 VSS.n3 0.0779226
R3155 VSS.n538 VSS 0.0725
R3156 VSS VSS.n537 0.0725
R3157 VSS.n637 VSS.n636 0.0572937
R3158 VSS.n570 VSS.n568 0.0572937
R3159 VSS.n636 VSS.n635 0.0552335
R3160 VSS.n571 VSS.n570 0.0552335
R3161 VSS.n3 VSS.n2 0.0430846
R3162 VSS.n27 VSS.n26 0.0367015
R3163 VSS.n637 VSS.n2 0.0277385
R3164 VSS.n568 VSS.n26 0.0277385
R3165 VSS.n587 VSS.n24 0.0203347
R3166 VSS.n588 VSS.n587 0.0203347
R3167 VSS.n589 VSS.n588 0.0203347
R3168 VSS.n595 VSS.n594 0.0203347
R3169 VSS.n596 VSS.n595 0.0203347
R3170 VSS.n600 VSS.n599 0.0203347
R3171 VSS.n600 VSS.n16 0.0203347
R3172 VSS.n608 VSS.n17 0.0203347
R3173 VSS.n17 VSS.n14 0.0203347
R3174 VSS.n615 VSS.n614 0.0203347
R3175 VSS.n615 VSS.n10 0.0203347
R3176 VSS.n623 VSS.n11 0.0203347
R3177 VSS.n11 VSS.n8 0.0203347
R3178 VSS.n629 VSS.n8 0.0203347
R3179 VSS.n635 VSS.n5 0.0186975
R3180 VSS.n571 VSS.n25 0.0186975
R3181 VSS.n594 VSS.n22 0.0183512
R3182 VSS.n624 VSS.n10 0.0183512
R3183 VSS.n284 VSS.n283 0.0167896
R3184 VSS.n298 VSS.n262 0.0167896
R3185 VSS.n304 VSS.n262 0.0167896
R3186 VSS.n304 VSS.n244 0.0167896
R3187 VSS.n318 VSS.n238 0.0167896
R3188 VSS.n330 VSS.n238 0.0167896
R3189 VSS.n344 VSS.n224 0.0167896
R3190 VSS.n345 VSS.n344 0.0167896
R3191 VSS.n349 VSS.n207 0.0167896
R3192 VSS.n363 VSS.n207 0.0167896
R3193 VSS.n370 VSS.n204 0.0167896
R3194 VSS.n370 VSS.n369 0.0167896
R3195 VSS.n384 VSS.n187 0.0167896
R3196 VSS.n390 VSS.n187 0.0167896
R3197 VSS.n390 VSS.n168 0.0167896
R3198 VSS.n409 VSS.n172 0.0167896
R3199 VSS.n283 VSS.n267 0.0151606
R3200 VSS.n319 VSS.n318 0.0151606
R3201 VSS.n369 VSS.n190 0.0151606
R3202 VSS.n410 VSS.n409 0.0151606
R3203 VSS.n280 VSS.n279 0.014448
R3204 VSS.n414 VSS.n166 0.014448
R3205 VSS.n599 VSS.n20 0.0143843
R3206 VSS.n613 VSS.n14 0.0143843
R3207 VSS.n633 VSS.n5 0.0119263
R3208 VSS.n580 VSS.n25 0.0119263
R3209 VSS.n563 VSS.n29 0.0119027
R3210 VSS.n329 VSS.n224 0.0119027
R3211 VSS.n363 VSS.n208 0.0119027
R3212 VSS.n413 VSS.n0 0.0119027
R3213 VSS.n609 VSS.n16 0.0104174
R3214 VSS.n609 VSS.n608 0.0104174
R3215 VSS.n345 VSS.n222 0.0086448
R3216 VSS.n349 VSS.n222 0.0086448
R3217 VSS.n596 VSS.n20 0.00645041
R3218 VSS.n614 VSS.n613 0.00645041
R3219 VSS.n279 VSS.n29 0.00538688
R3220 VSS.n330 VSS.n329 0.00538688
R3221 VSS.n208 VSS.n204 0.00538688
R3222 VSS.n414 VSS.n413 0.00538688
R3223 VSS.n284 VSS.n280 0.00284163
R3224 VSS.n172 VSS.n166 0.00284163
R3225 VSS.n564 VSS.n563 0.00273982
R3226 VSS.n576 VSS.n24 0.00248347
R3227 VSS.n589 VSS.n22 0.00248347
R3228 VSS.n624 VSS.n623 0.00248347
R3229 VSS.n629 VSS.n628 0.00248347
R3230 VSS.n642 VSS.n641 0.00233258
R3231 VSS.n298 VSS.n267 0.00212896
R3232 VSS.n319 VSS.n244 0.00212896
R3233 VSS.n384 VSS.n190 0.00212896
R3234 VSS.n410 VSS.n168 0.00212896
R3235 VSS.n576 VSS.n25 0.00149173
R3236 VSS.n628 VSS.n5 0.00149173
R3237 VSS.n642 VSS.n0 0.00090724
C0 Vthr a_n100_5015# 0.86816f
C1 Vthr Isum 1.43519f
C2 VDD VT 2.79531f
C3 a_n100_5015# Isyn 2.88246f
C4 Isum a_n100_5015# 4.29127f
C5 Vthr VDD 1.41927f
C6 a_n100_5015# VT 0.94096f
C7 VDD Isyn 1.16705f
C8 VDD a_n100_5015# 3.85397f
C9 VDD Isum 12.072f
C10 Vthr VSS 5.1368f
C11 Isyn VSS 5.44138f
C12 VT VSS 4.87087f
C13 Isum VSS 24.43127f
C14 VDD VSS 90.93834f
C15 a_n100_5015# VSS 18.1232f
C16 VDD.t51 VSS 10.3312f
C17 Isum.n348 VSS 6.3728f
C18 Isum.n430 VSS 0.77324f
C19 Isum.n431 VSS 1.15758f
C20 VT.t0 VSS 5.14219f
C21 Isyn.t0 VSS 1.37775f
C22 Vthr.t0 VSS 5.01007f
.ends
