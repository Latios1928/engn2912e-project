* NGSPICE file created from DPI_flat.ext - technology: gf180mcuD

.subckt DPI_flat Vthr Isum Isyn VT VSS VDD
X0 Isum.t7 Isum.t5 Isum.t7 Isum.t6 nfet_03v3 ad=0.14p pd=1.06u as=0 ps=0 w=0.5u l=0.64u
X1 Isum.t22 Isum.t20 Isum.t22 Isum.t21 nfet_03v3 ad=0.14p pd=1.06u as=0 ps=0 w=0.5u l=0.64u
X2 Isum.t33 Isum.t32 Isum.t33 Isum.t3 nfet_03v3 ad=0.3p pd=2.2u as=0 ps=0 w=0.5u l=0.64u
X3 VDD.t23 VDD.t21 VDD.t23 VDD.t22 pfet_03v3 ad=0.14p pd=1.06u as=0 ps=0 w=0.5u l=0.64u
X4 VDD.t40 VDD.t39 VDD.t40 VDD.t13 pfet_03v3 ad=0.14p pd=1.06u as=0 ps=0 w=0.5u l=0.64u
X5 VDD.t48 VDD.t47 VDD.t48 VDD.t25 pfet_03v3 ad=0.14p pd=1.06u as=0 ps=0 w=0.5u l=0.64u
X6 Isum.t28 Isum.t26 Isum.t28 Isum.t27 nfet_03v3 ad=0.3p pd=2.2u as=0 ps=0 w=0.5u l=0.64u
X7 a_n90_4665# a_n90_4665# Isum.t49 Isum.t48 nfet_03v3 ad=0.3p pd=2.2u as=0.3p ps=2.2u w=0.5u l=0.64u
X8 VDD.t8 VDD.t6 VDD.t8 VDD.t7 pfet_03v3 ad=0.14p pd=1.06u as=0 ps=0 w=0.5u l=0.64u
X9 VDD.t2 VT a_n90_4665# VDD.t1 pfet_03v3 ad=0.3p pd=2.2u as=0.3p ps=2.2u w=0.5u l=0.64u
X10 VDD.t34 VDD.t33 VDD.t34 VDD.t4 pfet_03v3 ad=0.3p pd=2.2u as=0 ps=0 w=0.5u l=0.64u
X11 VDD.t32 VDD.t30 VDD.t32 VDD.t31 pfet_03v3 ad=0.3p pd=2.2u as=0 ps=0 w=0.5u l=0.64u
X12 Isum.t43 Isum.t42 Isum.t43 Isum.t18 nfet_03v3 ad=0.14p pd=1.06u as=0 ps=0 w=0.5u l=0.64u
X13 Isum.t13 Isum.t11 Isum.t13 Isum.t12 nfet_03v3 ad=0.14p pd=1.06u as=0 ps=0 w=0.5u l=0.64u
X14 Isum.t19 Isum.t17 Isum.t19 Isum.t18 nfet_03v3 ad=0.14p pd=1.06u as=0 ps=0 w=0.5u l=0.64u
X15 Isum.t45 Isum.t44 Isum.t45 Isum.t21 nfet_03v3 ad=0.14p pd=1.06u as=0 ps=0 w=0.5u l=0.64u
X16 VDD.t29 VDD.t27 VDD.t29 VDD.t28 pfet_03v3 ad=0.3p pd=2.2u as=0 ps=0 w=0.5u l=0.64u
X17 VDD.t38 VDD.t37 VDD.t38 VDD.t10 pfet_03v3 ad=0.14p pd=1.06u as=0 ps=0 w=0.5u l=0.64u
X18 Isum.t25 Isum.t23 Isum.t25 Isum.t24 nfet_03v3 ad=0.14p pd=1.06u as=0 ps=0 w=0.5u l=0.64u
X19 VDD.t14 VDD.t12 VDD.t14 VDD.t13 pfet_03v3 ad=0.14p pd=1.06u as=0 ps=0 w=0.5u l=0.64u
X20 VDD.t26 VDD.t24 VDD.t26 VDD.t25 pfet_03v3 ad=0.14p pd=1.06u as=0 ps=0 w=0.5u l=0.64u
X21 VDD.t50 a_n90_4665# Isyn VDD.t49 pfet_03v3 ad=0.3p pd=2.2u as=0.3p ps=2.2u w=0.5u l=0.64u
X22 VDD.t42 VDD.t41 VDD.t42 VDD.t16 pfet_03v3 ad=0.14p pd=1.06u as=0 ps=0 w=0.5u l=0.64u
X23 Isum.t31 Isum.t29 Isum.t31 Isum.t30 nfet_03v3 ad=0.3p pd=2.2u as=0 ps=0 w=0.5u l=0.64u
X24 VDD.t5 VDD.t3 VDD.t5 VDD.t4 pfet_03v3 ad=0.3p pd=2.2u as=0 ps=0 w=0.5u l=0.64u
X25 VDD.t44 VDD.t43 VDD.t44 VDD.t19 pfet_03v3 ad=0.14p pd=1.06u as=0 ps=0 w=0.5u l=0.64u
X26 VDD.t0 Vthr Isum.t1 Isum.t0 nfet_03v3 ad=0.3p pd=2.2u as=0.3p ps=2.2u w=0.5u l=0.64u
X27 Isum.t37 Isum.t36 Isum.t37 Isum.t9 nfet_03v3 ad=0.14p pd=1.06u as=0 ps=0 w=0.5u l=0.64u
X28 Isum.t47 Isum.t46 Isum.t47 Isum.t24 nfet_03v3 ad=0.14p pd=1.06u as=0 ps=0 w=0.5u l=0.64u
X29 VDD.t11 VDD.t9 VDD.t11 VDD.t10 pfet_03v3 ad=0.14p pd=1.06u as=0 ps=0 w=0.5u l=0.64u
X30 VDD.t17 VDD.t15 VDD.t17 VDD.t16 pfet_03v3 ad=0.14p pd=1.06u as=0 ps=0 w=0.5u l=0.64u
X31 Isum.t35 Isum.t34 Isum.t35 Isum.t6 nfet_03v3 ad=0.14p pd=1.06u as=0 ps=0 w=0.5u l=0.64u
X32 Isum.t4 Isum.t2 Isum.t4 Isum.t3 nfet_03v3 ad=0.3p pd=2.2u as=0 ps=0 w=0.5u l=0.64u
X33 VDD.t20 VDD.t18 VDD.t20 VDD.t19 pfet_03v3 ad=0.14p pd=1.06u as=0 ps=0 w=0.5u l=0.64u
X34 VDD.t46 VDD.t45 VDD.t46 VDD.t22 pfet_03v3 ad=0.14p pd=1.06u as=0 ps=0 w=0.5u l=0.64u
X35 Isum.t39 Isum.t38 Isum.t39 Isum.t12 nfet_03v3 ad=0.14p pd=1.06u as=0 ps=0 w=0.5u l=0.64u
X36 VDD.t51 a_n90_4665# cap_mim_2f0_m4m5_noshield c_width=22.18u c_length=22.18u
X37 VDD.t36 VDD.t35 VDD.t36 VDD.t7 pfet_03v3 ad=0.14p pd=1.06u as=0 ps=0 w=0.5u l=0.64u
X38 Isum.t10 Isum.t8 Isum.t10 Isum.t9 nfet_03v3 ad=0.14p pd=1.06u as=0 ps=0 w=0.5u l=0.64u
X39 Isum.t16 Isum.t14 Isum.t16 Isum.t15 nfet_03v3 ad=0.14p pd=1.06u as=0 ps=0 w=0.5u l=0.64u
X40 Isum.t41 Isum.t40 Isum.t41 Isum.t15 nfet_03v3 ad=0.14p pd=1.06u as=0 ps=0 w=0.5u l=0.64u
R0 Isum.n349 Isum.n348 12079
R1 Isum.n208 Isum.n66 961.513
R2 Isum.n348 Isum.n347 869.037
R3 Isum.n197 Isum.n180 255.987
R4 Isum.n351 Isum.n61 255.987
R5 Isum.n62 Isum.n61 255.987
R6 Isum.n198 Isum.n197 255.987
R7 Isum.n248 Isum.n247 142.431
R8 Isum.n366 Isum.n38 142.431
R9 Isum.n247 Isum.n165 142.431
R10 Isum.n40 Isum.n38 142.431
R11 Isum.n350 Isum.n349 132.416
R12 Isum.n347 Isum.n66 92.4769
R13 Isum.n358 Isum.n51 84.7463
R14 Isum.n358 Isum.n357 84.7463
R15 Isum.n357 Isum.n356 84.7463
R16 Isum.n356 Isum.n55 84.7463
R17 Isum.n350 Isum.n55 84.7463
R18 Isum.n364 Isum.n42 76.2717
R19 Isum.n346 Isum.n68 42.3734
R20 Isum.n216 Isum.n68 42.3734
R21 Isum.n340 Isum.n339 42.3734
R22 Isum.n339 Isum.n79 42.3734
R23 Isum.n237 Isum.n236 42.3734
R24 Isum.n236 Isum.n169 42.3734
R25 Isum.n310 Isum.n309 42.3734
R26 Isum.n386 Isum.n6 42.3734
R27 Isum.n386 Isum.n7 42.3734
R28 Isum.n100 Isum.n99 42.3734
R29 Isum.n379 Isum.n18 42.3734
R30 Isum.n109 Isum.n18 42.3734
R31 Isum.n140 Isum.n106 42.3734
R32 Isum.n149 Isum.n106 42.3734
R33 Isum.n365 Isum.n39 42.3734
R34 Isum.n365 Isum.n364 42.3734
R35 Isum.n310 Isum.t48 39.1954
R36 Isum.n100 Isum.t0 39.1954
R37 Isum.n216 Isum.t30 30.7208
R38 Isum.t27 Isum.n39 30.7208
R39 Isum.n34 Isum.t49 26.3413
R40 Isum.n34 Isum.t1 25.7761
R41 Isum.n256 Isum.t29 24.363
R42 Isum.n288 Isum.t26 24.363
R43 Isum.n347 Isum.n346 23.3056
R44 Isum.n215 Isum.t24 21.1869
R45 Isum.n340 Isum.t24 21.1869
R46 Isum.t21 Isum.n79 21.1869
R47 Isum.n237 Isum.t21 21.1869
R48 Isum.t18 Isum.n169 21.1869
R49 Isum.n227 Isum.t18 21.1869
R50 Isum.n309 Isum.t15 21.1869
R51 Isum.t15 Isum.n6 21.1869
R52 Isum.t12 Isum.n7 21.1869
R53 Isum.n99 Isum.t12 21.1869
R54 Isum.n380 Isum.t9 21.1869
R55 Isum.t9 Isum.n379 21.1869
R56 Isum.t6 Isum.n109 21.1869
R57 Isum.n140 Isum.t6 21.1869
R58 Isum.t3 Isum.n149 21.1869
R59 Isum.n150 Isum.t3 21.1869
R60 Isum.n349 Isum.n61 20.2383
R61 Isum.n192 Isum.n191 15.5561
R62 Isum.n188 Isum.n187 15.5561
R63 Isum.n345 Isum.n69 15.5561
R64 Isum.n345 Isum.n70 15.5561
R65 Isum.n341 Isum.n70 15.5561
R66 Isum.n341 Isum.n76 15.5561
R67 Isum.n235 Isum.n76 15.5561
R68 Isum.n235 Isum.n228 15.5561
R69 Isum.n228 Isum.n8 15.5561
R70 Isum.n385 Isum.n8 15.5561
R71 Isum.n385 Isum.n9 15.5561
R72 Isum.n381 Isum.n9 15.5561
R73 Isum.n381 Isum.n15 15.5561
R74 Isum.n141 Isum.n15 15.5561
R75 Isum.n148 Isum.n141 15.5561
R76 Isum.n148 Isum.n43 15.5561
R77 Isum.n363 Isum.n43 15.5561
R78 Isum.n363 Isum.n44 15.5561
R79 Isum.n359 Isum.n44 15.5561
R80 Isum.n359 Isum.n50 15.5561
R81 Isum.n355 Isum.n50 15.5561
R82 Isum.n355 Isum.n56 15.5561
R83 Isum.n351 Isum.n56 15.5561
R84 Isum.n200 Isum.n177 15.5561
R85 Isum.n206 Isum.n175 15.5561
R86 Isum.n210 Isum.n67 15.5561
R87 Isum.n217 Isum.n67 15.5561
R88 Isum.n217 Isum.n77 15.5561
R89 Isum.n220 Isum.n77 15.5561
R90 Isum.n220 Isum.n168 15.5561
R91 Isum.n226 Isum.n168 15.5561
R92 Isum.n226 Isum.n4 15.5561
R93 Isum.n387 Isum.n4 15.5561
R94 Isum.n387 Isum.n5 15.5561
R95 Isum.n16 Isum.n5 15.5561
R96 Isum.n110 Isum.n16 15.5561
R97 Isum.n139 Isum.n110 15.5561
R98 Isum.n139 Isum.n107 15.5561
R99 Isum.n135 Isum.n107 15.5561
R100 Isum.n135 Isum.n41 15.5561
R101 Isum.n132 Isum.n41 15.5561
R102 Isum.n132 Isum.n52 15.5561
R103 Isum.n53 Isum.n52 15.5561
R104 Isum.n54 Isum.n53 15.5561
R105 Isum.n127 Isum.n54 15.5561
R106 Isum.n127 Isum.n62 15.5561
R107 Isum.n248 Isum.n80 15.5561
R108 Isum.n338 Isum.n80 15.5561
R109 Isum.n338 Isum.n81 15.5561
R110 Isum.n91 Isum.n81 15.5561
R111 Isum.n311 Isum.n91 15.5561
R112 Isum.n320 Isum.n311 15.5561
R113 Isum.n321 Isum.n320 15.5561
R114 Isum.n321 Isum.n19 15.5561
R115 Isum.n378 Isum.n19 15.5561
R116 Isum.n378 Isum.n20 15.5561
R117 Isum.n105 Isum.n20 15.5561
R118 Isum.n105 Isum.n33 15.5561
R119 Isum.n366 Isum.n33 15.5561
R120 Isum.n167 Isum.n165 15.5561
R121 Isum.n167 Isum.n78 15.5561
R122 Isum.n238 Isum.n78 15.5561
R123 Isum.n238 Isum.n92 15.5561
R124 Isum.n308 Isum.n92 15.5561
R125 Isum.n308 Isum.n93 15.5561
R126 Isum.n98 Isum.n93 15.5561
R127 Isum.n101 Isum.n98 15.5561
R128 Isum.n101 Isum.n17 15.5561
R129 Isum.n108 Isum.n17 15.5561
R130 Isum.n108 Isum.n104 15.5561
R131 Isum.n151 Isum.n104 15.5561
R132 Isum.n151 Isum.n40 15.5561
R133 Isum.n372 Isum.n371 12.5005
R134 Isum.n286 Isum.n285 12.5005
R135 Isum.n284 Isum.n283 12.5005
R136 Isum.n282 Isum.n156 12.5005
R137 Isum.n275 Isum.n157 12.5005
R138 Isum.n277 Isum.n276 12.5005
R139 Isum.n274 Isum.n158 12.5005
R140 Isum.n273 Isum.n272 12.5005
R141 Isum.n160 Isum.n159 12.5005
R142 Isum.n267 Isum.n266 12.5005
R143 Isum.n265 Isum.n161 12.5005
R144 Isum.n264 Isum.n263 12.5005
R145 Isum.n373 Isum.n27 12.5005
R146 Isum.n375 Isum.n374 12.5005
R147 Isum.n26 Isum.n23 12.5005
R148 Isum.n319 Isum.n315 12.5005
R149 Isum.n325 Isum.n324 12.5005
R150 Isum.n327 Isum.n326 12.5005
R151 Isum.n90 Isum.n88 12.5005
R152 Isum.n333 Isum.n332 12.5005
R153 Isum.n335 Isum.n334 12.5005
R154 Isum.n87 Isum.n84 12.5005
R155 Isum.n31 Isum.t4 12.1268
R156 Isum.n251 Isum.t25 12.1268
R157 Isum.t33 Isum.n152 12.1268
R158 Isum.t47 Isum.n260 12.1268
R159 Isum.n87 Isum.t23 11.863
R160 Isum.n334 Isum.t20 11.863
R161 Isum.n88 Isum.t17 11.863
R162 Isum.n326 Isum.t14 11.863
R163 Isum.n315 Isum.t11 11.863
R164 Isum.n26 Isum.t8 11.863
R165 Isum.n373 Isum.t5 11.863
R166 Isum.n372 Isum.t2 11.863
R167 Isum.n264 Isum.t46 11.863
R168 Isum.n265 Isum.t44 11.863
R169 Isum.n159 Isum.t42 11.863
R170 Isum.n273 Isum.t40 11.863
R171 Isum.n276 Isum.t38 11.863
R172 Isum.n275 Isum.t36 11.863
R173 Isum.n284 Isum.t34 11.863
R174 Isum.n285 Isum.t32 11.863
R175 Isum.t30 Isum.n215 11.653
R176 Isum.n150 Isum.t27 11.653
R177 Isum.n36 Isum.n35 10.2173
R178 Isum.n257 Isum.t31 9.8285
R179 Isum.t31 Isum.n255 9.8285
R180 Isum.n289 Isum.t28 9.8285
R181 Isum.t28 Isum.n154 9.8285
R182 Isum.n30 Isum.n28 8.63568
R183 Isum.n318 Isum.n317 8.63568
R184 Isum.n328 Isum.n313 8.63568
R185 Isum.n336 Isum.n85 8.63568
R186 Isum.n280 Isum.n155 8.63568
R187 Isum.n279 Isum.n278 8.63568
R188 Isum.n271 Isum.n270 8.63568
R189 Isum.n262 Isum.n261 8.63568
R190 Isum.n375 Isum.n24 8.59884
R191 Isum.n324 Isum.n316 8.59884
R192 Isum.n332 Isum.n89 8.59884
R193 Isum.n282 Isum.n281 8.59884
R194 Isum.n269 Isum.n158 8.59884
R195 Isum.n268 Isum.n267 8.59884
R196 Isum.n51 Isum.n42 8.47508
R197 Isum.n334 Isum.n87 8.1765
R198 Isum.n326 Isum.n88 8.1765
R199 Isum.n315 Isum.n26 8.1765
R200 Isum.n373 Isum.n372 8.1765
R201 Isum.n265 Isum.n264 8.1765
R202 Isum.n273 Isum.n159 8.1765
R203 Isum.n276 Isum.n275 8.1765
R204 Isum.n285 Isum.n284 8.1765
R205 Isum.n196 Isum.n195 7.08143
R206 Isum.n196 Isum.n179 7.08143
R207 Isum.n124 Isum.n60 6.99336
R208 Isum.n125 Isum.n124 6.99336
R209 Isum.n294 Isum.n293 5.94383
R210 Isum.n246 Isum.n245 5.94383
R211 Isum.n293 Isum.n292 5.89523
R212 Isum.n246 Isum.n163 5.89523
R213 Isum.n211 Isum.n210 5.2005
R214 Isum.n175 Isum.n174 5.2005
R215 Isum.n206 Isum.n205 5.2005
R216 Isum.n178 Isum.n177 5.2005
R217 Isum.n201 Isum.n200 5.2005
R218 Isum.n199 Isum.n198 5.2005
R219 Isum.n194 Isum.n180 5.2005
R220 Isum.n193 Isum.n192 5.2005
R221 Isum.n191 Isum.n190 5.2005
R222 Isum.n189 Isum.n188 5.2005
R223 Isum.n187 Isum.n186 5.2005
R224 Isum.n71 Isum.n69 5.2005
R225 Isum.n126 Isum.n62 5.2005
R226 Isum.n350 Isum.n62 5.2005
R227 Isum.n128 Isum.n127 5.2005
R228 Isum.n127 Isum.n55 5.2005
R229 Isum.n129 Isum.n54 5.2005
R230 Isum.n356 Isum.n54 5.2005
R231 Isum.n130 Isum.n53 5.2005
R232 Isum.n357 Isum.n53 5.2005
R233 Isum.n131 Isum.n52 5.2005
R234 Isum.n358 Isum.n52 5.2005
R235 Isum.n133 Isum.n132 5.2005
R236 Isum.n132 Isum.n51 5.2005
R237 Isum.n134 Isum.n41 5.2005
R238 Isum.n364 Isum.n41 5.2005
R239 Isum.n136 Isum.n135 5.2005
R240 Isum.n135 Isum.n39 5.2005
R241 Isum.n137 Isum.n107 5.2005
R242 Isum.n149 Isum.n107 5.2005
R243 Isum.n139 Isum.n138 5.2005
R244 Isum.n140 Isum.n139 5.2005
R245 Isum.n111 Isum.n110 5.2005
R246 Isum.n110 Isum.n18 5.2005
R247 Isum.n112 Isum.n16 5.2005
R248 Isum.n380 Isum.n16 5.2005
R249 Isum.n5 Isum.n3 5.2005
R250 Isum.n99 Isum.n5 5.2005
R251 Isum.n388 Isum.n387 5.2005
R252 Isum.n387 Isum.n386 5.2005
R253 Isum.n4 Isum.n2 5.2005
R254 Isum.n309 Isum.n4 5.2005
R255 Isum.n226 Isum.n225 5.2005
R256 Isum.n227 Isum.n226 5.2005
R257 Isum.n170 Isum.n168 5.2005
R258 Isum.n236 Isum.n168 5.2005
R259 Isum.n221 Isum.n220 5.2005
R260 Isum.n220 Isum.n79 5.2005
R261 Isum.n219 Isum.n77 5.2005
R262 Isum.n340 Isum.n77 5.2005
R263 Isum.n218 Isum.n217 5.2005
R264 Isum.n217 Isum.n216 5.2005
R265 Isum.n172 Isum.n67 5.2005
R266 Isum.n346 Isum.n67 5.2005
R267 Isum.n345 Isum.n344 5.2005
R268 Isum.n346 Isum.n345 5.2005
R269 Isum.n343 Isum.n70 5.2005
R270 Isum.n216 Isum.n70 5.2005
R271 Isum.n342 Isum.n341 5.2005
R272 Isum.n341 Isum.n340 5.2005
R273 Isum.n76 Isum.n75 5.2005
R274 Isum.n79 Isum.n76 5.2005
R275 Isum.n235 Isum.n234 5.2005
R276 Isum.n236 Isum.n235 5.2005
R277 Isum.n233 Isum.n228 5.2005
R278 Isum.n228 Isum.n227 5.2005
R279 Isum.n10 Isum.n8 5.2005
R280 Isum.n309 Isum.n8 5.2005
R281 Isum.n385 Isum.n384 5.2005
R282 Isum.n386 Isum.n385 5.2005
R283 Isum.n383 Isum.n9 5.2005
R284 Isum.n99 Isum.n9 5.2005
R285 Isum.n382 Isum.n381 5.2005
R286 Isum.n381 Isum.n380 5.2005
R287 Isum.n15 Isum.n14 5.2005
R288 Isum.n18 Isum.n15 5.2005
R289 Isum.n142 Isum.n141 5.2005
R290 Isum.n141 Isum.n140 5.2005
R291 Isum.n148 Isum.n147 5.2005
R292 Isum.n149 Isum.n148 5.2005
R293 Isum.n45 Isum.n43 5.2005
R294 Isum.n43 Isum.n39 5.2005
R295 Isum.n363 Isum.n362 5.2005
R296 Isum.n364 Isum.n363 5.2005
R297 Isum.n361 Isum.n44 5.2005
R298 Isum.n51 Isum.n44 5.2005
R299 Isum.n360 Isum.n359 5.2005
R300 Isum.n359 Isum.n358 5.2005
R301 Isum.n50 Isum.n49 5.2005
R302 Isum.n357 Isum.n50 5.2005
R303 Isum.n355 Isum.n354 5.2005
R304 Isum.n356 Isum.n355 5.2005
R305 Isum.n353 Isum.n56 5.2005
R306 Isum.n56 Isum.n55 5.2005
R307 Isum.n352 Isum.n351 5.2005
R308 Isum.n351 Isum.n350 5.2005
R309 Isum.n367 Isum.n366 5.2005
R310 Isum.n366 Isum.n365 5.2005
R311 Isum.n368 Isum.n33 5.2005
R312 Isum.n150 Isum.n33 5.2005
R313 Isum.n105 Isum.n32 5.2005
R314 Isum.n106 Isum.n105 5.2005
R315 Isum.n22 Isum.n20 5.2005
R316 Isum.n109 Isum.n20 5.2005
R317 Isum.n378 Isum.n377 5.2005
R318 Isum.n379 Isum.n378 5.2005
R319 Isum.n21 Isum.n19 5.2005
R320 Isum.n100 Isum.n19 5.2005
R321 Isum.n322 Isum.n321 5.2005
R322 Isum.n321 Isum.n7 5.2005
R323 Isum.n320 Isum.n312 5.2005
R324 Isum.n320 Isum.n6 5.2005
R325 Isum.n329 Isum.n311 5.2005
R326 Isum.n311 Isum.n310 5.2005
R327 Isum.n330 Isum.n91 5.2005
R328 Isum.n169 Isum.n91 5.2005
R329 Isum.n83 Isum.n81 5.2005
R330 Isum.n237 Isum.n81 5.2005
R331 Isum.n338 Isum.n337 5.2005
R332 Isum.n339 Isum.n338 5.2005
R333 Isum.n82 Isum.n80 5.2005
R334 Isum.n215 Isum.n80 5.2005
R335 Isum.n249 Isum.n248 5.2005
R336 Isum.n248 Isum.n68 5.2005
R337 Isum.n295 Isum.n40 5.2005
R338 Isum.n365 Isum.n40 5.2005
R339 Isum.n296 Isum.n151 5.2005
R340 Isum.n151 Isum.n150 5.2005
R341 Isum.n297 Isum.n104 5.2005
R342 Isum.n106 Isum.n104 5.2005
R343 Isum.n108 Isum.n102 5.2005
R344 Isum.n109 Isum.n108 5.2005
R345 Isum.n301 Isum.n17 5.2005
R346 Isum.n379 Isum.n17 5.2005
R347 Isum.n302 Isum.n101 5.2005
R348 Isum.n101 Isum.n100 5.2005
R349 Isum.n303 Isum.n98 5.2005
R350 Isum.n98 Isum.n7 5.2005
R351 Isum.n95 Isum.n93 5.2005
R352 Isum.n93 Isum.n6 5.2005
R353 Isum.n308 Isum.n307 5.2005
R354 Isum.n310 Isum.n308 5.2005
R355 Isum.n94 Isum.n92 5.2005
R356 Isum.n169 Isum.n92 5.2005
R357 Isum.n239 Isum.n238 5.2005
R358 Isum.n238 Isum.n237 5.2005
R359 Isum.n242 Isum.n78 5.2005
R360 Isum.n339 Isum.n78 5.2005
R361 Isum.n243 Isum.n167 5.2005
R362 Isum.n215 Isum.n167 5.2005
R363 Isum.n244 Isum.n165 5.2005
R364 Isum.n165 Isum.n68 5.2005
R365 Isum.n255 Isum.n254 4.85463
R366 Isum.n154 Isum.n29 4.85463
R367 Isum.n257 Isum.n164 4.69811
R368 Isum.n289 Isum.n153 4.69811
R369 Isum.n195 Isum.n194 4.5005
R370 Isum.n193 Isum.n181 4.5005
R371 Isum.n190 Isum.n182 4.5005
R372 Isum.n189 Isum.n183 4.5005
R373 Isum.n186 Isum.n185 4.5005
R374 Isum.n184 Isum.n71 4.5005
R375 Isum.n344 Isum.n72 4.5005
R376 Isum.n343 Isum.n73 4.5005
R377 Isum.n342 Isum.n74 4.5005
R378 Isum.n229 Isum.n75 4.5005
R379 Isum.n234 Isum.n230 4.5005
R380 Isum.n233 Isum.n232 4.5005
R381 Isum.n231 Isum.n10 4.5005
R382 Isum.n384 Isum.n11 4.5005
R383 Isum.n383 Isum.n12 4.5005
R384 Isum.n382 Isum.n13 4.5005
R385 Isum.n143 Isum.n14 4.5005
R386 Isum.n144 Isum.n142 4.5005
R387 Isum.n147 Isum.n146 4.5005
R388 Isum.n145 Isum.n45 4.5005
R389 Isum.n362 Isum.n46 4.5005
R390 Isum.n361 Isum.n47 4.5005
R391 Isum.n360 Isum.n48 4.5005
R392 Isum.n57 Isum.n49 4.5005
R393 Isum.n354 Isum.n58 4.5005
R394 Isum.n353 Isum.n59 4.5005
R395 Isum.n352 Isum.n60 4.5005
R396 Isum.n202 Isum.n201 4.5005
R397 Isum.n203 Isum.n178 4.5005
R398 Isum.n205 Isum.n204 4.5005
R399 Isum.n174 Isum.n173 4.5005
R400 Isum.n212 Isum.n211 4.5005
R401 Isum.n213 Isum.n172 4.5005
R402 Isum.n218 Isum.n214 4.5005
R403 Isum.n219 Isum.n171 4.5005
R404 Isum.n222 Isum.n221 4.5005
R405 Isum.n223 Isum.n170 4.5005
R406 Isum.n225 Isum.n224 4.5005
R407 Isum.n2 Isum.n0 4.5005
R408 VSS Isum.n388 4.5005
R409 Isum.n3 Isum.n1 4.5005
R410 Isum.n113 Isum.n112 4.5005
R411 Isum.n114 Isum.n111 4.5005
R412 Isum.n138 Isum.n115 4.5005
R413 Isum.n137 Isum.n116 4.5005
R414 Isum.n136 Isum.n117 4.5005
R415 Isum.n134 Isum.n118 4.5005
R416 Isum.n133 Isum.n119 4.5005
R417 Isum.n131 Isum.n120 4.5005
R418 Isum.n130 Isum.n121 4.5005
R419 Isum.n129 Isum.n122 4.5005
R420 Isum.n128 Isum.n123 4.5005
R421 Isum.n126 Isum.n125 4.5005
R422 Isum.n199 Isum.n179 4.5005
R423 Isum.n243 Isum.n166 4.5005
R424 Isum.n242 Isum.n241 4.5005
R425 Isum.n240 Isum.n239 4.5005
R426 Isum.n96 Isum.n94 4.5005
R427 Isum.n307 Isum.n306 4.5005
R428 Isum.n305 Isum.n95 4.5005
R429 Isum.n304 Isum.n303 4.5005
R430 Isum.n302 Isum.n97 4.5005
R431 Isum.n301 Isum.n300 4.5005
R432 Isum.n299 Isum.n102 4.5005
R433 Isum.n298 Isum.n297 4.5005
R434 Isum.n296 Isum.n103 4.5005
R435 Isum.n295 Isum.n294 4.5005
R436 Isum.n245 Isum.n244 4.5005
R437 Isum.n290 Isum.n154 4.5005
R438 Isum.n290 Isum.n289 4.5005
R439 Isum.n258 Isum.n255 4.5005
R440 Isum.n258 Isum.n257 4.5005
R441 Isum.n252 Isum.n82 4.5005
R442 Isum.n337 Isum.n336 4.5005
R443 Isum.n86 Isum.n83 4.5005
R444 Isum.n331 Isum.n330 4.5005
R445 Isum.n329 Isum.n328 4.5005
R446 Isum.n314 Isum.n312 4.5005
R447 Isum.n323 Isum.n322 4.5005
R448 Isum.n318 Isum.n21 4.5005
R449 Isum.n377 Isum.n376 4.5005
R450 Isum.n25 Isum.n22 4.5005
R451 Isum.n32 Isum.n28 4.5005
R452 Isum.n369 Isum.n368 4.5005
R453 Isum.n367 Isum.n37 4.5005
R454 Isum.n250 Isum.n249 4.5005
R455 Isum.n334 Isum.n333 4.0885
R456 Isum.n333 Isum.n88 4.0885
R457 Isum.n326 Isum.n325 4.0885
R458 Isum.n325 Isum.n315 4.0885
R459 Isum.n374 Isum.n26 4.0885
R460 Isum.n374 Isum.n373 4.0885
R461 Isum.n266 Isum.n265 4.0885
R462 Isum.n266 Isum.n159 4.0885
R463 Isum.n274 Isum.n273 4.0885
R464 Isum.n276 Isum.n274 4.0885
R465 Isum.n275 Isum.n156 4.0885
R466 Isum.n284 Isum.n156 4.0885
R467 Isum.n30 Isum.t7 3.5285
R468 Isum.t4 Isum.n30 3.5285
R469 Isum.t10 Isum.n24 3.5285
R470 Isum.t7 Isum.n24 3.5285
R471 Isum.n317 Isum.t13 3.5285
R472 Isum.n317 Isum.t10 3.5285
R473 Isum.n316 Isum.t16 3.5285
R474 Isum.t13 Isum.n316 3.5285
R475 Isum.n313 Isum.t19 3.5285
R476 Isum.t16 Isum.n313 3.5285
R477 Isum.n89 Isum.t22 3.5285
R478 Isum.t19 Isum.n89 3.5285
R479 Isum.t25 Isum.n85 3.5285
R480 Isum.t22 Isum.n85 3.5285
R481 Isum.t35 Isum.n280 3.5285
R482 Isum.n280 Isum.t33 3.5285
R483 Isum.n281 Isum.t37 3.5285
R484 Isum.n281 Isum.t35 3.5285
R485 Isum.n279 Isum.t39 3.5285
R486 Isum.t37 Isum.n279 3.5285
R487 Isum.t41 Isum.n269 3.5285
R488 Isum.n269 Isum.t39 3.5285
R489 Isum.n270 Isum.t43 3.5285
R490 Isum.n270 Isum.t41 3.5285
R491 Isum.n268 Isum.t45 3.5285
R492 Isum.t43 Isum.n268 3.5285
R493 Isum.n261 Isum.t47 3.5285
R494 Isum.n261 Isum.t45 3.5285
R495 Isum.n227 Isum.t48 3.17847
R496 Isum.n380 Isum.t0 3.17847
R497 Isum.n180 Isum.n65 3.11744
R498 Isum.n191 Isum.n64 3.11744
R499 Isum.n187 Isum.n63 3.11744
R500 Isum.n200 Isum.n176 3.11744
R501 Isum.n207 Isum.n206 3.11744
R502 Isum.n210 Isum.n209 3.11744
R503 Isum.n209 Isum.n175 3.11744
R504 Isum.n207 Isum.n177 3.11744
R505 Isum.n198 Isum.n176 3.11744
R506 Isum.n192 Isum.n65 3.11744
R507 Isum.n188 Isum.n64 3.11744
R508 Isum.n69 Isum.n63 3.11744
R509 Isum.n35 Isum 1.7105
R510 Isum.n209 Isum.n208 1.04278
R511 Isum.n208 Isum.n207 1.04278
R512 Isum.n208 Isum.n176 1.04278
R513 Isum.n348 Isum.n65 1.04278
R514 Isum.n348 Isum.n64 1.04278
R515 Isum.n348 Isum.n63 1.04278
R516 Isum.n260 Isum.n259 0.732757
R517 Isum.n291 Isum.n152 0.732757
R518 Isum.n259 Isum.n163 0.716145
R519 Isum.n292 Isum.n291 0.716145
R520 Isum.n35 Isum.n34 0.5063
R521 Isum.n293 Isum.n38 0.217167
R522 Isum.n42 Isum.n38 0.217167
R523 Isum.n247 Isum.n246 0.217167
R524 Isum.n247 Isum.n66 0.217167
R525 Isum.n244 Isum.n243 0.1445
R526 Isum.n243 Isum.n242 0.1445
R527 Isum.n242 Isum.n239 0.1445
R528 Isum.n239 Isum.n94 0.1445
R529 Isum.n307 Isum.n94 0.1445
R530 Isum.n307 Isum.n95 0.1445
R531 Isum.n303 Isum.n95 0.1445
R532 Isum.n303 Isum.n302 0.1445
R533 Isum.n302 Isum.n301 0.1445
R534 Isum.n301 Isum.n102 0.1445
R535 Isum.n297 Isum.n102 0.1445
R536 Isum.n297 Isum.n296 0.1445
R537 Isum.n296 Isum.n295 0.1445
R538 Isum.n201 Isum.n199 0.1445
R539 Isum.n201 Isum.n178 0.1445
R540 Isum.n205 Isum.n178 0.1445
R541 Isum.n205 Isum.n174 0.1445
R542 Isum.n211 Isum.n174 0.1445
R543 Isum.n211 Isum.n172 0.1445
R544 Isum.n218 Isum.n172 0.1445
R545 Isum.n219 Isum.n218 0.1445
R546 Isum.n221 Isum.n219 0.1445
R547 Isum.n221 Isum.n170 0.1445
R548 Isum.n225 Isum.n170 0.1445
R549 Isum.n225 Isum.n2 0.1445
R550 Isum.n388 Isum.n2 0.1445
R551 Isum.n388 Isum.n3 0.1445
R552 Isum.n112 Isum.n3 0.1445
R553 Isum.n112 Isum.n111 0.1445
R554 Isum.n138 Isum.n111 0.1445
R555 Isum.n138 Isum.n137 0.1445
R556 Isum.n137 Isum.n136 0.1445
R557 Isum.n136 Isum.n134 0.1445
R558 Isum.n134 Isum.n133 0.1445
R559 Isum.n133 Isum.n131 0.1445
R560 Isum.n131 Isum.n130 0.1445
R561 Isum.n130 Isum.n129 0.1445
R562 Isum.n129 Isum.n128 0.1445
R563 Isum.n128 Isum.n126 0.1445
R564 Isum.n194 Isum.n193 0.1445
R565 Isum.n193 Isum.n190 0.1445
R566 Isum.n190 Isum.n189 0.1445
R567 Isum.n189 Isum.n186 0.1445
R568 Isum.n186 Isum.n71 0.1445
R569 Isum.n344 Isum.n71 0.1445
R570 Isum.n344 Isum.n343 0.1445
R571 Isum.n343 Isum.n342 0.1445
R572 Isum.n342 Isum.n75 0.1445
R573 Isum.n234 Isum.n75 0.1445
R574 Isum.n234 Isum.n233 0.1445
R575 Isum.n233 Isum.n10 0.1445
R576 Isum.n384 Isum.n10 0.1445
R577 Isum.n384 Isum.n383 0.1445
R578 Isum.n383 Isum.n382 0.1445
R579 Isum.n382 Isum.n14 0.1445
R580 Isum.n142 Isum.n14 0.1445
R581 Isum.n147 Isum.n142 0.1445
R582 Isum.n147 Isum.n45 0.1445
R583 Isum.n362 Isum.n45 0.1445
R584 Isum.n362 Isum.n361 0.1445
R585 Isum.n361 Isum.n360 0.1445
R586 Isum.n360 Isum.n49 0.1445
R587 Isum.n354 Isum.n49 0.1445
R588 Isum.n354 Isum.n353 0.1445
R589 Isum.n353 Isum.n352 0.1445
R590 Isum.n195 Isum.n181 0.1445
R591 Isum.n182 Isum.n181 0.1445
R592 Isum.n183 Isum.n182 0.1445
R593 Isum.n185 Isum.n183 0.1445
R594 Isum.n185 Isum.n184 0.1445
R595 Isum.n184 Isum.n72 0.1445
R596 Isum.n73 Isum.n72 0.1445
R597 Isum.n74 Isum.n73 0.1445
R598 Isum.n229 Isum.n74 0.1445
R599 Isum.n230 Isum.n229 0.1445
R600 Isum.n232 Isum.n230 0.1445
R601 Isum.n232 Isum.n231 0.1445
R602 Isum.n231 Isum.n11 0.1445
R603 Isum.n12 Isum.n11 0.1445
R604 Isum.n13 Isum.n12 0.1445
R605 Isum.n143 Isum.n13 0.1445
R606 Isum.n144 Isum.n143 0.1445
R607 Isum.n146 Isum.n144 0.1445
R608 Isum.n146 Isum.n145 0.1445
R609 Isum.n145 Isum.n46 0.1445
R610 Isum.n47 Isum.n46 0.1445
R611 Isum.n48 Isum.n47 0.1445
R612 Isum.n57 Isum.n48 0.1445
R613 Isum.n58 Isum.n57 0.1445
R614 Isum.n59 Isum.n58 0.1445
R615 Isum.n60 Isum.n59 0.1445
R616 Isum.n202 Isum.n179 0.1445
R617 Isum.n203 Isum.n202 0.1445
R618 Isum.n204 Isum.n203 0.1445
R619 Isum.n204 Isum.n173 0.1445
R620 Isum.n212 Isum.n173 0.1445
R621 Isum.n213 Isum.n212 0.1445
R622 Isum.n214 Isum.n213 0.1445
R623 Isum.n214 Isum.n171 0.1445
R624 Isum.n222 Isum.n171 0.1445
R625 Isum.n223 Isum.n222 0.1445
R626 Isum.n224 Isum.n223 0.1445
R627 Isum.n224 Isum.n0 0.1445
R628 VSS Isum.n0 0.1445
R629 VSS Isum.n1 0.1445
R630 Isum.n113 Isum.n1 0.1445
R631 Isum.n114 Isum.n113 0.1445
R632 Isum.n115 Isum.n114 0.1445
R633 Isum.n116 Isum.n115 0.1445
R634 Isum.n117 Isum.n116 0.1445
R635 Isum.n118 Isum.n117 0.1445
R636 Isum.n119 Isum.n118 0.1445
R637 Isum.n120 Isum.n119 0.1445
R638 Isum.n121 Isum.n120 0.1445
R639 Isum.n122 Isum.n121 0.1445
R640 Isum.n123 Isum.n122 0.1445
R641 Isum.n125 Isum.n123 0.1445
R642 Isum.n249 Isum.n82 0.1445
R643 Isum.n337 Isum.n82 0.1445
R644 Isum.n337 Isum.n83 0.1445
R645 Isum.n330 Isum.n83 0.1445
R646 Isum.n330 Isum.n329 0.1445
R647 Isum.n329 Isum.n312 0.1445
R648 Isum.n322 Isum.n312 0.1445
R649 Isum.n322 Isum.n21 0.1445
R650 Isum.n377 Isum.n21 0.1445
R651 Isum.n377 Isum.n22 0.1445
R652 Isum.n32 Isum.n22 0.1445
R653 Isum.n368 Isum.n32 0.1445
R654 Isum.n368 Isum.n367 0.1445
R655 Isum.n245 Isum.n166 0.1445
R656 Isum.n241 Isum.n166 0.1445
R657 Isum.n241 Isum.n240 0.1445
R658 Isum.n240 Isum.n96 0.1445
R659 Isum.n306 Isum.n96 0.1445
R660 Isum.n306 Isum.n305 0.1445
R661 Isum.n305 Isum.n304 0.1445
R662 Isum.n304 Isum.n97 0.1445
R663 Isum.n300 Isum.n97 0.1445
R664 Isum.n300 Isum.n299 0.1445
R665 Isum.n299 Isum.n298 0.1445
R666 Isum.n298 Isum.n103 0.1445
R667 Isum.n294 Isum.n103 0.1445
R668 Isum.n197 Isum.n196 0.111138
R669 Isum.n197 Isum.n66 0.111138
R670 Isum.n124 Isum.n61 0.111138
R671 Isum.n290 Isum.n288 0.0424731
R672 Isum.n258 Isum.n256 0.0424731
R673 Isum.n153 Isum.n29 0.032787
R674 Isum.n254 Isum.n164 0.032787
R675 Isum.n370 Isum.n29 0.0315762
R676 Isum.n288 Isum.n287 0.0315762
R677 Isum.n254 Isum.n253 0.0315762
R678 Isum.n256 Isum.n162 0.0315762
R679 Isum.n291 Isum.n153 0.0265314
R680 Isum.n259 Isum.n164 0.0265314
R681 Isum.n267 Isum.n161 0.0203347
R682 Isum.n267 Isum.n160 0.0203347
R683 Isum.n272 Isum.n158 0.0203347
R684 Isum.n277 Isum.n158 0.0203347
R685 Isum.n282 Isum.n157 0.0203347
R686 Isum.n283 Isum.n282 0.0203347
R687 Isum.n291 Isum.n290 0.0168453
R688 Isum.n259 Isum.n258 0.0168453
R689 Isum.n260 Isum.n162 0.0115331
R690 Isum.n287 Isum.n152 0.0115331
R691 Isum.n263 Isum.n262 0.0104174
R692 Isum.n262 Isum.n161 0.0104174
R693 Isum.n271 Isum.n160 0.0104174
R694 Isum.n272 Isum.n271 0.0104174
R695 Isum.n278 Isum.n277 0.0104174
R696 Isum.n278 Isum.n157 0.0104174
R697 Isum.n283 Isum.n155 0.0104174
R698 Isum.n286 Isum.n155 0.0104174
R699 Isum.n263 Isum.n162 0.00930165
R700 Isum.n287 Isum.n286 0.00930165
R701 Isum.n251 Isum.n250 0.0086448
R702 Isum.n252 Isum.n251 0.0086448
R703 Isum.n336 Isum.n84 0.0086448
R704 Isum.n336 Isum.n335 0.0086448
R705 Isum.n335 Isum.n86 0.0086448
R706 Isum.n332 Isum.n86 0.0086448
R707 Isum.n332 Isum.n331 0.0086448
R708 Isum.n331 Isum.n90 0.0086448
R709 Isum.n328 Isum.n90 0.0086448
R710 Isum.n328 Isum.n327 0.0086448
R711 Isum.n327 Isum.n314 0.0086448
R712 Isum.n324 Isum.n314 0.0086448
R713 Isum.n324 Isum.n323 0.0086448
R714 Isum.n323 Isum.n319 0.0086448
R715 Isum.n319 Isum.n318 0.0086448
R716 Isum.n318 Isum.n23 0.0086448
R717 Isum.n376 Isum.n23 0.0086448
R718 Isum.n376 Isum.n375 0.0086448
R719 Isum.n375 Isum.n25 0.0086448
R720 Isum.n27 Isum.n25 0.0086448
R721 Isum.n28 Isum.n27 0.0086448
R722 Isum.n371 Isum.n28 0.0086448
R723 Isum.n369 Isum.n31 0.0086448
R724 Isum.n253 Isum.n84 0.00772851
R725 Isum.n371 Isum.n370 0.00772851
R726 Isum.n250 Isum.n163 0.00599774
R727 Isum.n292 Isum.n37 0.00599774
R728 Isum.n37 Isum.n36 0.00497964
R729 Isum.n36 Isum.n31 0.00416516
R730 Isum.n253 Isum.n252 0.00141629
R731 Isum.n370 Isum.n369 0.00141629
R732 VDD.n143 VDD.n141 147.439
R733 VDD.n182 VDD.n181 147.439
R734 VDD.n149 VDD.n141 147.439
R735 VDD.n181 VDD.n126 147.439
R736 VDD.n77 VDD.n74 128.189
R737 VDD.n213 VDD.n20 128.189
R738 VDD.n87 VDD.n64 59.836
R739 VDD.n224 VDD.n223 59.836
R740 VDD.n221 VDD.n220 59.836
R741 VDD.n75 VDD.t31 51.6086
R742 VDD.t28 VDD.n215 51.6086
R743 VDD.n214 VDD.n213 49.2957
R744 VDD.n77 VDD.n76 49.2957
R745 VDD.n84 VDD.t25 44.8771
R746 VDD.n84 VDD.t22 44.8771
R747 VDD.n63 VDD.t16 44.8771
R748 VDD.t13 VDD.n222 44.8771
R749 VDD.n217 VDD.t7 44.8771
R750 VDD.n217 VDD.t4 44.8771
R751 VDD.t49 VDD.n63 27.6744
R752 VDD.n222 VDD.t1 27.6744
R753 VDD.n207 VDD.t0 26.0766
R754 VDD.n208 VDD.t2 24.4345
R755 VDD.n206 VDD.t50 24.4345
R756 VDD.n242 VDD.t30 24.363
R757 VDD.n274 VDD.t27 24.363
R758 VDD.t19 VDD.t49 17.2032
R759 VDD.t1 VDD.t10 17.2032
R760 VDD.t25 VDD.n83 14.9594
R761 VDD.n87 VDD.t22 14.9594
R762 VDD.n64 VDD.t19 14.9594
R763 VDD.n224 VDD.t16 14.9594
R764 VDD.n223 VDD.t13 14.9594
R765 VDD.t10 VDD.n221 14.9594
R766 VDD.n220 VDD.t7 14.9594
R767 VDD.t4 VDD.n216 14.9594
R768 VDD.n74 VDD.n65 14.0005
R769 VDD.n85 VDD.n65 14.0005
R770 VDD.n86 VDD.n85 14.0005
R771 VDD.n86 VDD.n43 14.0005
R772 VDD.n44 VDD.n43 14.0005
R773 VDD.n225 VDD.n44 14.0005
R774 VDD.n225 VDD.n45 14.0005
R775 VDD.n45 VDD.n6 14.0005
R776 VDD.n7 VDD.n6 14.0005
R777 VDD.n219 VDD.n7 14.0005
R778 VDD.n219 VDD.n218 14.0005
R779 VDD.n218 VDD.n19 14.0005
R780 VDD.n20 VDD.n19 14.0005
R781 VDD.n82 VDD.n67 14.0005
R782 VDD.n82 VDD.n61 14.0005
R783 VDD.n88 VDD.n61 14.0005
R784 VDD.n88 VDD.n62 14.0005
R785 VDD.n62 VDD.n58 14.0005
R786 VDD.n58 VDD.n46 14.0005
R787 VDD.n47 VDD.n46 14.0005
R788 VDD.n48 VDD.n47 14.0005
R789 VDD.n49 VDD.n48 14.0005
R790 VDD.n50 VDD.n49 14.0005
R791 VDD.n51 VDD.n50 14.0005
R792 VDD.n52 VDD.n51 14.0005
R793 VDD.n212 VDD.n52 14.0005
R794 VDD.n143 VDD.n142 14.0005
R795 VDD.n142 VDD.n107 14.0005
R796 VDD.n108 VDD.n107 14.0005
R797 VDD.n109 VDD.n108 14.0005
R798 VDD.n112 VDD.n109 14.0005
R799 VDD.n113 VDD.n112 14.0005
R800 VDD.n114 VDD.n113 14.0005
R801 VDD.n115 VDD.n114 14.0005
R802 VDD.n118 VDD.n115 14.0005
R803 VDD.n119 VDD.n118 14.0005
R804 VDD.n120 VDD.n119 14.0005
R805 VDD.n121 VDD.n120 14.0005
R806 VDD.n124 VDD.n121 14.0005
R807 VDD.n125 VDD.n124 14.0005
R808 VDD.n182 VDD.n125 14.0005
R809 VDD.n150 VDD.n149 14.0005
R810 VDD.n151 VDD.n150 14.0005
R811 VDD.n151 VDD.n137 14.0005
R812 VDD.n157 VDD.n137 14.0005
R813 VDD.n158 VDD.n157 14.0005
R814 VDD.n159 VDD.n158 14.0005
R815 VDD.n159 VDD.n133 14.0005
R816 VDD.n165 VDD.n133 14.0005
R817 VDD.n166 VDD.n165 14.0005
R818 VDD.n167 VDD.n166 14.0005
R819 VDD.n167 VDD.n129 14.0005
R820 VDD.n174 VDD.n129 14.0005
R821 VDD.n175 VDD.n174 14.0005
R822 VDD.n176 VDD.n175 14.0005
R823 VDD.n176 VDD.n126 14.0005
R824 VDD.n285 VDD.n284 12.5005
R825 VDD.n272 VDD.n271 12.5005
R826 VDD.n270 VDD.n269 12.5005
R827 VDD.n268 VDD.n26 12.5005
R828 VDD.n261 VDD.n27 12.5005
R829 VDD.n263 VDD.n262 12.5005
R830 VDD.n260 VDD.n28 12.5005
R831 VDD.n259 VDD.n258 12.5005
R832 VDD.n30 VDD.n29 12.5005
R833 VDD.n253 VDD.n252 12.5005
R834 VDD.n251 VDD.n31 12.5005
R835 VDD.n250 VDD.n249 12.5005
R836 VDD.n286 VDD.n13 12.5005
R837 VDD.n288 VDD.n287 12.5005
R838 VDD.n12 VDD.n4 12.5005
R839 VDD.n11 VDD.n3 12.5005
R840 VDD VDD.n1 12.5005
R841 VDD.n229 VDD.n228 12.5005
R842 VDD.n41 VDD.n38 12.5005
R843 VDD.n235 VDD.n234 12.5005
R844 VDD.n236 VDD.n37 12.5005
R845 VDD.n238 VDD.n237 12.5005
R846 VDD.n237 VDD.t24 11.863
R847 VDD.n236 VDD.t21 11.863
R848 VDD.n38 VDD.t18 11.863
R849 VDD.n228 VDD.t15 11.863
R850 VDD.n11 VDD.t12 11.863
R851 VDD.n12 VDD.t9 11.863
R852 VDD.n286 VDD.t6 11.863
R853 VDD.n285 VDD.t3 11.863
R854 VDD.n250 VDD.t47 11.863
R855 VDD.n251 VDD.t45 11.863
R856 VDD.n29 VDD.t43 11.863
R857 VDD.n259 VDD.t41 11.863
R858 VDD.n262 VDD.t39 11.863
R859 VDD.n261 VDD.t37 11.863
R860 VDD.n270 VDD.t35 11.863
R861 VDD.n271 VDD.t33 11.863
R862 VDD.n17 VDD.t5 11.4188
R863 VDD.n70 VDD.t26 11.4188
R864 VDD.t34 VDD.n22 11.4188
R865 VDD.t48 VDD.n246 11.4188
R866 VDD.n205 VDD.n204 10.3343
R867 VDD.n209 VDD.n208 10.0319
R868 VDD.n243 VDD.t32 9.1205
R869 VDD.t32 VDD.n241 9.1205
R870 VDD.n275 VDD.t29 9.1205
R871 VDD.t29 VDD.n24 9.1205
R872 VDD.n83 VDD.t31 8.22788
R873 VDD.n216 VDD.t28 8.22788
R874 VDD.n237 VDD.n236 8.1765
R875 VDD.n228 VDD.n38 8.1765
R876 VDD.n12 VDD.n11 8.1765
R877 VDD.n286 VDD.n285 8.1765
R878 VDD.n251 VDD.n250 8.1765
R879 VDD.n259 VDD.n29 8.1765
R880 VDD.n262 VDD.n261 8.1765
R881 VDD.n271 VDD.n270 8.1765
R882 VDD.n205 VDD.t51 7.66975
R883 VDD.n16 VDD.n14 7.53568
R884 VDD.n293 VDD.n292 7.53568
R885 VDD.n230 VDD.n227 7.53568
R886 VDD.n69 VDD.n36 7.53568
R887 VDD.n266 VDD.n25 7.53568
R888 VDD.n265 VDD.n264 7.53568
R889 VDD.n257 VDD.n256 7.53568
R890 VDD.n248 VDD.n247 7.53568
R891 VDD.n288 VDD.n9 7.49884
R892 VDD VDD.n294 7.49884
R893 VDD.n234 VDD.n40 7.49884
R894 VDD.n268 VDD.n267 7.49884
R895 VDD.n255 VDD.n28 7.49884
R896 VDD.n254 VDD.n253 7.49884
R897 VDD.n74 VDD.n73 6.3005
R898 VDD.n75 VDD.n74 6.3005
R899 VDD.n72 VDD.n65 6.3005
R900 VDD.n83 VDD.n65 6.3005
R901 VDD.n85 VDD.n66 6.3005
R902 VDD.n85 VDD.n84 6.3005
R903 VDD.n86 VDD.n42 6.3005
R904 VDD.n87 VDD.n86 6.3005
R905 VDD.n232 VDD.n43 6.3005
R906 VDD.n64 VDD.n43 6.3005
R907 VDD.n231 VDD.n44 6.3005
R908 VDD.n63 VDD.n44 6.3005
R909 VDD.n226 VDD.n225 6.3005
R910 VDD.n225 VDD.n224 6.3005
R911 VDD.n45 VDD.n5 6.3005
R912 VDD.n223 VDD.n45 6.3005
R913 VDD.n291 VDD.n6 6.3005
R914 VDD.n222 VDD.n6 6.3005
R915 VDD.n290 VDD.n7 6.3005
R916 VDD.n221 VDD.n7 6.3005
R917 VDD.n219 VDD.n8 6.3005
R918 VDD.n220 VDD.n219 6.3005
R919 VDD.n218 VDD.n18 6.3005
R920 VDD.n218 VDD.n217 6.3005
R921 VDD.n281 VDD.n19 6.3005
R922 VDD.n216 VDD.n19 6.3005
R923 VDD.n280 VDD.n20 6.3005
R924 VDD.n215 VDD.n20 6.3005
R925 VDD.n212 VDD.n211 6.3005
R926 VDD.n53 VDD.n52 6.3005
R927 VDD.n216 VDD.n52 6.3005
R928 VDD.n101 VDD.n51 6.3005
R929 VDD.n217 VDD.n51 6.3005
R930 VDD.n100 VDD.n50 6.3005
R931 VDD.n220 VDD.n50 6.3005
R932 VDD.n99 VDD.n49 6.3005
R933 VDD.n221 VDD.n49 6.3005
R934 VDD.n55 VDD.n48 6.3005
R935 VDD.n222 VDD.n48 6.3005
R936 VDD.n95 VDD.n47 6.3005
R937 VDD.n223 VDD.n47 6.3005
R938 VDD.n94 VDD.n46 6.3005
R939 VDD.n224 VDD.n46 6.3005
R940 VDD.n93 VDD.n58 6.3005
R941 VDD.n63 VDD.n58 6.3005
R942 VDD.n62 VDD.n57 6.3005
R943 VDD.n64 VDD.n62 6.3005
R944 VDD.n89 VDD.n88 6.3005
R945 VDD.n88 VDD.n87 6.3005
R946 VDD.n61 VDD.n60 6.3005
R947 VDD.n84 VDD.n61 6.3005
R948 VDD.n82 VDD.n81 6.3005
R949 VDD.n83 VDD.n82 6.3005
R950 VDD.n68 VDD.n67 6.3005
R951 VDD.n183 VDD.n182 6.3005
R952 VDD.n184 VDD.n125 6.3005
R953 VDD.n124 VDD.n122 6.3005
R954 VDD.n188 VDD.n121 6.3005
R955 VDD.n189 VDD.n120 6.3005
R956 VDD.n190 VDD.n119 6.3005
R957 VDD.n118 VDD.n116 6.3005
R958 VDD.n194 VDD.n115 6.3005
R959 VDD.n195 VDD.n114 6.3005
R960 VDD.n196 VDD.n113 6.3005
R961 VDD.n112 VDD.n110 6.3005
R962 VDD.n200 VDD.n109 6.3005
R963 VDD.n201 VDD.n108 6.3005
R964 VDD.n202 VDD.n107 6.3005
R965 VDD.n142 VDD.n106 6.3005
R966 VDD.n144 VDD.n143 6.3005
R967 VDD.n178 VDD.n126 6.3005
R968 VDD.n177 VDD.n176 6.3005
R969 VDD.n175 VDD.n128 6.3005
R970 VDD.n174 VDD.n173 6.3005
R971 VDD.n130 VDD.n129 6.3005
R972 VDD.n168 VDD.n167 6.3005
R973 VDD.n166 VDD.n132 6.3005
R974 VDD.n165 VDD.n164 6.3005
R975 VDD.n134 VDD.n133 6.3005
R976 VDD.n160 VDD.n159 6.3005
R977 VDD.n158 VDD.n136 6.3005
R978 VDD.n157 VDD.n156 6.3005
R979 VDD.n138 VDD.n137 6.3005
R980 VDD.n152 VDD.n151 6.3005
R981 VDD.n150 VDD.n140 6.3005
R982 VDD.n149 VDD.n148 6.3005
R983 VDD.n180 VDD.n123 6.1567
R984 VDD.n180 VDD.n179 6.1567
R985 VDD.n147 VDD.n146 6.1567
R986 VDD.n146 VDD.n145 6.1567
R987 VDD.n79 VDD.n78 5.94383
R988 VDD.n78 VDD.n33 5.89523
R989 VDD.n278 VDD.n21 5.80222
R990 VDD.n209 VDD.n21 5.73202
R991 VDD.n241 VDD.n240 4.85463
R992 VDD.n24 VDD.n15 4.85463
R993 VDD.n243 VDD.n34 4.69811
R994 VDD.n275 VDD.n23 4.69811
R995 VDD.n140 VDD.n139 4.5005
R996 VDD.n153 VDD.n152 4.5005
R997 VDD.n154 VDD.n138 4.5005
R998 VDD.n156 VDD.n155 4.5005
R999 VDD.n136 VDD.n135 4.5005
R1000 VDD.n161 VDD.n160 4.5005
R1001 VDD.n162 VDD.n134 4.5005
R1002 VDD.n164 VDD.n163 4.5005
R1003 VDD.n132 VDD.n131 4.5005
R1004 VDD.n169 VDD.n168 4.5005
R1005 VDD.n170 VDD.n130 4.5005
R1006 VDD.n173 VDD.n172 4.5005
R1007 VDD.n171 VDD.n128 4.5005
R1008 VDD.n177 VDD.n127 4.5005
R1009 VDD.n179 VDD.n178 4.5005
R1010 VDD.n148 VDD.n147 4.5005
R1011 VDD.n106 VDD.n104 4.5005
R1012 VDD.n203 VDD.n202 4.5005
R1013 VDD.n201 VDD.n105 4.5005
R1014 VDD.n200 VDD.n199 4.5005
R1015 VDD.n198 VDD.n110 4.5005
R1016 VDD.n197 VDD.n196 4.5005
R1017 VDD.n195 VDD.n111 4.5005
R1018 VDD.n194 VDD.n193 4.5005
R1019 VDD.n192 VDD.n116 4.5005
R1020 VDD.n191 VDD.n190 4.5005
R1021 VDD.n189 VDD.n117 4.5005
R1022 VDD.n188 VDD.n187 4.5005
R1023 VDD.n186 VDD.n122 4.5005
R1024 VDD.n185 VDD.n184 4.5005
R1025 VDD.n183 VDD.n123 4.5005
R1026 VDD.n145 VDD.n144 4.5005
R1027 VDD.n81 VDD.n80 4.5005
R1028 VDD.n60 VDD.n59 4.5005
R1029 VDD.n90 VDD.n89 4.5005
R1030 VDD.n91 VDD.n57 4.5005
R1031 VDD.n93 VDD.n92 4.5005
R1032 VDD.n94 VDD.n56 4.5005
R1033 VDD.n96 VDD.n95 4.5005
R1034 VDD.n97 VDD.n55 4.5005
R1035 VDD.n99 VDD.n98 4.5005
R1036 VDD.n100 VDD.n54 4.5005
R1037 VDD.n102 VDD.n101 4.5005
R1038 VDD.n103 VDD.n53 4.5005
R1039 VDD.n211 VDD.n210 4.5005
R1040 VDD.n79 VDD.n68 4.5005
R1041 VDD.n276 VDD.n24 4.5005
R1042 VDD.n276 VDD.n275 4.5005
R1043 VDD.n244 VDD.n241 4.5005
R1044 VDD.n244 VDD.n243 4.5005
R1045 VDD.n73 VDD.n71 4.5005
R1046 VDD.n72 VDD.n35 4.5005
R1047 VDD.n66 VDD.n36 4.5005
R1048 VDD.n42 VDD.n39 4.5005
R1049 VDD.n233 VDD.n232 4.5005
R1050 VDD.n231 VDD.n230 4.5005
R1051 VDD.n226 VDD.n0 4.5005
R1052 VDD.n5 VDD.n2 4.5005
R1053 VDD.n292 VDD.n291 4.5005
R1054 VDD.n290 VDD.n289 4.5005
R1055 VDD.n10 VDD.n8 4.5005
R1056 VDD.n18 VDD.n14 4.5005
R1057 VDD.n282 VDD.n281 4.5005
R1058 VDD.n280 VDD.n279 4.5005
R1059 VDD.n236 VDD.n235 4.0885
R1060 VDD.n235 VDD.n38 4.0885
R1061 VDD.n228 VDD.n1 4.0885
R1062 VDD.n11 VDD.n1 4.0885
R1063 VDD.n287 VDD.n12 4.0885
R1064 VDD.n287 VDD.n286 4.0885
R1065 VDD.n252 VDD.n251 4.0885
R1066 VDD.n252 VDD.n29 4.0885
R1067 VDD.n260 VDD.n259 4.0885
R1068 VDD.n262 VDD.n260 4.0885
R1069 VDD.n261 VDD.n26 4.0885
R1070 VDD.n270 VDD.n26 4.0885
R1071 VDD.n16 VDD.t8 3.9205
R1072 VDD.t5 VDD.n16 3.9205
R1073 VDD.n9 VDD.t11 3.9205
R1074 VDD.t8 VDD.n9 3.9205
R1075 VDD.t14 VDD.n293 3.9205
R1076 VDD.n293 VDD.t11 3.9205
R1077 VDD.n294 VDD.t17 3.9205
R1078 VDD.n294 VDD.t14 3.9205
R1079 VDD.n227 VDD.t20 3.9205
R1080 VDD.n227 VDD.t17 3.9205
R1081 VDD.t23 VDD.n40 3.9205
R1082 VDD.t20 VDD.n40 3.9205
R1083 VDD.t26 VDD.n69 3.9205
R1084 VDD.n69 VDD.t23 3.9205
R1085 VDD.t36 VDD.n266 3.9205
R1086 VDD.n266 VDD.t34 3.9205
R1087 VDD.n267 VDD.t38 3.9205
R1088 VDD.n267 VDD.t36 3.9205
R1089 VDD.n265 VDD.t40 3.9205
R1090 VDD.t38 VDD.n265 3.9205
R1091 VDD.t42 VDD.n255 3.9205
R1092 VDD.n255 VDD.t40 3.9205
R1093 VDD.n256 VDD.t44 3.9205
R1094 VDD.n256 VDD.t42 3.9205
R1095 VDD.n254 VDD.t46 3.9205
R1096 VDD.t44 VDD.n254 3.9205
R1097 VDD.n247 VDD.t48 3.9205
R1098 VDD.n247 VDD.t46 3.9205
R1099 VDD.n214 VDD.n212 3.69669
R1100 VDD.n76 VDD.n67 3.69669
R1101 VDD.n76 VDD.n75 2.42368
R1102 VDD.n215 VDD.n214 2.42368
R1103 VDD.n206 VDD.n205 0.8663
R1104 VDD.n246 VDD.n245 0.732757
R1105 VDD.n277 VDD.n22 0.732757
R1106 VDD.n245 VDD.n33 0.716145
R1107 VDD.n278 VDD.n277 0.716145
R1108 VDD.n208 VDD.n207 0.3605
R1109 VDD.n213 VDD.n21 0.263
R1110 VDD.n78 VDD.n77 0.263
R1111 VDD.n181 VDD.n180 0.2255
R1112 VDD.n146 VDD.n141 0.2255
R1113 VDD.n207 VDD.n206 0.2057
R1114 VDD.n81 VDD.n68 0.1445
R1115 VDD.n81 VDD.n60 0.1445
R1116 VDD.n89 VDD.n60 0.1445
R1117 VDD.n89 VDD.n57 0.1445
R1118 VDD.n93 VDD.n57 0.1445
R1119 VDD.n94 VDD.n93 0.1445
R1120 VDD.n95 VDD.n94 0.1445
R1121 VDD.n95 VDD.n55 0.1445
R1122 VDD.n99 VDD.n55 0.1445
R1123 VDD.n100 VDD.n99 0.1445
R1124 VDD.n101 VDD.n100 0.1445
R1125 VDD.n101 VDD.n53 0.1445
R1126 VDD.n211 VDD.n53 0.1445
R1127 VDD.n73 VDD.n72 0.1445
R1128 VDD.n72 VDD.n66 0.1445
R1129 VDD.n66 VDD.n42 0.1445
R1130 VDD.n232 VDD.n42 0.1445
R1131 VDD.n232 VDD.n231 0.1445
R1132 VDD.n231 VDD.n226 0.1445
R1133 VDD.n226 VDD.n5 0.1445
R1134 VDD.n291 VDD.n5 0.1445
R1135 VDD.n291 VDD.n290 0.1445
R1136 VDD.n290 VDD.n8 0.1445
R1137 VDD.n18 VDD.n8 0.1445
R1138 VDD.n281 VDD.n18 0.1445
R1139 VDD.n281 VDD.n280 0.1445
R1140 VDD.n148 VDD.n140 0.1445
R1141 VDD.n152 VDD.n140 0.1445
R1142 VDD.n152 VDD.n138 0.1445
R1143 VDD.n156 VDD.n138 0.1445
R1144 VDD.n156 VDD.n136 0.1445
R1145 VDD.n160 VDD.n136 0.1445
R1146 VDD.n160 VDD.n134 0.1445
R1147 VDD.n164 VDD.n134 0.1445
R1148 VDD.n164 VDD.n132 0.1445
R1149 VDD.n168 VDD.n132 0.1445
R1150 VDD.n168 VDD.n130 0.1445
R1151 VDD.n173 VDD.n130 0.1445
R1152 VDD.n173 VDD.n128 0.1445
R1153 VDD.n177 VDD.n128 0.1445
R1154 VDD.n178 VDD.n177 0.1445
R1155 VDD.n144 VDD.n106 0.1445
R1156 VDD.n202 VDD.n106 0.1445
R1157 VDD.n202 VDD.n201 0.1445
R1158 VDD.n201 VDD.n200 0.1445
R1159 VDD.n200 VDD.n110 0.1445
R1160 VDD.n196 VDD.n110 0.1445
R1161 VDD.n196 VDD.n195 0.1445
R1162 VDD.n195 VDD.n194 0.1445
R1163 VDD.n194 VDD.n116 0.1445
R1164 VDD.n190 VDD.n116 0.1445
R1165 VDD.n190 VDD.n189 0.1445
R1166 VDD.n189 VDD.n188 0.1445
R1167 VDD.n188 VDD.n122 0.1445
R1168 VDD.n184 VDD.n122 0.1445
R1169 VDD.n184 VDD.n183 0.1445
R1170 VDD.n147 VDD.n139 0.1445
R1171 VDD.n153 VDD.n139 0.1445
R1172 VDD.n154 VDD.n153 0.1445
R1173 VDD.n155 VDD.n154 0.1445
R1174 VDD.n155 VDD.n135 0.1445
R1175 VDD.n161 VDD.n135 0.1445
R1176 VDD.n162 VDD.n161 0.1445
R1177 VDD.n163 VDD.n162 0.1445
R1178 VDD.n163 VDD.n131 0.1445
R1179 VDD.n169 VDD.n131 0.1445
R1180 VDD.n170 VDD.n169 0.1445
R1181 VDD.n172 VDD.n170 0.1445
R1182 VDD.n172 VDD.n171 0.1445
R1183 VDD.n171 VDD.n127 0.1445
R1184 VDD.n179 VDD.n127 0.1445
R1185 VDD.n145 VDD.n104 0.1445
R1186 VDD.n203 VDD.n105 0.1445
R1187 VDD.n199 VDD.n105 0.1445
R1188 VDD.n199 VDD.n198 0.1445
R1189 VDD.n198 VDD.n197 0.1445
R1190 VDD.n197 VDD.n111 0.1445
R1191 VDD.n193 VDD.n111 0.1445
R1192 VDD.n193 VDD.n192 0.1445
R1193 VDD.n192 VDD.n191 0.1445
R1194 VDD.n191 VDD.n117 0.1445
R1195 VDD.n187 VDD.n117 0.1445
R1196 VDD.n187 VDD.n186 0.1445
R1197 VDD.n186 VDD.n185 0.1445
R1198 VDD.n185 VDD.n123 0.1445
R1199 VDD.n80 VDD.n79 0.1445
R1200 VDD.n80 VDD.n59 0.1445
R1201 VDD.n90 VDD.n59 0.1445
R1202 VDD.n91 VDD.n90 0.1445
R1203 VDD.n92 VDD.n91 0.1445
R1204 VDD.n92 VDD.n56 0.1445
R1205 VDD.n96 VDD.n56 0.1445
R1206 VDD.n97 VDD.n96 0.1445
R1207 VDD.n98 VDD.n97 0.1445
R1208 VDD.n98 VDD.n54 0.1445
R1209 VDD.n102 VDD.n54 0.1445
R1210 VDD.n103 VDD.n102 0.1445
R1211 VDD.n210 VDD.n103 0.1445
R1212 VDD.n210 VDD.n209 0.1193
R1213 VDD.n204 VDD.n203 0.1049
R1214 VDD.n276 VDD.n274 0.0424731
R1215 VDD.n244 VDD.n242 0.0424731
R1216 VDD.n204 VDD.n104 0.0401
R1217 VDD.n23 VDD.n15 0.032787
R1218 VDD.n240 VDD.n34 0.032787
R1219 VDD.n283 VDD.n15 0.0315762
R1220 VDD.n274 VDD.n273 0.0315762
R1221 VDD.n240 VDD.n239 0.0315762
R1222 VDD.n242 VDD.n32 0.0315762
R1223 VDD.n277 VDD.n23 0.0265314
R1224 VDD.n245 VDD.n34 0.0265314
R1225 VDD.n253 VDD.n31 0.0203347
R1226 VDD.n253 VDD.n30 0.0203347
R1227 VDD.n258 VDD.n28 0.0203347
R1228 VDD.n263 VDD.n28 0.0203347
R1229 VDD.n268 VDD.n27 0.0203347
R1230 VDD.n269 VDD.n268 0.0203347
R1231 VDD.n277 VDD.n276 0.0168453
R1232 VDD.n245 VDD.n244 0.0168453
R1233 VDD.n246 VDD.n32 0.0115331
R1234 VDD.n273 VDD.n22 0.0115331
R1235 VDD.n249 VDD.n248 0.0104174
R1236 VDD.n248 VDD.n31 0.0104174
R1237 VDD.n257 VDD.n30 0.0104174
R1238 VDD.n258 VDD.n257 0.0104174
R1239 VDD.n264 VDD.n263 0.0104174
R1240 VDD.n264 VDD.n27 0.0104174
R1241 VDD.n269 VDD.n25 0.0104174
R1242 VDD.n272 VDD.n25 0.0104174
R1243 VDD.n249 VDD.n32 0.00930165
R1244 VDD.n273 VDD.n272 0.00930165
R1245 VDD.n71 VDD.n70 0.0086448
R1246 VDD.n70 VDD.n35 0.0086448
R1247 VDD.n238 VDD.n36 0.0086448
R1248 VDD.n37 VDD.n36 0.0086448
R1249 VDD.n39 VDD.n37 0.0086448
R1250 VDD.n234 VDD.n39 0.0086448
R1251 VDD.n234 VDD.n233 0.0086448
R1252 VDD.n233 VDD.n41 0.0086448
R1253 VDD.n230 VDD.n41 0.0086448
R1254 VDD.n230 VDD.n229 0.0086448
R1255 VDD.n229 VDD.n0 0.0086448
R1256 VDD VDD.n0 0.0086448
R1257 VDD VDD.n2 0.0086448
R1258 VDD.n3 VDD.n2 0.0086448
R1259 VDD.n292 VDD.n3 0.0086448
R1260 VDD.n292 VDD.n4 0.0086448
R1261 VDD.n289 VDD.n4 0.0086448
R1262 VDD.n289 VDD.n288 0.0086448
R1263 VDD.n288 VDD.n10 0.0086448
R1264 VDD.n13 VDD.n10 0.0086448
R1265 VDD.n14 VDD.n13 0.0086448
R1266 VDD.n284 VDD.n14 0.0086448
R1267 VDD.n282 VDD.n17 0.0086448
R1268 VDD.n279 VDD.n17 0.0086448
R1269 VDD.n239 VDD.n238 0.00772851
R1270 VDD.n284 VDD.n283 0.00772851
R1271 VDD.n71 VDD.n33 0.00599774
R1272 VDD.n279 VDD.n278 0.00599774
R1273 VDD.n239 VDD.n35 0.00141629
R1274 VDD.n283 VDD.n282 0.00141629
R1275 VSS.n341 VSS.n252 12765
R1276 VSS.n353 VSS.n30 961.513
R1277 VSS.n419 VSS.n7 956.279
R1278 VSS.n341 VSS.n6 869.037
R1279 VSS.n252 VSS.n251 826.729
R1280 VSS.n411 VSS.n7 826.729
R1281 VSS.n251 VSS.n6 784.793
R1282 VSS.n344 VSS.n343 255.987
R1283 VSS.n418 VSS.n8 255.987
R1284 VSS.n345 VSS.n344 255.987
R1285 VSS.n418 VSS.n9 255.987
R1286 VSS.n419 VSS.n6 171.487
R1287 VSS.n421 VSS.n420 142.431
R1288 VSS.n420 VSS.n4 142.431
R1289 VSS.n129 VSS.n128 142.431
R1290 VSS.n129 VSS.n81 142.431
R1291 VSS.n30 VSS.n6 92.4769
R1292 VSS.n197 VSS.n196 24.363
R1293 VSS.n169 VSS.n168 24.363
R1294 VSS.n126 VSS.n83 15.5561
R1295 VSS.n120 VSS.n119 15.5561
R1296 VSS.n117 VSS.n88 15.5561
R1297 VSS.n113 VSS.n112 15.5561
R1298 VSS.n110 VSS.n94 15.5561
R1299 VSS.n106 VSS.n105 15.5561
R1300 VSS.n206 VSS.n205 15.5561
R1301 VSS.n215 VSS.n214 15.5561
R1302 VSS.n218 VSS.n217 15.5561
R1303 VSS.n232 VSS.n231 15.5561
R1304 VSS.n229 VSS.n42 15.5561
R1305 VSS.n249 VSS.n43 15.5561
R1306 VSS.n339 VSS.n36 15.5561
R1307 VSS.n260 VSS.n254 15.5561
R1308 VSS.n262 VSS.n261 15.5561
R1309 VSS.n267 VSS.n266 15.5561
R1310 VSS.n270 VSS.n269 15.5561
R1311 VSS.n275 VSS.n274 15.5561
R1312 VSS.n278 VSS.n277 15.5561
R1313 VSS.n283 VSS.n282 15.5561
R1314 VSS.n286 VSS.n285 15.5561
R1315 VSS.n291 VSS.n290 15.5561
R1316 VSS.n294 VSS.n293 15.5561
R1317 VSS.n299 VSS.n298 15.5561
R1318 VSS.n301 VSS.n8 15.5561
R1319 VSS.n351 VSS.n32 15.5561
R1320 VSS.n355 VSS.n29 15.5561
R1321 VSS.n410 VSS.n23 15.5561
R1322 VSS.n410 VSS.n24 15.5561
R1323 VSS.n361 VSS.n360 15.5561
R1324 VSS.n363 VSS.n362 15.5561
R1325 VSS.n366 VSS.n365 15.5561
R1326 VSS.n368 VSS.n367 15.5561
R1327 VSS.n372 VSS.n371 15.5561
R1328 VSS.n374 VSS.n373 15.5561
R1329 VSS.n378 VSS.n377 15.5561
R1330 VSS.n380 VSS.n379 15.5561
R1331 VSS.n413 VSS.n13 15.5561
R1332 VSS.n246 VSS.n245 12.5005
R1333 VSS.n162 VSS.n161 12.5005
R1334 VSS.n178 VSS.n155 12.5005
R1335 VSS.n180 VSS.n179 12.5005
R1336 VSS.n181 VSS.n153 12.5005
R1337 VSS.n182 VSS.n148 12.5005
R1338 VSS.n184 VSS.n183 12.5005
R1339 VSS.n150 VSS.n145 12.5005
R1340 VSS.n189 VSS.n140 12.5005
R1341 VSS.n191 VSS.n190 12.5005
R1342 VSS.n192 VSS.n138 12.5005
R1343 VSS.n194 VSS.n193 12.5005
R1344 VSS.n243 VSS.n45 12.5005
R1345 VSS.n241 VSS.n240 12.5005
R1346 VSS.n55 VSS.n51 12.5005
R1347 VSS.n224 VSS.n54 12.5005
R1348 VSS.n226 VSS.n225 12.5005
R1349 VSS.n222 VSS.n221 12.5005
R1350 VSS.n62 VSS.n60 12.5005
R1351 VSS.n212 VSS.n211 12.5005
R1352 VSS.n210 VSS.n209 12.5005
R1353 VSS.n72 VSS.n70 12.5005
R1354 VSS.n46 VSS.n0 12.1268
R1355 VSS.n77 VSS.n76 12.1268
R1356 VSS.n175 VSS.n174 12.1268
R1357 VSS.n141 VSS.n134 12.1268
R1358 Isum VSS.n424 11.9273
R1359 VSS.n70 VSS.n69 11.863
R1360 VSS.n210 VSS.n71 11.863
R1361 VSS.n60 VSS.n59 11.863
R1362 VSS.n222 VSS.n61 11.863
R1363 VSS.n224 VSS.n223 11.863
R1364 VSS.n51 VSS.n50 11.863
R1365 VSS.n243 VSS.n242 11.863
R1366 VSS.n245 VSS.n244 11.863
R1367 VSS.n193 VSS.n136 11.863
R1368 VSS.n192 VSS.n137 11.863
R1369 VSS.n140 VSS.n139 11.863
R1370 VSS.n150 VSS.n149 11.863
R1371 VSS.n182 VSS.n151 11.863
R1372 VSS.n181 VSS.n152 11.863
R1373 VSS.n155 VSS.n154 11.863
R1374 VSS.n161 VSS.n160 11.863
R1375 VSS.n198 VSS.n79 9.8285
R1376 VSS.n200 VSS.n79 9.8285
R1377 VSS.n171 VSS.n170 9.8285
R1378 VSS.n170 VSS.n167 9.8285
R1379 VSS.n247 VSS.n47 8.63568
R1380 VSS.n235 VSS.n234 8.63568
R1381 VSS.n220 VSS.n64 8.63568
R1382 VSS.n208 VSS.n74 8.63568
R1383 VSS.n177 VSS.n176 8.63568
R1384 VSS.n157 VSS.n156 8.63568
R1385 VSS.n188 VSS.n187 8.63568
R1386 VSS.n142 VSS.n135 8.63568
R1387 VSS.n240 VSS.n238 8.59884
R1388 VSS.n226 VSS.n58 8.59884
R1389 VSS.n212 VSS.n68 8.59884
R1390 VSS.n179 VSS.n159 8.59884
R1391 VSS.n185 VSS.n184 8.59884
R1392 VSS.n190 VSS.n144 8.59884
R1393 VSS.n210 VSS.n70 8.1765
R1394 VSS.n222 VSS.n60 8.1765
R1395 VSS.n224 VSS.n51 8.1765
R1396 VSS.n245 VSS.n243 8.1765
R1397 VSS.n193 VSS.n192 8.1765
R1398 VSS.n150 VSS.n140 8.1765
R1399 VSS.n182 VSS.n181 8.1765
R1400 VSS.n161 VSS.n155 8.1765
R1401 VSS.n257 VSS.n34 7.08143
R1402 VSS.n347 VSS.n34 7.08143
R1403 VSS.n417 VSS.n416 6.99336
R1404 VSS.n417 VSS.n10 6.99336
R1405 VSS.n100 VSS.n5 5.94383
R1406 VSS.n130 VSS.n80 5.94383
R1407 VSS.n5 VSS.n1 5.89523
R1408 VSS.n132 VSS.n130 5.89523
R1409 VSS.n422 VSS.n421 5.2005
R1410 VSS.n43 VSS.n2 5.2005
R1411 VSS.n249 VSS.n248 5.2005
R1412 VSS.n44 VSS.n42 5.2005
R1413 VSS.n230 VSS.n229 5.2005
R1414 VSS.n233 VSS.n232 5.2005
R1415 VSS.n231 VSS.n228 5.2005
R1416 VSS.n217 VSS.n56 5.2005
R1417 VSS.n219 VSS.n218 5.2005
R1418 VSS.n216 VSS.n215 5.2005
R1419 VSS.n214 VSS.n65 5.2005
R1420 VSS.n207 VSS.n206 5.2005
R1421 VSS.n205 VSS.n204 5.2005
R1422 VSS.n81 VSS.n75 5.2005
R1423 VSS.n101 VSS.n4 5.2005
R1424 VSS.n105 VSS.n102 5.2005
R1425 VSS.n107 VSS.n106 5.2005
R1426 VSS.n108 VSS.n94 5.2005
R1427 VSS.n110 VSS.n109 5.2005
R1428 VSS.n112 VSS.n92 5.2005
R1429 VSS.n114 VSS.n113 5.2005
R1430 VSS.n115 VSS.n88 5.2005
R1431 VSS.n117 VSS.n116 5.2005
R1432 VSS.n119 VSS.n86 5.2005
R1433 VSS.n121 VSS.n120 5.2005
R1434 VSS.n84 VSS.n83 5.2005
R1435 VSS.n126 VSS.n125 5.2005
R1436 VSS.n128 VSS.n82 5.2005
R1437 VSS.n343 VSS.n35 5.2005
R1438 VSS.n255 VSS.n36 5.2005
R1439 VSS.n339 VSS.n338 5.2005
R1440 VSS.n256 VSS.n254 5.2005
R1441 VSS.n334 VSS.n260 5.2005
R1442 VSS.n333 VSS.n261 5.2005
R1443 VSS.n332 VSS.n262 5.2005
R1444 VSS.n266 VSS.n263 5.2005
R1445 VSS.n328 VSS.n267 5.2005
R1446 VSS.n327 VSS.n269 5.2005
R1447 VSS.n326 VSS.n270 5.2005
R1448 VSS.n274 VSS.n271 5.2005
R1449 VSS.n322 VSS.n275 5.2005
R1450 VSS.n321 VSS.n277 5.2005
R1451 VSS.n320 VSS.n278 5.2005
R1452 VSS.n282 VSS.n279 5.2005
R1453 VSS.n316 VSS.n283 5.2005
R1454 VSS.n315 VSS.n285 5.2005
R1455 VSS.n314 VSS.n286 5.2005
R1456 VSS.n290 VSS.n287 5.2005
R1457 VSS.n310 VSS.n291 5.2005
R1458 VSS.n309 VSS.n293 5.2005
R1459 VSS.n308 VSS.n294 5.2005
R1460 VSS.n298 VSS.n295 5.2005
R1461 VSS.n304 VSS.n299 5.2005
R1462 VSS.n303 VSS.n301 5.2005
R1463 VSS.n302 VSS.n8 5.2005
R1464 VSS.n252 VSS.n8 5.2005
R1465 VSS.n415 VSS.n9 5.2005
R1466 VSS.n414 VSS.n413 5.2005
R1467 VSS.n13 VSS.n12 5.2005
R1468 VSS.n381 VSS.n380 5.2005
R1469 VSS.n385 VSS.n379 5.2005
R1470 VSS.n386 VSS.n378 5.2005
R1471 VSS.n387 VSS.n377 5.2005
R1472 VSS.n375 VSS.n374 5.2005
R1473 VSS.n391 VSS.n373 5.2005
R1474 VSS.n392 VSS.n372 5.2005
R1475 VSS.n393 VSS.n371 5.2005
R1476 VSS.n369 VSS.n368 5.2005
R1477 VSS.n397 VSS.n367 5.2005
R1478 VSS.n398 VSS.n366 5.2005
R1479 VSS.n399 VSS.n365 5.2005
R1480 VSS.n364 VSS.n363 5.2005
R1481 VSS.n403 VSS.n362 5.2005
R1482 VSS.n404 VSS.n361 5.2005
R1483 VSS.n405 VSS.n360 5.2005
R1484 VSS.n26 VSS.n24 5.2005
R1485 VSS.n410 VSS.n409 5.2005
R1486 VSS.n411 VSS.n410 5.2005
R1487 VSS.n25 VSS.n23 5.2005
R1488 VSS.n356 VSS.n355 5.2005
R1489 VSS.n29 VSS.n28 5.2005
R1490 VSS.n351 VSS.n350 5.2005
R1491 VSS.n33 VSS.n32 5.2005
R1492 VSS.n346 VSS.n345 5.2005
R1493 VSS.n201 VSS.n200 4.85463
R1494 VSS.n167 VSS.n166 4.85463
R1495 VSS.n198 VSS.n78 4.69811
R1496 VSS.n171 VSS.n165 4.69811
R1497 VSS.n125 VSS.n124 4.5005
R1498 VSS.n123 VSS.n84 4.5005
R1499 VSS.n122 VSS.n121 4.5005
R1500 VSS.n86 VSS.n85 4.5005
R1501 VSS.n116 VSS.n89 4.5005
R1502 VSS.n115 VSS.n90 4.5005
R1503 VSS.n114 VSS.n91 4.5005
R1504 VSS.n95 VSS.n92 4.5005
R1505 VSS.n109 VSS.n96 4.5005
R1506 VSS.n108 VSS.n97 4.5005
R1507 VSS.n107 VSS.n98 4.5005
R1508 VSS.n102 VSS.n99 4.5005
R1509 VSS.n101 VSS.n100 4.5005
R1510 VSS.n82 VSS.n80 4.5005
R1511 VSS.n172 VSS.n167 4.5005
R1512 VSS.n172 VSS.n171 4.5005
R1513 VSS.n200 VSS.n199 4.5005
R1514 VSS.n199 VSS.n198 4.5005
R1515 VSS.n204 VSS.n203 4.5005
R1516 VSS.n208 VSS.n207 4.5005
R1517 VSS.n66 VSS.n65 4.5005
R1518 VSS.n216 VSS.n213 4.5005
R1519 VSS.n220 VSS.n219 4.5005
R1520 VSS.n57 VSS.n56 4.5005
R1521 VSS.n228 VSS.n227 4.5005
R1522 VSS.n234 VSS.n233 4.5005
R1523 VSS.n230 VSS.n52 4.5005
R1524 VSS.n239 VSS.n44 4.5005
R1525 VSS.n248 VSS.n247 4.5005
R1526 VSS.n48 VSS.n2 4.5005
R1527 VSS.n423 VSS.n422 4.5005
R1528 VSS.n131 VSS.n75 4.5005
R1529 VSS.n257 VSS.n35 4.5005
R1530 VSS.n258 VSS.n255 4.5005
R1531 VSS.n338 VSS.n337 4.5005
R1532 VSS.n336 VSS.n256 4.5005
R1533 VSS.n335 VSS.n334 4.5005
R1534 VSS.n333 VSS.n259 4.5005
R1535 VSS.n332 VSS.n331 4.5005
R1536 VSS.n330 VSS.n263 4.5005
R1537 VSS.n329 VSS.n328 4.5005
R1538 VSS.n327 VSS.n264 4.5005
R1539 VSS.n326 VSS.n325 4.5005
R1540 VSS.n324 VSS.n271 4.5005
R1541 VSS.n323 VSS.n322 4.5005
R1542 VSS.n321 VSS.n272 4.5005
R1543 VSS.n320 VSS.n319 4.5005
R1544 VSS.n318 VSS.n279 4.5005
R1545 VSS.n317 VSS.n316 4.5005
R1546 VSS.n315 VSS.n280 4.5005
R1547 VSS.n314 VSS.n313 4.5005
R1548 VSS.n312 VSS.n287 4.5005
R1549 VSS.n311 VSS.n310 4.5005
R1550 VSS.n309 VSS.n288 4.5005
R1551 VSS.n308 VSS.n307 4.5005
R1552 VSS.n306 VSS.n295 4.5005
R1553 VSS.n305 VSS.n304 4.5005
R1554 VSS.n303 VSS.n296 4.5005
R1555 VSS.n302 VSS.n10 4.5005
R1556 VSS.n348 VSS.n33 4.5005
R1557 VSS.n350 VSS.n349 4.5005
R1558 VSS.n28 VSS.n27 4.5005
R1559 VSS.n357 VSS.n356 4.5005
R1560 VSS.n358 VSS.n25 4.5005
R1561 VSS.n409 VSS.n408 4.5005
R1562 VSS.n407 VSS.n26 4.5005
R1563 VSS.n406 VSS.n405 4.5005
R1564 VSS.n404 VSS.n359 4.5005
R1565 VSS.n403 VSS.n402 4.5005
R1566 VSS.n401 VSS.n364 4.5005
R1567 VSS.n400 VSS.n399 4.5005
R1568 VSS.n398 VSS 4.5005
R1569 VSS.n397 VSS.n396 4.5005
R1570 VSS.n395 VSS.n369 4.5005
R1571 VSS.n394 VSS.n393 4.5005
R1572 VSS.n392 VSS.n370 4.5005
R1573 VSS.n391 VSS.n390 4.5005
R1574 VSS.n389 VSS.n375 4.5005
R1575 VSS.n388 VSS.n387 4.5005
R1576 VSS.n386 VSS.n376 4.5005
R1577 VSS.n385 VSS.n384 4.5005
R1578 VSS.n383 VSS.n381 4.5005
R1579 VSS.n382 VSS.n12 4.5005
R1580 VSS.n414 VSS.n11 4.5005
R1581 VSS.n416 VSS.n415 4.5005
R1582 VSS.n347 VSS.n346 4.5005
R1583 VSS.n211 VSS.n210 4.0885
R1584 VSS.n211 VSS.n60 4.0885
R1585 VSS.n225 VSS.n222 4.0885
R1586 VSS.n225 VSS.n224 4.0885
R1587 VSS.n241 VSS.n51 4.0885
R1588 VSS.n243 VSS.n241 4.0885
R1589 VSS.n192 VSS.n191 4.0885
R1590 VSS.n191 VSS.n140 4.0885
R1591 VSS.n183 VSS.n150 4.0885
R1592 VSS.n183 VSS.n182 4.0885
R1593 VSS.n181 VSS.n180 4.0885
R1594 VSS.n180 VSS.n155 4.0885
R1595 VSS.n237 VSS.n47 3.5285
R1596 VSS.n47 VSS.n46 3.5285
R1597 VSS.n238 VSS.n236 3.5285
R1598 VSS.n238 VSS.n237 3.5285
R1599 VSS.n235 VSS.n53 3.5285
R1600 VSS.n236 VSS.n235 3.5285
R1601 VSS.n63 VSS.n58 3.5285
R1602 VSS.n58 VSS.n53 3.5285
R1603 VSS.n67 VSS.n64 3.5285
R1604 VSS.n64 VSS.n63 3.5285
R1605 VSS.n73 VSS.n68 3.5285
R1606 VSS.n68 VSS.n67 3.5285
R1607 VSS.n76 VSS.n74 3.5285
R1608 VSS.n74 VSS.n73 3.5285
R1609 VSS.n176 VSS.n163 3.5285
R1610 VSS.n176 VSS.n175 3.5285
R1611 VSS.n159 VSS.n158 3.5285
R1612 VSS.n163 VSS.n159 3.5285
R1613 VSS.n157 VSS.n147 3.5285
R1614 VSS.n158 VSS.n157 3.5285
R1615 VSS.n186 VSS.n185 3.5285
R1616 VSS.n185 VSS.n147 3.5285
R1617 VSS.n187 VSS.n146 3.5285
R1618 VSS.n187 VSS.n186 3.5285
R1619 VSS.n144 VSS.n143 3.5285
R1620 VSS.n146 VSS.n144 3.5285
R1621 VSS.n142 VSS.n141 3.5285
R1622 VSS.n143 VSS.n142 3.5285
R1623 VSS.n127 VSS.n126 3.11744
R1624 VSS.n120 VSS.n87 3.11744
R1625 VSS.n118 VSS.n117 3.11744
R1626 VSS.n113 VSS.n93 3.11744
R1627 VSS.n111 VSS.n110 3.11744
R1628 VSS.n106 VSS.n103 3.11744
R1629 VSS.n104 VSS.n4 3.11744
R1630 VSS.n205 VSS.n37 3.11744
R1631 VSS.n214 VSS.n38 3.11744
R1632 VSS.n218 VSS.n39 3.11744
R1633 VSS.n231 VSS.n40 3.11744
R1634 VSS.n229 VSS.n41 3.11744
R1635 VSS.n250 VSS.n249 3.11744
R1636 VSS.n421 VSS.n3 3.11744
R1637 VSS.n43 VSS.n3 3.11744
R1638 VSS.n250 VSS.n42 3.11744
R1639 VSS.n232 VSS.n41 3.11744
R1640 VSS.n217 VSS.n40 3.11744
R1641 VSS.n215 VSS.n39 3.11744
R1642 VSS.n206 VSS.n38 3.11744
R1643 VSS.n81 VSS.n37 3.11744
R1644 VSS.n105 VSS.n104 3.11744
R1645 VSS.n103 VSS.n94 3.11744
R1646 VSS.n112 VSS.n111 3.11744
R1647 VSS.n93 VSS.n88 3.11744
R1648 VSS.n119 VSS.n118 3.11744
R1649 VSS.n87 VSS.n83 3.11744
R1650 VSS.n128 VSS.n127 3.11744
R1651 VSS.n342 VSS.n36 3.11744
R1652 VSS.n340 VSS.n254 3.11744
R1653 VSS.n261 VSS.n253 3.11744
R1654 VSS.n265 VSS.n262 3.11744
R1655 VSS.n268 VSS.n267 3.11744
R1656 VSS.n273 VSS.n270 3.11744
R1657 VSS.n276 VSS.n275 3.11744
R1658 VSS.n281 VSS.n278 3.11744
R1659 VSS.n284 VSS.n283 3.11744
R1660 VSS.n289 VSS.n286 3.11744
R1661 VSS.n292 VSS.n291 3.11744
R1662 VSS.n297 VSS.n294 3.11744
R1663 VSS.n300 VSS.n299 3.11744
R1664 VSS.n343 VSS.n342 3.11744
R1665 VSS.n340 VSS.n339 3.11744
R1666 VSS.n260 VSS.n253 3.11744
R1667 VSS.n266 VSS.n265 3.11744
R1668 VSS.n269 VSS.n268 3.11744
R1669 VSS.n274 VSS.n273 3.11744
R1670 VSS.n277 VSS.n276 3.11744
R1671 VSS.n282 VSS.n281 3.11744
R1672 VSS.n285 VSS.n284 3.11744
R1673 VSS.n290 VSS.n289 3.11744
R1674 VSS.n293 VSS.n292 3.11744
R1675 VSS.n298 VSS.n297 3.11744
R1676 VSS.n301 VSS.n300 3.11744
R1677 VSS.n32 VSS.n31 3.11744
R1678 VSS.n352 VSS.n29 3.11744
R1679 VSS.n354 VSS.n23 3.11744
R1680 VSS.n360 VSS.n22 3.11744
R1681 VSS.n362 VSS.n21 3.11744
R1682 VSS.n365 VSS.n20 3.11744
R1683 VSS.n367 VSS.n19 3.11744
R1684 VSS.n371 VSS.n18 3.11744
R1685 VSS.n373 VSS.n17 3.11744
R1686 VSS.n377 VSS.n16 3.11744
R1687 VSS.n379 VSS.n15 3.11744
R1688 VSS.n14 VSS.n13 3.11744
R1689 VSS.n412 VSS.n9 3.11744
R1690 VSS.n413 VSS.n412 3.11744
R1691 VSS.n380 VSS.n14 3.11744
R1692 VSS.n378 VSS.n15 3.11744
R1693 VSS.n374 VSS.n16 3.11744
R1694 VSS.n372 VSS.n17 3.11744
R1695 VSS.n368 VSS.n18 3.11744
R1696 VSS.n366 VSS.n19 3.11744
R1697 VSS.n363 VSS.n20 3.11744
R1698 VSS.n361 VSS.n21 3.11744
R1699 VSS.n24 VSS.n22 3.11744
R1700 VSS.n355 VSS.n354 3.11744
R1701 VSS.n352 VSS.n351 3.11744
R1702 VSS.n345 VSS.n31 3.11744
R1703 VSS.n251 VSS.n3 1.04278
R1704 VSS.n251 VSS.n250 1.04278
R1705 VSS.n251 VSS.n41 1.04278
R1706 VSS.n251 VSS.n40 1.04278
R1707 VSS.n251 VSS.n39 1.04278
R1708 VSS.n251 VSS.n38 1.04278
R1709 VSS.n251 VSS.n37 1.04278
R1710 VSS.n104 VSS.n7 1.04278
R1711 VSS.n103 VSS.n7 1.04278
R1712 VSS.n111 VSS.n7 1.04278
R1713 VSS.n93 VSS.n7 1.04278
R1714 VSS.n118 VSS.n7 1.04278
R1715 VSS.n87 VSS.n7 1.04278
R1716 VSS.n127 VSS.n7 1.04278
R1717 VSS.n342 VSS.n341 1.04278
R1718 VSS.n341 VSS.n340 1.04278
R1719 VSS.n341 VSS.n253 1.04278
R1720 VSS.n265 VSS.n252 1.04278
R1721 VSS.n268 VSS.n252 1.04278
R1722 VSS.n273 VSS.n252 1.04278
R1723 VSS.n276 VSS.n252 1.04278
R1724 VSS.n281 VSS.n252 1.04278
R1725 VSS.n284 VSS.n252 1.04278
R1726 VSS.n289 VSS.n252 1.04278
R1727 VSS.n292 VSS.n252 1.04278
R1728 VSS.n297 VSS.n252 1.04278
R1729 VSS.n300 VSS.n252 1.04278
R1730 VSS.n412 VSS.n411 1.04278
R1731 VSS.n411 VSS.n14 1.04278
R1732 VSS.n411 VSS.n15 1.04278
R1733 VSS.n411 VSS.n16 1.04278
R1734 VSS.n411 VSS.n17 1.04278
R1735 VSS.n411 VSS.n18 1.04278
R1736 VSS.n411 VSS.n19 1.04278
R1737 VSS.n411 VSS.n20 1.04278
R1738 VSS.n411 VSS.n21 1.04278
R1739 VSS.n411 VSS.n22 1.04278
R1740 VSS.n354 VSS.n353 1.04278
R1741 VSS.n353 VSS.n352 1.04278
R1742 VSS.n353 VSS.n31 1.04278
R1743 VSS.n134 VSS.n133 0.732757
R1744 VSS.n174 VSS.n173 0.732757
R1745 VSS.n133 VSS.n132 0.716145
R1746 VSS.n173 VSS.n1 0.716145
R1747 VSS.n420 VSS.n5 0.217167
R1748 VSS.n420 VSS.n419 0.217167
R1749 VSS.n130 VSS.n129 0.217167
R1750 VSS.n129 VSS.n30 0.217167
R1751 VSS.n346 VSS.n33 0.1445
R1752 VSS.n350 VSS.n33 0.1445
R1753 VSS.n350 VSS.n28 0.1445
R1754 VSS.n356 VSS.n28 0.1445
R1755 VSS.n356 VSS.n25 0.1445
R1756 VSS.n409 VSS.n25 0.1445
R1757 VSS.n409 VSS.n26 0.1445
R1758 VSS.n405 VSS.n26 0.1445
R1759 VSS.n405 VSS.n404 0.1445
R1760 VSS.n404 VSS.n403 0.1445
R1761 VSS.n403 VSS.n364 0.1445
R1762 VSS.n399 VSS.n364 0.1445
R1763 VSS.n399 VSS.n398 0.1445
R1764 VSS.n398 VSS.n397 0.1445
R1765 VSS.n397 VSS.n369 0.1445
R1766 VSS.n393 VSS.n369 0.1445
R1767 VSS.n393 VSS.n392 0.1445
R1768 VSS.n392 VSS.n391 0.1445
R1769 VSS.n391 VSS.n375 0.1445
R1770 VSS.n387 VSS.n375 0.1445
R1771 VSS.n387 VSS.n386 0.1445
R1772 VSS.n386 VSS.n385 0.1445
R1773 VSS.n385 VSS.n381 0.1445
R1774 VSS.n381 VSS.n12 0.1445
R1775 VSS.n414 VSS.n12 0.1445
R1776 VSS.n415 VSS.n414 0.1445
R1777 VSS.n125 VSS.n82 0.1445
R1778 VSS.n125 VSS.n84 0.1445
R1779 VSS.n121 VSS.n84 0.1445
R1780 VSS.n121 VSS.n86 0.1445
R1781 VSS.n116 VSS.n86 0.1445
R1782 VSS.n116 VSS.n115 0.1445
R1783 VSS.n115 VSS.n114 0.1445
R1784 VSS.n114 VSS.n92 0.1445
R1785 VSS.n109 VSS.n92 0.1445
R1786 VSS.n109 VSS.n108 0.1445
R1787 VSS.n108 VSS.n107 0.1445
R1788 VSS.n107 VSS.n102 0.1445
R1789 VSS.n102 VSS.n101 0.1445
R1790 VSS.n124 VSS.n80 0.1445
R1791 VSS.n124 VSS.n123 0.1445
R1792 VSS.n123 VSS.n122 0.1445
R1793 VSS.n122 VSS.n85 0.1445
R1794 VSS.n89 VSS.n85 0.1445
R1795 VSS.n90 VSS.n89 0.1445
R1796 VSS.n91 VSS.n90 0.1445
R1797 VSS.n95 VSS.n91 0.1445
R1798 VSS.n96 VSS.n95 0.1445
R1799 VSS.n97 VSS.n96 0.1445
R1800 VSS.n98 VSS.n97 0.1445
R1801 VSS.n99 VSS.n98 0.1445
R1802 VSS.n100 VSS.n99 0.1445
R1803 VSS.n204 VSS.n75 0.1445
R1804 VSS.n207 VSS.n204 0.1445
R1805 VSS.n207 VSS.n65 0.1445
R1806 VSS.n216 VSS.n65 0.1445
R1807 VSS.n219 VSS.n216 0.1445
R1808 VSS.n219 VSS.n56 0.1445
R1809 VSS.n228 VSS.n56 0.1445
R1810 VSS.n233 VSS.n228 0.1445
R1811 VSS.n233 VSS.n230 0.1445
R1812 VSS.n230 VSS.n44 0.1445
R1813 VSS.n248 VSS.n44 0.1445
R1814 VSS.n248 VSS.n2 0.1445
R1815 VSS.n422 VSS.n2 0.1445
R1816 VSS.n255 VSS.n35 0.1445
R1817 VSS.n338 VSS.n255 0.1445
R1818 VSS.n338 VSS.n256 0.1445
R1819 VSS.n334 VSS.n256 0.1445
R1820 VSS.n334 VSS.n333 0.1445
R1821 VSS.n333 VSS.n332 0.1445
R1822 VSS.n332 VSS.n263 0.1445
R1823 VSS.n328 VSS.n263 0.1445
R1824 VSS.n328 VSS.n327 0.1445
R1825 VSS.n327 VSS.n326 0.1445
R1826 VSS.n326 VSS.n271 0.1445
R1827 VSS.n322 VSS.n271 0.1445
R1828 VSS.n322 VSS.n321 0.1445
R1829 VSS.n321 VSS.n320 0.1445
R1830 VSS.n320 VSS.n279 0.1445
R1831 VSS.n316 VSS.n279 0.1445
R1832 VSS.n316 VSS.n315 0.1445
R1833 VSS.n315 VSS.n314 0.1445
R1834 VSS.n314 VSS.n287 0.1445
R1835 VSS.n310 VSS.n287 0.1445
R1836 VSS.n310 VSS.n309 0.1445
R1837 VSS.n309 VSS.n308 0.1445
R1838 VSS.n308 VSS.n295 0.1445
R1839 VSS.n304 VSS.n295 0.1445
R1840 VSS.n304 VSS.n303 0.1445
R1841 VSS.n303 VSS.n302 0.1445
R1842 VSS.n258 VSS.n257 0.1445
R1843 VSS.n337 VSS.n258 0.1445
R1844 VSS.n337 VSS.n336 0.1445
R1845 VSS.n336 VSS.n335 0.1445
R1846 VSS.n335 VSS.n259 0.1445
R1847 VSS.n331 VSS.n259 0.1445
R1848 VSS.n331 VSS.n330 0.1445
R1849 VSS.n330 VSS.n329 0.1445
R1850 VSS.n329 VSS.n264 0.1445
R1851 VSS.n325 VSS.n264 0.1445
R1852 VSS.n325 VSS.n324 0.1445
R1853 VSS.n324 VSS.n323 0.1445
R1854 VSS.n323 VSS.n272 0.1445
R1855 VSS.n319 VSS.n272 0.1445
R1856 VSS.n319 VSS.n318 0.1445
R1857 VSS.n318 VSS.n317 0.1445
R1858 VSS.n317 VSS.n280 0.1445
R1859 VSS.n313 VSS.n280 0.1445
R1860 VSS.n313 VSS.n312 0.1445
R1861 VSS.n312 VSS.n311 0.1445
R1862 VSS.n311 VSS.n288 0.1445
R1863 VSS.n307 VSS.n288 0.1445
R1864 VSS.n307 VSS.n306 0.1445
R1865 VSS.n306 VSS.n305 0.1445
R1866 VSS.n305 VSS.n296 0.1445
R1867 VSS.n296 VSS.n10 0.1445
R1868 VSS.n348 VSS.n347 0.1445
R1869 VSS.n349 VSS.n348 0.1445
R1870 VSS.n349 VSS.n27 0.1445
R1871 VSS.n357 VSS.n27 0.1445
R1872 VSS.n358 VSS.n357 0.1445
R1873 VSS.n408 VSS.n358 0.1445
R1874 VSS.n408 VSS.n407 0.1445
R1875 VSS.n407 VSS.n406 0.1445
R1876 VSS.n406 VSS.n359 0.1445
R1877 VSS.n402 VSS.n359 0.1445
R1878 VSS.n402 VSS.n401 0.1445
R1879 VSS.n401 VSS.n400 0.1445
R1880 VSS.n400 VSS 0.1445
R1881 VSS.n396 VSS 0.1445
R1882 VSS.n396 VSS.n395 0.1445
R1883 VSS.n395 VSS.n394 0.1445
R1884 VSS.n394 VSS.n370 0.1445
R1885 VSS.n390 VSS.n370 0.1445
R1886 VSS.n390 VSS.n389 0.1445
R1887 VSS.n389 VSS.n388 0.1445
R1888 VSS.n388 VSS.n376 0.1445
R1889 VSS.n384 VSS.n376 0.1445
R1890 VSS.n384 VSS.n383 0.1445
R1891 VSS.n383 VSS.n382 0.1445
R1892 VSS.n382 VSS.n11 0.1445
R1893 VSS.n416 VSS.n11 0.1445
R1894 VSS.n418 VSS.n417 0.111138
R1895 VSS.n419 VSS.n418 0.111138
R1896 VSS.n344 VSS.n34 0.111138
R1897 VSS.n344 VSS.n30 0.111138
R1898 VSS.n172 VSS.n169 0.0424731
R1899 VSS.n199 VSS.n197 0.0424731
R1900 VSS.n166 VSS.n165 0.032787
R1901 VSS.n201 VSS.n78 0.032787
R1902 VSS.n166 VSS.n49 0.0315762
R1903 VSS.n169 VSS.n164 0.0315762
R1904 VSS.n202 VSS.n201 0.0315762
R1905 VSS.n197 VSS.n195 0.0315762
R1906 VSS.n173 VSS.n165 0.0265314
R1907 VSS.n133 VSS.n78 0.0265314
R1908 VSS.n190 VSS.n138 0.0203347
R1909 VSS.n190 VSS.n189 0.0203347
R1910 VSS.n184 VSS.n145 0.0203347
R1911 VSS.n184 VSS.n148 0.0203347
R1912 VSS.n179 VSS.n153 0.0203347
R1913 VSS.n179 VSS.n178 0.0203347
R1914 VSS.n173 VSS.n172 0.0168453
R1915 VSS.n199 VSS.n133 0.0168453
R1916 VSS.n195 VSS.n134 0.0115331
R1917 VSS.n174 VSS.n164 0.0115331
R1918 VSS.n194 VSS.n135 0.0104174
R1919 VSS.n138 VSS.n135 0.0104174
R1920 VSS.n189 VSS.n188 0.0104174
R1921 VSS.n188 VSS.n145 0.0104174
R1922 VSS.n156 VSS.n148 0.0104174
R1923 VSS.n156 VSS.n153 0.0104174
R1924 VSS.n178 VSS.n177 0.0104174
R1925 VSS.n177 VSS.n162 0.0104174
R1926 VSS.n195 VSS.n194 0.00930165
R1927 VSS.n164 VSS.n162 0.00930165
R1928 VSS.n131 VSS.n77 0.0086448
R1929 VSS.n203 VSS.n77 0.0086448
R1930 VSS.n208 VSS.n72 0.0086448
R1931 VSS.n209 VSS.n208 0.0086448
R1932 VSS.n209 VSS.n66 0.0086448
R1933 VSS.n212 VSS.n66 0.0086448
R1934 VSS.n213 VSS.n212 0.0086448
R1935 VSS.n213 VSS.n62 0.0086448
R1936 VSS.n220 VSS.n62 0.0086448
R1937 VSS.n221 VSS.n220 0.0086448
R1938 VSS.n221 VSS.n57 0.0086448
R1939 VSS.n226 VSS.n57 0.0086448
R1940 VSS.n227 VSS.n226 0.0086448
R1941 VSS.n227 VSS.n54 0.0086448
R1942 VSS.n234 VSS.n54 0.0086448
R1943 VSS.n234 VSS.n55 0.0086448
R1944 VSS.n55 VSS.n52 0.0086448
R1945 VSS.n240 VSS.n52 0.0086448
R1946 VSS.n240 VSS.n239 0.0086448
R1947 VSS.n239 VSS.n45 0.0086448
R1948 VSS.n247 VSS.n45 0.0086448
R1949 VSS.n247 VSS.n246 0.0086448
R1950 VSS.n48 VSS.n0 0.0086448
R1951 VSS.n202 VSS.n72 0.00772851
R1952 VSS.n246 VSS.n49 0.00772851
R1953 VSS.n132 VSS.n131 0.00599774
R1954 VSS.n423 VSS.n1 0.00599774
R1955 VSS.n424 VSS.n423 0.00497964
R1956 VSS.n424 VSS.n0 0.00416516
R1957 VSS.n203 VSS.n202 0.00141629
R1958 VSS.n49 VSS.n48 0.00141629
C0 VDD VT 0.56086f
C1 VDD Isyn 2.07811f
C2 VDD a_n90_4665# 4.57155f
C3 a_n90_4665# Isum 2.31447f
C4 VDD Isum 7.16994f
C5 Vthr VSS 6.53568f
C6 Isyn VSS 5.70776f
C7 VT VSS 5.79402f
C8 Isum VSS 16.35442f
C9 VDD VSS 49.12919f
C10 a_n90_4665# VSS 13.337f
C11 VDD.t51 VSS 9.57087f
C12 Isum.n66 VSS 0.72815f
C13 Isum.n208 VSS 0.91981f
C14 Isum.n347 VSS 0.67362f
C15 Isum.n348 VSS 4.02338f
C16 Isum.n349 VSS 0.89282f
.ends
