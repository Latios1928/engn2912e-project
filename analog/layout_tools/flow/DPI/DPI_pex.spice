* NGSPICE file created from DPI_flat.ext - technology: gf180mcuD

.subckt DPI_flat Vthr Isum Isyn VT VSS VDD
X0 Isum.t7 Isum.t5 Isum.t7 Isum.t6 nfet_03v3 ad=0.14p pd=1.06u as=0 ps=0 w=0.5u l=0.64u
X1 Isum.t22 Isum.t20 Isum.t22 Isum.t21 nfet_03v3 ad=0.14p pd=1.06u as=0 ps=0 w=0.5u l=0.64u
X2 Isum.t33 Isum.t32 Isum.t33 Isum.t3 nfet_03v3 ad=0.3p pd=2.2u as=0 ps=0 w=0.5u l=0.64u
X3 VDD.t51 a_n90_4665# cap_mim_2f0_m4m5_noshield c_width=22.18u c_length=22.18u
X4 VDD.t23 VDD.t21 VDD.t23 VDD.t22 pfet_03v3 ad=0.14p pd=1.06u as=0 ps=0 w=0.5u l=0.64u
X5 VDD.t40 VDD.t39 VDD.t40 VDD.t13 pfet_03v3 ad=0.14p pd=1.06u as=0 ps=0 w=0.5u l=0.64u
X6 VDD.t48 VDD.t47 VDD.t48 VDD.t25 pfet_03v3 ad=0.14p pd=1.06u as=0 ps=0 w=0.5u l=0.64u
X7 Isum.t28 Isum.t26 Isum.t28 Isum.t27 nfet_03v3 ad=0.3p pd=2.2u as=0 ps=0 w=0.5u l=0.64u
X8 a_n90_4665# a_n90_4665# Isum.t49 Isum.t48 nfet_03v3 ad=0.3p pd=2.2u as=0.3p ps=2.2u w=0.5u l=0.64u
X9 VDD.t8 VDD.t6 VDD.t8 VDD.t7 pfet_03v3 ad=0.14p pd=1.06u as=0 ps=0 w=0.5u l=0.64u
X10 VDD.t2 VT a_n90_4665# VDD.t1 pfet_03v3 ad=0.3p pd=2.2u as=0.3p ps=2.2u w=0.5u l=0.64u
X11 VDD.t34 VDD.t33 VDD.t34 VDD.t4 pfet_03v3 ad=0.3p pd=2.2u as=0 ps=0 w=0.5u l=0.64u
X12 VDD.t32 VDD.t30 VDD.t32 VDD.t31 pfet_03v3 ad=0.3p pd=2.2u as=0 ps=0 w=0.5u l=0.64u
X13 Isum.t43 Isum.t42 Isum.t43 Isum.t18 nfet_03v3 ad=0.14p pd=1.06u as=0 ps=0 w=0.5u l=0.64u
X14 Isum.t13 Isum.t11 Isum.t13 Isum.t12 nfet_03v3 ad=0.14p pd=1.06u as=0 ps=0 w=0.5u l=0.64u
X15 Isum.t19 Isum.t17 Isum.t19 Isum.t18 nfet_03v3 ad=0.14p pd=1.06u as=0 ps=0 w=0.5u l=0.64u
X16 Isum.t45 Isum.t44 Isum.t45 Isum.t21 nfet_03v3 ad=0.14p pd=1.06u as=0 ps=0 w=0.5u l=0.64u
X17 VDD.t29 VDD.t27 VDD.t29 VDD.t28 pfet_03v3 ad=0.3p pd=2.2u as=0 ps=0 w=0.5u l=0.64u
X18 VDD.t38 VDD.t37 VDD.t38 VDD.t10 pfet_03v3 ad=0.14p pd=1.06u as=0 ps=0 w=0.5u l=0.64u
X19 Isum.t25 Isum.t23 Isum.t25 Isum.t24 nfet_03v3 ad=0.14p pd=1.06u as=0 ps=0 w=0.5u l=0.64u
X20 VDD.t14 VDD.t12 VDD.t14 VDD.t13 pfet_03v3 ad=0.14p pd=1.06u as=0 ps=0 w=0.5u l=0.64u
X21 VDD.t26 VDD.t24 VDD.t26 VDD.t25 pfet_03v3 ad=0.14p pd=1.06u as=0 ps=0 w=0.5u l=0.64u
X22 VDD.t50 a_n90_4665# Isyn.t0 VDD.t49 pfet_03v3 ad=0.3p pd=2.2u as=0.3p ps=2.2u w=0.5u l=0.64u
X23 VDD.t42 VDD.t41 VDD.t42 VDD.t16 pfet_03v3 ad=0.14p pd=1.06u as=0 ps=0 w=0.5u l=0.64u
X24 Isum.t31 Isum.t29 Isum.t31 Isum.t30 nfet_03v3 ad=0.3p pd=2.2u as=0 ps=0 w=0.5u l=0.64u
X25 VDD.t5 VDD.t3 VDD.t5 VDD.t4 pfet_03v3 ad=0.3p pd=2.2u as=0 ps=0 w=0.5u l=0.64u
X26 VDD.t44 VDD.t43 VDD.t44 VDD.t19 pfet_03v3 ad=0.14p pd=1.06u as=0 ps=0 w=0.5u l=0.64u
X27 VDD.t0 Vthr Isum.t1 Isum.t0 nfet_03v3 ad=0.3p pd=2.2u as=0.3p ps=2.2u w=0.5u l=0.64u
X28 Isum.t37 Isum.t36 Isum.t37 Isum.t9 nfet_03v3 ad=0.14p pd=1.06u as=0 ps=0 w=0.5u l=0.64u
X29 Isum.t47 Isum.t46 Isum.t47 Isum.t24 nfet_03v3 ad=0.14p pd=1.06u as=0 ps=0 w=0.5u l=0.64u
X30 VDD.t11 VDD.t9 VDD.t11 VDD.t10 pfet_03v3 ad=0.14p pd=1.06u as=0 ps=0 w=0.5u l=0.64u
X31 VDD.t17 VDD.t15 VDD.t17 VDD.t16 pfet_03v3 ad=0.14p pd=1.06u as=0 ps=0 w=0.5u l=0.64u
X32 Isum.t35 Isum.t34 Isum.t35 Isum.t6 nfet_03v3 ad=0.14p pd=1.06u as=0 ps=0 w=0.5u l=0.64u
X33 Isum.t4 Isum.t2 Isum.t4 Isum.t3 nfet_03v3 ad=0.3p pd=2.2u as=0 ps=0 w=0.5u l=0.64u
X34 VDD.t20 VDD.t18 VDD.t20 VDD.t19 pfet_03v3 ad=0.14p pd=1.06u as=0 ps=0 w=0.5u l=0.64u
X35 VDD.t46 VDD.t45 VDD.t46 VDD.t22 pfet_03v3 ad=0.14p pd=1.06u as=0 ps=0 w=0.5u l=0.64u
X36 Isum.t39 Isum.t38 Isum.t39 Isum.t12 nfet_03v3 ad=0.14p pd=1.06u as=0 ps=0 w=0.5u l=0.64u
X37 VDD.t36 VDD.t35 VDD.t36 VDD.t7 pfet_03v3 ad=0.14p pd=1.06u as=0 ps=0 w=0.5u l=0.64u
X38 Isum.t10 Isum.t8 Isum.t10 Isum.t9 nfet_03v3 ad=0.14p pd=1.06u as=0 ps=0 w=0.5u l=0.64u
X39 Isum.t16 Isum.t14 Isum.t16 Isum.t15 nfet_03v3 ad=0.14p pd=1.06u as=0 ps=0 w=0.5u l=0.64u
X40 Isum.t41 Isum.t40 Isum.t41 Isum.t15 nfet_03v3 ad=0.14p pd=1.06u as=0 ps=0 w=0.5u l=0.64u
R0 Isyn Isyn.t0 24.321
R1 Isum.n347 Isum.n346 29675.6
R2 Isum.n345 Isum.n64 255.987
R3 Isum.n349 Isum.n61 255.987
R4 Isum.n62 Isum.n61 255.987
R5 Isum.n345 Isum.n65 255.987
R6 Isum.n346 Isum.n63 151.605
R7 Isum.n329 Isum.n87 142.431
R8 Isum.n364 Isum.n38 142.431
R9 Isum.n329 Isum.n88 142.431
R10 Isum.n40 Isum.n38 142.431
R11 Isum.n348 Isum.n347 131.601
R12 Isum.n72 Isum.n63 84.2247
R13 Isum.n338 Isum.n72 84.2247
R14 Isum.n338 Isum.n73 84.2247
R15 Isum.n332 Isum.n73 84.2247
R16 Isum.n332 Isum.n331 84.2247
R17 Isum.n356 Isum.n51 84.2247
R18 Isum.n356 Isum.n355 84.2247
R19 Isum.n355 Isum.n354 84.2247
R20 Isum.n354 Isum.n55 84.2247
R21 Isum.n348 Isum.n55 84.2247
R22 Isum.n330 Isum.n86 75.8023
R23 Isum.n362 Isum.n42 75.8023
R24 Isum.n138 Isum.n86 42.1126
R25 Isum.n146 Isum.n138 42.1126
R26 Isum.n168 Isum.n133 42.1126
R27 Isum.n180 Isum.n133 42.1126
R28 Isum.n179 Isum.n137 42.1126
R29 Isum.n137 Isum.n136 42.1126
R30 Isum.n191 Isum.n190 42.1126
R31 Isum.n384 Isum.n6 42.1126
R32 Isum.n384 Isum.n7 42.1126
R33 Isum.n102 Isum.n101 42.1126
R34 Isum.n377 Isum.n18 42.1126
R35 Isum.n264 Isum.n18 42.1126
R36 Isum.n295 Isum.n262 42.1126
R37 Isum.n304 Isum.n262 42.1126
R38 Isum.n363 Isum.n39 42.1126
R39 Isum.n363 Isum.n362 42.1126
R40 Isum.n191 Isum.t48 38.9542
R41 Isum.n102 Isum.t0 38.9542
R42 Isum.n146 Isum.t30 30.5318
R43 Isum.t27 Isum.n39 30.5318
R44 Isum.n34 Isum.t49 26.3413
R45 Isum.n34 Isum.t1 25.7761
R46 Isum.n221 Isum.t29 24.363
R47 Isum.n253 Isum.t26 24.363
R48 Isum.n169 Isum.t24 21.0565
R49 Isum.t24 Isum.n168 21.0565
R50 Isum.n180 Isum.t21 21.0565
R51 Isum.t21 Isum.n179 21.0565
R52 Isum.n136 Isum.t18 21.0565
R53 Isum.n189 Isum.t18 21.0565
R54 Isum.n190 Isum.t15 21.0565
R55 Isum.t15 Isum.n6 21.0565
R56 Isum.t12 Isum.n7 21.0565
R57 Isum.n101 Isum.t12 21.0565
R58 Isum.n378 Isum.t9 21.0565
R59 Isum.t9 Isum.n377 21.0565
R60 Isum.t6 Isum.n264 21.0565
R61 Isum.n295 Isum.t6 21.0565
R62 Isum.t3 Isum.n304 21.0565
R63 Isum.n305 Isum.t3 21.0565
R64 Isum.n347 Isum.n61 20.1144
R65 Isum.n74 Isum.n64 15.5561
R66 Isum.n337 Isum.n74 15.5561
R67 Isum.n337 Isum.n75 15.5561
R68 Isum.n333 Isum.n75 15.5561
R69 Isum.n333 Isum.n83 15.5561
R70 Isum.n139 Isum.n83 15.5561
R71 Isum.n145 Isum.n139 15.5561
R72 Isum.n145 Isum.n132 15.5561
R73 Isum.n181 Isum.n132 15.5561
R74 Isum.n181 Isum.n128 15.5561
R75 Isum.n188 Isum.n128 15.5561
R76 Isum.n188 Isum.n8 15.5561
R77 Isum.n383 Isum.n8 15.5561
R78 Isum.n383 Isum.n9 15.5561
R79 Isum.n379 Isum.n9 15.5561
R80 Isum.n379 Isum.n15 15.5561
R81 Isum.n296 Isum.n15 15.5561
R82 Isum.n303 Isum.n296 15.5561
R83 Isum.n303 Isum.n43 15.5561
R84 Isum.n361 Isum.n43 15.5561
R85 Isum.n361 Isum.n44 15.5561
R86 Isum.n357 Isum.n44 15.5561
R87 Isum.n357 Isum.n50 15.5561
R88 Isum.n353 Isum.n50 15.5561
R89 Isum.n353 Isum.n56 15.5561
R90 Isum.n349 Isum.n56 15.5561
R91 Isum.n68 Isum.n65 15.5561
R92 Isum.n339 Isum.n68 15.5561
R93 Isum.n339 Isum.n71 15.5561
R94 Isum.n84 Isum.n71 15.5561
R95 Isum.n85 Isum.n84 15.5561
R96 Isum.n154 Isum.n85 15.5561
R97 Isum.n154 Isum.n147 15.5561
R98 Isum.n167 Isum.n147 15.5561
R99 Isum.n167 Isum.n134 15.5561
R100 Isum.n163 Isum.n134 15.5561
R101 Isum.n163 Isum.n127 15.5561
R102 Isum.n127 Isum.n4 15.5561
R103 Isum.n385 Isum.n4 15.5561
R104 Isum.n385 Isum.n5 15.5561
R105 Isum.n16 Isum.n5 15.5561
R106 Isum.n265 Isum.n16 15.5561
R107 Isum.n294 Isum.n265 15.5561
R108 Isum.n294 Isum.n263 15.5561
R109 Isum.n290 Isum.n263 15.5561
R110 Isum.n290 Isum.n41 15.5561
R111 Isum.n287 Isum.n41 15.5561
R112 Isum.n287 Isum.n52 15.5561
R113 Isum.n53 Isum.n52 15.5561
R114 Isum.n54 Isum.n53 15.5561
R115 Isum.n282 Isum.n54 15.5561
R116 Isum.n282 Isum.n62 15.5561
R117 Isum.n170 Isum.n87 15.5561
R118 Isum.n177 Isum.n170 15.5561
R119 Isum.n178 Isum.n177 15.5561
R120 Isum.n178 Isum.n126 15.5561
R121 Isum.n192 Isum.n126 15.5561
R122 Isum.n201 Isum.n192 15.5561
R123 Isum.n202 Isum.n201 15.5561
R124 Isum.n202 Isum.n19 15.5561
R125 Isum.n376 Isum.n19 15.5561
R126 Isum.n376 Isum.n20 15.5561
R127 Isum.n261 Isum.n20 15.5561
R128 Isum.n261 Isum.n33 15.5561
R129 Isum.n364 Isum.n33 15.5561
R130 Isum.n91 Isum.n88 15.5561
R131 Isum.n92 Isum.n91 15.5561
R132 Isum.n135 Isum.n92 15.5561
R133 Isum.n135 Isum.n95 15.5561
R134 Isum.n96 Isum.n95 15.5561
R135 Isum.n97 Isum.n96 15.5561
R136 Isum.n100 Isum.n97 15.5561
R137 Isum.n103 Isum.n100 15.5561
R138 Isum.n103 Isum.n17 15.5561
R139 Isum.n104 Isum.n17 15.5561
R140 Isum.n260 Isum.n104 15.5561
R141 Isum.n306 Isum.n260 15.5561
R142 Isum.n306 Isum.n40 15.5561
R143 Isum.n370 Isum.n369 12.5005
R144 Isum.n251 Isum.n250 12.5005
R145 Isum.n249 Isum.n248 12.5005
R146 Isum.n247 Isum.n110 12.5005
R147 Isum.n240 Isum.n111 12.5005
R148 Isum.n242 Isum.n241 12.5005
R149 Isum.n239 Isum.n112 12.5005
R150 Isum.n238 Isum.n237 12.5005
R151 Isum.n114 Isum.n113 12.5005
R152 Isum.n232 Isum.n231 12.5005
R153 Isum.n230 Isum.n115 12.5005
R154 Isum.n229 Isum.n228 12.5005
R155 Isum.n371 Isum.n27 12.5005
R156 Isum.n373 Isum.n372 12.5005
R157 Isum.n26 Isum.n23 12.5005
R158 Isum.n200 Isum.n196 12.5005
R159 Isum.n206 Isum.n205 12.5005
R160 Isum.n208 Isum.n207 12.5005
R161 Isum.n124 Isum.n121 12.5005
R162 Isum.n214 Isum.n213 12.5005
R163 Isum.n215 Isum.n120 12.5005
R164 Isum.n217 Isum.n216 12.5005
R165 Isum.n31 Isum.t4 12.1268
R166 Isum.n172 Isum.t25 12.1268
R167 Isum.t33 Isum.n106 12.1268
R168 Isum.t47 Isum.n225 12.1268
R169 Isum.n216 Isum.t23 11.863
R170 Isum.n215 Isum.t20 11.863
R171 Isum.n121 Isum.t17 11.863
R172 Isum.n207 Isum.t14 11.863
R173 Isum.n196 Isum.t11 11.863
R174 Isum.n26 Isum.t8 11.863
R175 Isum.n371 Isum.t5 11.863
R176 Isum.n370 Isum.t2 11.863
R177 Isum.n229 Isum.t46 11.863
R178 Isum.n230 Isum.t44 11.863
R179 Isum.n113 Isum.t42 11.863
R180 Isum.n238 Isum.t40 11.863
R181 Isum.n241 Isum.t38 11.863
R182 Isum.n240 Isum.t36 11.863
R183 Isum.n249 Isum.t34 11.863
R184 Isum.n250 Isum.t32 11.863
R185 Isum.n169 Isum.t30 11.5813
R186 Isum.n305 Isum.t27 11.5813
R187 Isum.n36 Isum.n35 10.2173
R188 Isum.n222 Isum.t31 9.8285
R189 Isum.t31 Isum.n220 9.8285
R190 Isum.n254 Isum.t28 9.8285
R191 Isum.t28 Isum.n108 9.8285
R192 Isum.n30 Isum.n28 8.63568
R193 Isum.n199 Isum.n198 8.63568
R194 Isum.n209 Isum.n194 8.63568
R195 Isum.n171 Isum.n119 8.63568
R196 Isum.n245 Isum.n109 8.63568
R197 Isum.n244 Isum.n243 8.63568
R198 Isum.n236 Isum.n235 8.63568
R199 Isum.n227 Isum.n226 8.63568
R200 Isum.n373 Isum.n24 8.59884
R201 Isum.n205 Isum.n197 8.59884
R202 Isum.n213 Isum.n123 8.59884
R203 Isum.n247 Isum.n246 8.59884
R204 Isum.n234 Isum.n112 8.59884
R205 Isum.n233 Isum.n232 8.59884
R206 Isum.n331 Isum.n330 8.42292
R207 Isum.n51 Isum.n42 8.42292
R208 Isum.n216 Isum.n215 8.1765
R209 Isum.n207 Isum.n121 8.1765
R210 Isum.n196 Isum.n26 8.1765
R211 Isum.n371 Isum.n370 8.1765
R212 Isum.n230 Isum.n229 8.1765
R213 Isum.n238 Isum.n113 8.1765
R214 Isum.n241 Isum.n240 8.1765
R215 Isum.n250 Isum.n249 8.1765
R216 Isum.n344 Isum.n66 7.08143
R217 Isum.n344 Isum.n343 7.08143
R218 Isum.n279 Isum.n60 6.99336
R219 Isum.n280 Isum.n279 6.99336
R220 Isum.n259 Isum.n258 5.94383
R221 Isum.n328 Isum.n327 5.94383
R222 Isum.n258 Isum.n257 5.89523
R223 Isum.n328 Isum.n89 5.89523
R224 Isum.n281 Isum.n62 5.2005
R225 Isum.n348 Isum.n62 5.2005
R226 Isum.n283 Isum.n282 5.2005
R227 Isum.n282 Isum.n55 5.2005
R228 Isum.n284 Isum.n54 5.2005
R229 Isum.n354 Isum.n54 5.2005
R230 Isum.n285 Isum.n53 5.2005
R231 Isum.n355 Isum.n53 5.2005
R232 Isum.n286 Isum.n52 5.2005
R233 Isum.n356 Isum.n52 5.2005
R234 Isum.n288 Isum.n287 5.2005
R235 Isum.n287 Isum.n51 5.2005
R236 Isum.n289 Isum.n41 5.2005
R237 Isum.n362 Isum.n41 5.2005
R238 Isum.n291 Isum.n290 5.2005
R239 Isum.n290 Isum.n39 5.2005
R240 Isum.n292 Isum.n263 5.2005
R241 Isum.n304 Isum.n263 5.2005
R242 Isum.n294 Isum.n293 5.2005
R243 Isum.n295 Isum.n294 5.2005
R244 Isum.n266 Isum.n265 5.2005
R245 Isum.n265 Isum.n18 5.2005
R246 Isum.n267 Isum.n16 5.2005
R247 Isum.n378 Isum.n16 5.2005
R248 Isum.n5 Isum.n3 5.2005
R249 Isum.n101 Isum.n5 5.2005
R250 Isum.n386 Isum.n385 5.2005
R251 Isum.n385 Isum.n384 5.2005
R252 Isum.n4 Isum.n2 5.2005
R253 Isum.n190 Isum.n4 5.2005
R254 Isum.n162 Isum.n127 5.2005
R255 Isum.n189 Isum.n127 5.2005
R256 Isum.n164 Isum.n163 5.2005
R257 Isum.n163 Isum.n137 5.2005
R258 Isum.n165 Isum.n134 5.2005
R259 Isum.n180 Isum.n134 5.2005
R260 Isum.n167 Isum.n166 5.2005
R261 Isum.n168 Isum.n167 5.2005
R262 Isum.n148 Isum.n147 5.2005
R263 Isum.n147 Isum.n146 5.2005
R264 Isum.n155 Isum.n154 5.2005
R265 Isum.n154 Isum.n86 5.2005
R266 Isum.n153 Isum.n85 5.2005
R267 Isum.n331 Isum.n85 5.2005
R268 Isum.n152 Isum.n84 5.2005
R269 Isum.n332 Isum.n84 5.2005
R270 Isum.n71 Isum.n70 5.2005
R271 Isum.n73 Isum.n71 5.2005
R272 Isum.n340 Isum.n339 5.2005
R273 Isum.n339 Isum.n338 5.2005
R274 Isum.n341 Isum.n68 5.2005
R275 Isum.n72 Isum.n68 5.2005
R276 Isum.n342 Isum.n65 5.2005
R277 Isum.n65 Isum.n63 5.2005
R278 Isum.n76 Isum.n64 5.2005
R279 Isum.n64 Isum.n63 5.2005
R280 Isum.n77 Isum.n74 5.2005
R281 Isum.n74 Isum.n72 5.2005
R282 Isum.n337 Isum.n336 5.2005
R283 Isum.n338 Isum.n337 5.2005
R284 Isum.n335 Isum.n75 5.2005
R285 Isum.n75 Isum.n73 5.2005
R286 Isum.n334 Isum.n333 5.2005
R287 Isum.n333 Isum.n332 5.2005
R288 Isum.n83 Isum.n82 5.2005
R289 Isum.n331 Isum.n83 5.2005
R290 Isum.n140 Isum.n139 5.2005
R291 Isum.n139 Isum.n86 5.2005
R292 Isum.n145 Isum.n144 5.2005
R293 Isum.n146 Isum.n145 5.2005
R294 Isum.n132 Isum.n131 5.2005
R295 Isum.n168 Isum.n132 5.2005
R296 Isum.n182 Isum.n181 5.2005
R297 Isum.n181 Isum.n180 5.2005
R298 Isum.n129 Isum.n128 5.2005
R299 Isum.n137 Isum.n128 5.2005
R300 Isum.n188 Isum.n187 5.2005
R301 Isum.n189 Isum.n188 5.2005
R302 Isum.n10 Isum.n8 5.2005
R303 Isum.n190 Isum.n8 5.2005
R304 Isum.n383 Isum.n382 5.2005
R305 Isum.n384 Isum.n383 5.2005
R306 Isum.n381 Isum.n9 5.2005
R307 Isum.n101 Isum.n9 5.2005
R308 Isum.n380 Isum.n379 5.2005
R309 Isum.n379 Isum.n378 5.2005
R310 Isum.n15 Isum.n14 5.2005
R311 Isum.n18 Isum.n15 5.2005
R312 Isum.n297 Isum.n296 5.2005
R313 Isum.n296 Isum.n295 5.2005
R314 Isum.n303 Isum.n302 5.2005
R315 Isum.n304 Isum.n303 5.2005
R316 Isum.n45 Isum.n43 5.2005
R317 Isum.n43 Isum.n39 5.2005
R318 Isum.n361 Isum.n360 5.2005
R319 Isum.n362 Isum.n361 5.2005
R320 Isum.n359 Isum.n44 5.2005
R321 Isum.n51 Isum.n44 5.2005
R322 Isum.n358 Isum.n357 5.2005
R323 Isum.n357 Isum.n356 5.2005
R324 Isum.n50 Isum.n49 5.2005
R325 Isum.n355 Isum.n50 5.2005
R326 Isum.n353 Isum.n352 5.2005
R327 Isum.n354 Isum.n353 5.2005
R328 Isum.n351 Isum.n56 5.2005
R329 Isum.n56 Isum.n55 5.2005
R330 Isum.n350 Isum.n349 5.2005
R331 Isum.n349 Isum.n348 5.2005
R332 Isum.n365 Isum.n364 5.2005
R333 Isum.n364 Isum.n363 5.2005
R334 Isum.n366 Isum.n33 5.2005
R335 Isum.n305 Isum.n33 5.2005
R336 Isum.n261 Isum.n32 5.2005
R337 Isum.n262 Isum.n261 5.2005
R338 Isum.n22 Isum.n20 5.2005
R339 Isum.n264 Isum.n20 5.2005
R340 Isum.n376 Isum.n375 5.2005
R341 Isum.n377 Isum.n376 5.2005
R342 Isum.n21 Isum.n19 5.2005
R343 Isum.n102 Isum.n19 5.2005
R344 Isum.n203 Isum.n202 5.2005
R345 Isum.n202 Isum.n7 5.2005
R346 Isum.n201 Isum.n193 5.2005
R347 Isum.n201 Isum.n6 5.2005
R348 Isum.n210 Isum.n192 5.2005
R349 Isum.n192 Isum.n191 5.2005
R350 Isum.n211 Isum.n126 5.2005
R351 Isum.n136 Isum.n126 5.2005
R352 Isum.n178 Isum.n125 5.2005
R353 Isum.n179 Isum.n178 5.2005
R354 Isum.n177 Isum.n176 5.2005
R355 Isum.n177 Isum.n133 5.2005
R356 Isum.n175 Isum.n170 5.2005
R357 Isum.n170 Isum.n169 5.2005
R358 Isum.n174 Isum.n87 5.2005
R359 Isum.n138 Isum.n87 5.2005
R360 Isum.n307 Isum.n40 5.2005
R361 Isum.n363 Isum.n40 5.2005
R362 Isum.n308 Isum.n306 5.2005
R363 Isum.n306 Isum.n305 5.2005
R364 Isum.n260 Isum.n105 5.2005
R365 Isum.n262 Isum.n260 5.2005
R366 Isum.n312 Isum.n104 5.2005
R367 Isum.n264 Isum.n104 5.2005
R368 Isum.n313 Isum.n17 5.2005
R369 Isum.n377 Isum.n17 5.2005
R370 Isum.n314 Isum.n103 5.2005
R371 Isum.n103 Isum.n102 5.2005
R372 Isum.n100 Isum.n98 5.2005
R373 Isum.n100 Isum.n7 5.2005
R374 Isum.n318 Isum.n97 5.2005
R375 Isum.n97 Isum.n6 5.2005
R376 Isum.n319 Isum.n96 5.2005
R377 Isum.n191 Isum.n96 5.2005
R378 Isum.n320 Isum.n95 5.2005
R379 Isum.n136 Isum.n95 5.2005
R380 Isum.n135 Isum.n93 5.2005
R381 Isum.n179 Isum.n135 5.2005
R382 Isum.n324 Isum.n92 5.2005
R383 Isum.n133 Isum.n92 5.2005
R384 Isum.n325 Isum.n91 5.2005
R385 Isum.n169 Isum.n91 5.2005
R386 Isum.n326 Isum.n88 5.2005
R387 Isum.n138 Isum.n88 5.2005
R388 Isum.n220 Isum.n219 4.85463
R389 Isum.n108 Isum.n29 4.85463
R390 Isum.n222 Isum.n117 4.69811
R391 Isum.n254 Isum.n107 4.69811
R392 Isum.n76 Isum.n66 4.5005
R393 Isum.n78 Isum.n77 4.5005
R394 Isum.n336 Isum.n79 4.5005
R395 Isum.n335 Isum.n80 4.5005
R396 Isum.n334 Isum.n81 4.5005
R397 Isum.n141 Isum.n82 4.5005
R398 Isum.n142 Isum.n140 4.5005
R399 Isum.n144 Isum.n143 4.5005
R400 Isum.n131 Isum.n130 4.5005
R401 Isum.n183 Isum.n182 4.5005
R402 Isum.n184 Isum.n129 4.5005
R403 Isum.n187 Isum.n186 4.5005
R404 Isum.n185 Isum.n10 4.5005
R405 Isum.n382 Isum.n11 4.5005
R406 Isum.n381 Isum.n12 4.5005
R407 Isum.n380 Isum.n13 4.5005
R408 Isum.n298 Isum.n14 4.5005
R409 Isum.n299 Isum.n297 4.5005
R410 Isum.n302 Isum.n301 4.5005
R411 Isum.n300 Isum.n45 4.5005
R412 Isum.n360 Isum.n46 4.5005
R413 Isum.n359 Isum.n47 4.5005
R414 Isum.n358 Isum.n48 4.5005
R415 Isum.n57 Isum.n49 4.5005
R416 Isum.n352 Isum.n58 4.5005
R417 Isum.n351 Isum.n59 4.5005
R418 Isum.n350 Isum.n60 4.5005
R419 Isum.n341 Isum.n67 4.5005
R420 Isum.n340 Isum.n69 4.5005
R421 Isum.n150 Isum.n70 4.5005
R422 Isum.n152 Isum.n151 4.5005
R423 Isum.n153 Isum.n149 4.5005
R424 Isum.n156 Isum.n155 4.5005
R425 Isum.n157 Isum.n148 4.5005
R426 Isum.n166 Isum.n158 4.5005
R427 Isum.n165 Isum.n159 4.5005
R428 Isum.n164 Isum.n160 4.5005
R429 Isum.n162 Isum.n161 4.5005
R430 Isum.n2 Isum.n0 4.5005
R431 VSS Isum.n386 4.5005
R432 Isum.n3 Isum.n1 4.5005
R433 Isum.n268 Isum.n267 4.5005
R434 Isum.n269 Isum.n266 4.5005
R435 Isum.n293 Isum.n270 4.5005
R436 Isum.n292 Isum.n271 4.5005
R437 Isum.n291 Isum.n272 4.5005
R438 Isum.n289 Isum.n273 4.5005
R439 Isum.n288 Isum.n274 4.5005
R440 Isum.n286 Isum.n275 4.5005
R441 Isum.n285 Isum.n276 4.5005
R442 Isum.n284 Isum.n277 4.5005
R443 Isum.n283 Isum.n278 4.5005
R444 Isum.n281 Isum.n280 4.5005
R445 Isum.n343 Isum.n342 4.5005
R446 Isum.n325 Isum.n90 4.5005
R447 Isum.n324 Isum.n323 4.5005
R448 Isum.n322 Isum.n93 4.5005
R449 Isum.n321 Isum.n320 4.5005
R450 Isum.n319 Isum.n94 4.5005
R451 Isum.n318 Isum.n317 4.5005
R452 Isum.n316 Isum.n98 4.5005
R453 Isum.n315 Isum.n314 4.5005
R454 Isum.n313 Isum.n99 4.5005
R455 Isum.n312 Isum.n311 4.5005
R456 Isum.n310 Isum.n105 4.5005
R457 Isum.n309 Isum.n308 4.5005
R458 Isum.n307 Isum.n259 4.5005
R459 Isum.n327 Isum.n326 4.5005
R460 Isum.n255 Isum.n108 4.5005
R461 Isum.n255 Isum.n254 4.5005
R462 Isum.n223 Isum.n220 4.5005
R463 Isum.n223 Isum.n222 4.5005
R464 Isum.n175 Isum.n118 4.5005
R465 Isum.n176 Isum.n119 4.5005
R466 Isum.n125 Isum.n122 4.5005
R467 Isum.n212 Isum.n211 4.5005
R468 Isum.n210 Isum.n209 4.5005
R469 Isum.n195 Isum.n193 4.5005
R470 Isum.n204 Isum.n203 4.5005
R471 Isum.n199 Isum.n21 4.5005
R472 Isum.n375 Isum.n374 4.5005
R473 Isum.n25 Isum.n22 4.5005
R474 Isum.n32 Isum.n28 4.5005
R475 Isum.n367 Isum.n366 4.5005
R476 Isum.n365 Isum.n37 4.5005
R477 Isum.n174 Isum.n173 4.5005
R478 Isum.n215 Isum.n214 4.0885
R479 Isum.n214 Isum.n121 4.0885
R480 Isum.n207 Isum.n206 4.0885
R481 Isum.n206 Isum.n196 4.0885
R482 Isum.n372 Isum.n26 4.0885
R483 Isum.n372 Isum.n371 4.0885
R484 Isum.n231 Isum.n230 4.0885
R485 Isum.n231 Isum.n113 4.0885
R486 Isum.n239 Isum.n238 4.0885
R487 Isum.n241 Isum.n239 4.0885
R488 Isum.n240 Isum.n110 4.0885
R489 Isum.n249 Isum.n110 4.0885
R490 Isum.n30 Isum.t7 3.5285
R491 Isum.t4 Isum.n30 3.5285
R492 Isum.t10 Isum.n24 3.5285
R493 Isum.t7 Isum.n24 3.5285
R494 Isum.n198 Isum.t13 3.5285
R495 Isum.n198 Isum.t10 3.5285
R496 Isum.n197 Isum.t16 3.5285
R497 Isum.t13 Isum.n197 3.5285
R498 Isum.n194 Isum.t19 3.5285
R499 Isum.t16 Isum.n194 3.5285
R500 Isum.t22 Isum.n123 3.5285
R501 Isum.t19 Isum.n123 3.5285
R502 Isum.t25 Isum.n171 3.5285
R503 Isum.n171 Isum.t22 3.5285
R504 Isum.t35 Isum.n245 3.5285
R505 Isum.n245 Isum.t33 3.5285
R506 Isum.n246 Isum.t37 3.5285
R507 Isum.n246 Isum.t35 3.5285
R508 Isum.n244 Isum.t39 3.5285
R509 Isum.t37 Isum.n244 3.5285
R510 Isum.t41 Isum.n234 3.5285
R511 Isum.n234 Isum.t39 3.5285
R512 Isum.n235 Isum.t43 3.5285
R513 Isum.n235 Isum.t41 3.5285
R514 Isum.n233 Isum.t45 3.5285
R515 Isum.t43 Isum.n233 3.5285
R516 Isum.n226 Isum.t47 3.5285
R517 Isum.n226 Isum.t45 3.5285
R518 Isum.t48 Isum.n189 3.15891
R519 Isum.n378 Isum.t0 3.15891
R520 Isum.n35 Isum 1.7105
R521 Isum.n225 Isum.n224 0.732757
R522 Isum.n256 Isum.n106 0.732757
R523 Isum.n224 Isum.n89 0.716145
R524 Isum.n257 Isum.n256 0.716145
R525 Isum.n35 Isum.n34 0.5063
R526 Isum.n258 Isum.n38 0.217167
R527 Isum.n42 Isum.n38 0.217167
R528 Isum.n329 Isum.n328 0.217167
R529 Isum.n330 Isum.n329 0.217167
R530 Isum.n326 Isum.n325 0.1445
R531 Isum.n325 Isum.n324 0.1445
R532 Isum.n324 Isum.n93 0.1445
R533 Isum.n320 Isum.n93 0.1445
R534 Isum.n320 Isum.n319 0.1445
R535 Isum.n319 Isum.n318 0.1445
R536 Isum.n318 Isum.n98 0.1445
R537 Isum.n314 Isum.n98 0.1445
R538 Isum.n314 Isum.n313 0.1445
R539 Isum.n313 Isum.n312 0.1445
R540 Isum.n312 Isum.n105 0.1445
R541 Isum.n308 Isum.n105 0.1445
R542 Isum.n308 Isum.n307 0.1445
R543 Isum.n342 Isum.n341 0.1445
R544 Isum.n341 Isum.n340 0.1445
R545 Isum.n340 Isum.n70 0.1445
R546 Isum.n152 Isum.n70 0.1445
R547 Isum.n153 Isum.n152 0.1445
R548 Isum.n155 Isum.n153 0.1445
R549 Isum.n155 Isum.n148 0.1445
R550 Isum.n166 Isum.n148 0.1445
R551 Isum.n166 Isum.n165 0.1445
R552 Isum.n165 Isum.n164 0.1445
R553 Isum.n164 Isum.n162 0.1445
R554 Isum.n162 Isum.n2 0.1445
R555 Isum.n386 Isum.n2 0.1445
R556 Isum.n386 Isum.n3 0.1445
R557 Isum.n267 Isum.n3 0.1445
R558 Isum.n267 Isum.n266 0.1445
R559 Isum.n293 Isum.n266 0.1445
R560 Isum.n293 Isum.n292 0.1445
R561 Isum.n292 Isum.n291 0.1445
R562 Isum.n291 Isum.n289 0.1445
R563 Isum.n289 Isum.n288 0.1445
R564 Isum.n288 Isum.n286 0.1445
R565 Isum.n286 Isum.n285 0.1445
R566 Isum.n285 Isum.n284 0.1445
R567 Isum.n284 Isum.n283 0.1445
R568 Isum.n283 Isum.n281 0.1445
R569 Isum.n77 Isum.n76 0.1445
R570 Isum.n336 Isum.n77 0.1445
R571 Isum.n336 Isum.n335 0.1445
R572 Isum.n335 Isum.n334 0.1445
R573 Isum.n334 Isum.n82 0.1445
R574 Isum.n140 Isum.n82 0.1445
R575 Isum.n144 Isum.n140 0.1445
R576 Isum.n144 Isum.n131 0.1445
R577 Isum.n182 Isum.n131 0.1445
R578 Isum.n182 Isum.n129 0.1445
R579 Isum.n187 Isum.n129 0.1445
R580 Isum.n187 Isum.n10 0.1445
R581 Isum.n382 Isum.n10 0.1445
R582 Isum.n382 Isum.n381 0.1445
R583 Isum.n381 Isum.n380 0.1445
R584 Isum.n380 Isum.n14 0.1445
R585 Isum.n297 Isum.n14 0.1445
R586 Isum.n302 Isum.n297 0.1445
R587 Isum.n302 Isum.n45 0.1445
R588 Isum.n360 Isum.n45 0.1445
R589 Isum.n360 Isum.n359 0.1445
R590 Isum.n359 Isum.n358 0.1445
R591 Isum.n358 Isum.n49 0.1445
R592 Isum.n352 Isum.n49 0.1445
R593 Isum.n352 Isum.n351 0.1445
R594 Isum.n351 Isum.n350 0.1445
R595 Isum.n78 Isum.n66 0.1445
R596 Isum.n79 Isum.n78 0.1445
R597 Isum.n80 Isum.n79 0.1445
R598 Isum.n81 Isum.n80 0.1445
R599 Isum.n141 Isum.n81 0.1445
R600 Isum.n142 Isum.n141 0.1445
R601 Isum.n143 Isum.n142 0.1445
R602 Isum.n143 Isum.n130 0.1445
R603 Isum.n183 Isum.n130 0.1445
R604 Isum.n184 Isum.n183 0.1445
R605 Isum.n186 Isum.n184 0.1445
R606 Isum.n186 Isum.n185 0.1445
R607 Isum.n185 Isum.n11 0.1445
R608 Isum.n12 Isum.n11 0.1445
R609 Isum.n13 Isum.n12 0.1445
R610 Isum.n298 Isum.n13 0.1445
R611 Isum.n299 Isum.n298 0.1445
R612 Isum.n301 Isum.n299 0.1445
R613 Isum.n301 Isum.n300 0.1445
R614 Isum.n300 Isum.n46 0.1445
R615 Isum.n47 Isum.n46 0.1445
R616 Isum.n48 Isum.n47 0.1445
R617 Isum.n57 Isum.n48 0.1445
R618 Isum.n58 Isum.n57 0.1445
R619 Isum.n59 Isum.n58 0.1445
R620 Isum.n60 Isum.n59 0.1445
R621 Isum.n343 Isum.n67 0.1445
R622 Isum.n69 Isum.n67 0.1445
R623 Isum.n150 Isum.n69 0.1445
R624 Isum.n151 Isum.n150 0.1445
R625 Isum.n151 Isum.n149 0.1445
R626 Isum.n156 Isum.n149 0.1445
R627 Isum.n157 Isum.n156 0.1445
R628 Isum.n158 Isum.n157 0.1445
R629 Isum.n159 Isum.n158 0.1445
R630 Isum.n160 Isum.n159 0.1445
R631 Isum.n161 Isum.n160 0.1445
R632 Isum.n161 Isum.n0 0.1445
R633 VSS Isum.n0 0.1445
R634 VSS Isum.n1 0.1445
R635 Isum.n268 Isum.n1 0.1445
R636 Isum.n269 Isum.n268 0.1445
R637 Isum.n270 Isum.n269 0.1445
R638 Isum.n271 Isum.n270 0.1445
R639 Isum.n272 Isum.n271 0.1445
R640 Isum.n273 Isum.n272 0.1445
R641 Isum.n274 Isum.n273 0.1445
R642 Isum.n275 Isum.n274 0.1445
R643 Isum.n276 Isum.n275 0.1445
R644 Isum.n277 Isum.n276 0.1445
R645 Isum.n278 Isum.n277 0.1445
R646 Isum.n280 Isum.n278 0.1445
R647 Isum.n175 Isum.n174 0.1445
R648 Isum.n176 Isum.n175 0.1445
R649 Isum.n176 Isum.n125 0.1445
R650 Isum.n211 Isum.n125 0.1445
R651 Isum.n211 Isum.n210 0.1445
R652 Isum.n210 Isum.n193 0.1445
R653 Isum.n203 Isum.n193 0.1445
R654 Isum.n203 Isum.n21 0.1445
R655 Isum.n375 Isum.n21 0.1445
R656 Isum.n375 Isum.n22 0.1445
R657 Isum.n32 Isum.n22 0.1445
R658 Isum.n366 Isum.n32 0.1445
R659 Isum.n366 Isum.n365 0.1445
R660 Isum.n327 Isum.n90 0.1445
R661 Isum.n323 Isum.n90 0.1445
R662 Isum.n323 Isum.n322 0.1445
R663 Isum.n322 Isum.n321 0.1445
R664 Isum.n321 Isum.n94 0.1445
R665 Isum.n317 Isum.n94 0.1445
R666 Isum.n317 Isum.n316 0.1445
R667 Isum.n316 Isum.n315 0.1445
R668 Isum.n315 Isum.n99 0.1445
R669 Isum.n311 Isum.n99 0.1445
R670 Isum.n311 Isum.n310 0.1445
R671 Isum.n310 Isum.n309 0.1445
R672 Isum.n309 Isum.n259 0.1445
R673 Isum.n345 Isum.n344 0.111138
R674 Isum.n346 Isum.n345 0.111138
R675 Isum.n279 Isum.n61 0.111138
R676 Isum.n255 Isum.n253 0.0424731
R677 Isum.n223 Isum.n221 0.0424731
R678 Isum.n107 Isum.n29 0.032787
R679 Isum.n219 Isum.n117 0.032787
R680 Isum.n368 Isum.n29 0.0315762
R681 Isum.n253 Isum.n252 0.0315762
R682 Isum.n219 Isum.n218 0.0315762
R683 Isum.n221 Isum.n116 0.0315762
R684 Isum.n256 Isum.n107 0.0265314
R685 Isum.n224 Isum.n117 0.0265314
R686 Isum.n232 Isum.n115 0.0203347
R687 Isum.n232 Isum.n114 0.0203347
R688 Isum.n237 Isum.n112 0.0203347
R689 Isum.n242 Isum.n112 0.0203347
R690 Isum.n247 Isum.n111 0.0203347
R691 Isum.n248 Isum.n247 0.0203347
R692 Isum.n256 Isum.n255 0.0168453
R693 Isum.n224 Isum.n223 0.0168453
R694 Isum.n225 Isum.n116 0.0115331
R695 Isum.n252 Isum.n106 0.0115331
R696 Isum.n228 Isum.n227 0.0104174
R697 Isum.n227 Isum.n115 0.0104174
R698 Isum.n236 Isum.n114 0.0104174
R699 Isum.n237 Isum.n236 0.0104174
R700 Isum.n243 Isum.n242 0.0104174
R701 Isum.n243 Isum.n111 0.0104174
R702 Isum.n248 Isum.n109 0.0104174
R703 Isum.n251 Isum.n109 0.0104174
R704 Isum.n228 Isum.n116 0.00930165
R705 Isum.n252 Isum.n251 0.00930165
R706 Isum.n173 Isum.n172 0.0086448
R707 Isum.n172 Isum.n118 0.0086448
R708 Isum.n217 Isum.n119 0.0086448
R709 Isum.n120 Isum.n119 0.0086448
R710 Isum.n122 Isum.n120 0.0086448
R711 Isum.n213 Isum.n122 0.0086448
R712 Isum.n213 Isum.n212 0.0086448
R713 Isum.n212 Isum.n124 0.0086448
R714 Isum.n209 Isum.n124 0.0086448
R715 Isum.n209 Isum.n208 0.0086448
R716 Isum.n208 Isum.n195 0.0086448
R717 Isum.n205 Isum.n195 0.0086448
R718 Isum.n205 Isum.n204 0.0086448
R719 Isum.n204 Isum.n200 0.0086448
R720 Isum.n200 Isum.n199 0.0086448
R721 Isum.n199 Isum.n23 0.0086448
R722 Isum.n374 Isum.n23 0.0086448
R723 Isum.n374 Isum.n373 0.0086448
R724 Isum.n373 Isum.n25 0.0086448
R725 Isum.n27 Isum.n25 0.0086448
R726 Isum.n28 Isum.n27 0.0086448
R727 Isum.n369 Isum.n28 0.0086448
R728 Isum.n367 Isum.n31 0.0086448
R729 Isum.n218 Isum.n217 0.00772851
R730 Isum.n369 Isum.n368 0.00772851
R731 Isum.n173 Isum.n89 0.00599774
R732 Isum.n257 Isum.n37 0.00599774
R733 Isum.n37 Isum.n36 0.00497964
R734 Isum.n36 Isum.n31 0.00416516
R735 Isum.n218 Isum.n118 0.00141629
R736 Isum.n368 Isum.n367 0.00141629
R737 VDD.n143 VDD.n141 147.439
R738 VDD.n182 VDD.n181 147.439
R739 VDD.n149 VDD.n141 147.439
R740 VDD.n181 VDD.n126 147.439
R741 VDD.n77 VDD.n74 128.189
R742 VDD.n213 VDD.n20 128.189
R743 VDD.n87 VDD.n64 59.836
R744 VDD.n224 VDD.n223 59.836
R745 VDD.n221 VDD.n220 59.836
R746 VDD.n75 VDD.t31 51.6086
R747 VDD.t28 VDD.n215 51.6086
R748 VDD.n214 VDD.n213 49.2957
R749 VDD.n77 VDD.n76 49.2957
R750 VDD.n84 VDD.t25 44.8771
R751 VDD.n84 VDD.t22 44.8771
R752 VDD.n63 VDD.t16 44.8771
R753 VDD.t13 VDD.n222 44.8771
R754 VDD.n217 VDD.t7 44.8771
R755 VDD.n217 VDD.t4 44.8771
R756 VDD.t49 VDD.n63 27.6744
R757 VDD.n222 VDD.t1 27.6744
R758 VDD.n207 VDD.t0 26.0766
R759 VDD.n208 VDD.t2 24.4345
R760 VDD.n206 VDD.t50 24.4345
R761 VDD.n242 VDD.t30 24.363
R762 VDD.n274 VDD.t27 24.363
R763 VDD.t19 VDD.t49 17.2032
R764 VDD.t1 VDD.t10 17.2032
R765 VDD.t25 VDD.n83 14.9594
R766 VDD.n87 VDD.t22 14.9594
R767 VDD.n64 VDD.t19 14.9594
R768 VDD.n224 VDD.t16 14.9594
R769 VDD.n223 VDD.t13 14.9594
R770 VDD.t10 VDD.n221 14.9594
R771 VDD.n220 VDD.t7 14.9594
R772 VDD.t4 VDD.n216 14.9594
R773 VDD.n74 VDD.n65 14.0005
R774 VDD.n85 VDD.n65 14.0005
R775 VDD.n86 VDD.n85 14.0005
R776 VDD.n86 VDD.n43 14.0005
R777 VDD.n44 VDD.n43 14.0005
R778 VDD.n225 VDD.n44 14.0005
R779 VDD.n225 VDD.n45 14.0005
R780 VDD.n45 VDD.n6 14.0005
R781 VDD.n7 VDD.n6 14.0005
R782 VDD.n219 VDD.n7 14.0005
R783 VDD.n219 VDD.n218 14.0005
R784 VDD.n218 VDD.n19 14.0005
R785 VDD.n20 VDD.n19 14.0005
R786 VDD.n82 VDD.n67 14.0005
R787 VDD.n82 VDD.n61 14.0005
R788 VDD.n88 VDD.n61 14.0005
R789 VDD.n88 VDD.n62 14.0005
R790 VDD.n62 VDD.n58 14.0005
R791 VDD.n58 VDD.n46 14.0005
R792 VDD.n47 VDD.n46 14.0005
R793 VDD.n48 VDD.n47 14.0005
R794 VDD.n49 VDD.n48 14.0005
R795 VDD.n50 VDD.n49 14.0005
R796 VDD.n51 VDD.n50 14.0005
R797 VDD.n52 VDD.n51 14.0005
R798 VDD.n212 VDD.n52 14.0005
R799 VDD.n143 VDD.n142 14.0005
R800 VDD.n142 VDD.n107 14.0005
R801 VDD.n108 VDD.n107 14.0005
R802 VDD.n109 VDD.n108 14.0005
R803 VDD.n112 VDD.n109 14.0005
R804 VDD.n113 VDD.n112 14.0005
R805 VDD.n114 VDD.n113 14.0005
R806 VDD.n115 VDD.n114 14.0005
R807 VDD.n118 VDD.n115 14.0005
R808 VDD.n119 VDD.n118 14.0005
R809 VDD.n120 VDD.n119 14.0005
R810 VDD.n121 VDD.n120 14.0005
R811 VDD.n124 VDD.n121 14.0005
R812 VDD.n125 VDD.n124 14.0005
R813 VDD.n182 VDD.n125 14.0005
R814 VDD.n150 VDD.n149 14.0005
R815 VDD.n151 VDD.n150 14.0005
R816 VDD.n151 VDD.n137 14.0005
R817 VDD.n157 VDD.n137 14.0005
R818 VDD.n158 VDD.n157 14.0005
R819 VDD.n159 VDD.n158 14.0005
R820 VDD.n159 VDD.n133 14.0005
R821 VDD.n165 VDD.n133 14.0005
R822 VDD.n166 VDD.n165 14.0005
R823 VDD.n167 VDD.n166 14.0005
R824 VDD.n167 VDD.n129 14.0005
R825 VDD.n174 VDD.n129 14.0005
R826 VDD.n175 VDD.n174 14.0005
R827 VDD.n176 VDD.n175 14.0005
R828 VDD.n176 VDD.n126 14.0005
R829 VDD.n285 VDD.n284 12.5005
R830 VDD.n272 VDD.n271 12.5005
R831 VDD.n270 VDD.n269 12.5005
R832 VDD.n268 VDD.n26 12.5005
R833 VDD.n261 VDD.n27 12.5005
R834 VDD.n263 VDD.n262 12.5005
R835 VDD.n260 VDD.n28 12.5005
R836 VDD.n259 VDD.n258 12.5005
R837 VDD.n30 VDD.n29 12.5005
R838 VDD.n253 VDD.n252 12.5005
R839 VDD.n251 VDD.n31 12.5005
R840 VDD.n250 VDD.n249 12.5005
R841 VDD.n286 VDD.n13 12.5005
R842 VDD.n288 VDD.n287 12.5005
R843 VDD.n12 VDD.n4 12.5005
R844 VDD.n11 VDD.n3 12.5005
R845 VDD VDD.n1 12.5005
R846 VDD.n229 VDD.n228 12.5005
R847 VDD.n41 VDD.n38 12.5005
R848 VDD.n235 VDD.n234 12.5005
R849 VDD.n236 VDD.n37 12.5005
R850 VDD.n238 VDD.n237 12.5005
R851 VDD.n237 VDD.t24 11.863
R852 VDD.n236 VDD.t21 11.863
R853 VDD.n38 VDD.t18 11.863
R854 VDD.n228 VDD.t15 11.863
R855 VDD.n11 VDD.t12 11.863
R856 VDD.n12 VDD.t9 11.863
R857 VDD.n286 VDD.t6 11.863
R858 VDD.n285 VDD.t3 11.863
R859 VDD.n250 VDD.t47 11.863
R860 VDD.n251 VDD.t45 11.863
R861 VDD.n29 VDD.t43 11.863
R862 VDD.n259 VDD.t41 11.863
R863 VDD.n262 VDD.t39 11.863
R864 VDD.n261 VDD.t37 11.863
R865 VDD.n270 VDD.t35 11.863
R866 VDD.n271 VDD.t33 11.863
R867 VDD.n17 VDD.t5 11.4188
R868 VDD.n70 VDD.t26 11.4188
R869 VDD.t34 VDD.n22 11.4188
R870 VDD.t48 VDD.n246 11.4188
R871 VDD.n205 VDD.n204 10.3343
R872 VDD.n209 VDD.n208 10.0319
R873 VDD.n205 VDD.t51 9.79835
R874 VDD.n243 VDD.t32 9.1205
R875 VDD.t32 VDD.n241 9.1205
R876 VDD.n275 VDD.t29 9.1205
R877 VDD.t29 VDD.n24 9.1205
R878 VDD.n83 VDD.t31 8.22788
R879 VDD.n216 VDD.t28 8.22788
R880 VDD.n237 VDD.n236 8.1765
R881 VDD.n228 VDD.n38 8.1765
R882 VDD.n12 VDD.n11 8.1765
R883 VDD.n286 VDD.n285 8.1765
R884 VDD.n251 VDD.n250 8.1765
R885 VDD.n259 VDD.n29 8.1765
R886 VDD.n262 VDD.n261 8.1765
R887 VDD.n271 VDD.n270 8.1765
R888 VDD.n16 VDD.n14 7.53568
R889 VDD.n293 VDD.n292 7.53568
R890 VDD.n230 VDD.n227 7.53568
R891 VDD.n69 VDD.n36 7.53568
R892 VDD.n266 VDD.n25 7.53568
R893 VDD.n265 VDD.n264 7.53568
R894 VDD.n257 VDD.n256 7.53568
R895 VDD.n248 VDD.n247 7.53568
R896 VDD.n288 VDD.n9 7.49884
R897 VDD VDD.n294 7.49884
R898 VDD.n234 VDD.n40 7.49884
R899 VDD.n268 VDD.n267 7.49884
R900 VDD.n255 VDD.n28 7.49884
R901 VDD.n254 VDD.n253 7.49884
R902 VDD.n74 VDD.n73 6.3005
R903 VDD.n75 VDD.n74 6.3005
R904 VDD.n72 VDD.n65 6.3005
R905 VDD.n83 VDD.n65 6.3005
R906 VDD.n85 VDD.n66 6.3005
R907 VDD.n85 VDD.n84 6.3005
R908 VDD.n86 VDD.n42 6.3005
R909 VDD.n87 VDD.n86 6.3005
R910 VDD.n232 VDD.n43 6.3005
R911 VDD.n64 VDD.n43 6.3005
R912 VDD.n231 VDD.n44 6.3005
R913 VDD.n63 VDD.n44 6.3005
R914 VDD.n226 VDD.n225 6.3005
R915 VDD.n225 VDD.n224 6.3005
R916 VDD.n45 VDD.n5 6.3005
R917 VDD.n223 VDD.n45 6.3005
R918 VDD.n291 VDD.n6 6.3005
R919 VDD.n222 VDD.n6 6.3005
R920 VDD.n290 VDD.n7 6.3005
R921 VDD.n221 VDD.n7 6.3005
R922 VDD.n219 VDD.n8 6.3005
R923 VDD.n220 VDD.n219 6.3005
R924 VDD.n218 VDD.n18 6.3005
R925 VDD.n218 VDD.n217 6.3005
R926 VDD.n281 VDD.n19 6.3005
R927 VDD.n216 VDD.n19 6.3005
R928 VDD.n280 VDD.n20 6.3005
R929 VDD.n215 VDD.n20 6.3005
R930 VDD.n212 VDD.n211 6.3005
R931 VDD.n53 VDD.n52 6.3005
R932 VDD.n216 VDD.n52 6.3005
R933 VDD.n101 VDD.n51 6.3005
R934 VDD.n217 VDD.n51 6.3005
R935 VDD.n100 VDD.n50 6.3005
R936 VDD.n220 VDD.n50 6.3005
R937 VDD.n99 VDD.n49 6.3005
R938 VDD.n221 VDD.n49 6.3005
R939 VDD.n55 VDD.n48 6.3005
R940 VDD.n222 VDD.n48 6.3005
R941 VDD.n95 VDD.n47 6.3005
R942 VDD.n223 VDD.n47 6.3005
R943 VDD.n94 VDD.n46 6.3005
R944 VDD.n224 VDD.n46 6.3005
R945 VDD.n93 VDD.n58 6.3005
R946 VDD.n63 VDD.n58 6.3005
R947 VDD.n62 VDD.n57 6.3005
R948 VDD.n64 VDD.n62 6.3005
R949 VDD.n89 VDD.n88 6.3005
R950 VDD.n88 VDD.n87 6.3005
R951 VDD.n61 VDD.n60 6.3005
R952 VDD.n84 VDD.n61 6.3005
R953 VDD.n82 VDD.n81 6.3005
R954 VDD.n83 VDD.n82 6.3005
R955 VDD.n68 VDD.n67 6.3005
R956 VDD.n183 VDD.n182 6.3005
R957 VDD.n184 VDD.n125 6.3005
R958 VDD.n124 VDD.n122 6.3005
R959 VDD.n188 VDD.n121 6.3005
R960 VDD.n189 VDD.n120 6.3005
R961 VDD.n190 VDD.n119 6.3005
R962 VDD.n118 VDD.n116 6.3005
R963 VDD.n194 VDD.n115 6.3005
R964 VDD.n195 VDD.n114 6.3005
R965 VDD.n196 VDD.n113 6.3005
R966 VDD.n112 VDD.n110 6.3005
R967 VDD.n200 VDD.n109 6.3005
R968 VDD.n201 VDD.n108 6.3005
R969 VDD.n202 VDD.n107 6.3005
R970 VDD.n142 VDD.n106 6.3005
R971 VDD.n144 VDD.n143 6.3005
R972 VDD.n178 VDD.n126 6.3005
R973 VDD.n177 VDD.n176 6.3005
R974 VDD.n175 VDD.n128 6.3005
R975 VDD.n174 VDD.n173 6.3005
R976 VDD.n130 VDD.n129 6.3005
R977 VDD.n168 VDD.n167 6.3005
R978 VDD.n166 VDD.n132 6.3005
R979 VDD.n165 VDD.n164 6.3005
R980 VDD.n134 VDD.n133 6.3005
R981 VDD.n160 VDD.n159 6.3005
R982 VDD.n158 VDD.n136 6.3005
R983 VDD.n157 VDD.n156 6.3005
R984 VDD.n138 VDD.n137 6.3005
R985 VDD.n152 VDD.n151 6.3005
R986 VDD.n150 VDD.n140 6.3005
R987 VDD.n149 VDD.n148 6.3005
R988 VDD.n180 VDD.n123 6.1567
R989 VDD.n180 VDD.n179 6.1567
R990 VDD.n147 VDD.n146 6.1567
R991 VDD.n146 VDD.n145 6.1567
R992 VDD.n79 VDD.n78 5.94383
R993 VDD.n78 VDD.n33 5.89523
R994 VDD.n278 VDD.n21 5.80222
R995 VDD.n209 VDD.n21 5.73202
R996 VDD.n241 VDD.n240 4.85463
R997 VDD.n24 VDD.n15 4.85463
R998 VDD.n243 VDD.n34 4.69811
R999 VDD.n275 VDD.n23 4.69811
R1000 VDD.n140 VDD.n139 4.5005
R1001 VDD.n153 VDD.n152 4.5005
R1002 VDD.n154 VDD.n138 4.5005
R1003 VDD.n156 VDD.n155 4.5005
R1004 VDD.n136 VDD.n135 4.5005
R1005 VDD.n161 VDD.n160 4.5005
R1006 VDD.n162 VDD.n134 4.5005
R1007 VDD.n164 VDD.n163 4.5005
R1008 VDD.n132 VDD.n131 4.5005
R1009 VDD.n169 VDD.n168 4.5005
R1010 VDD.n170 VDD.n130 4.5005
R1011 VDD.n173 VDD.n172 4.5005
R1012 VDD.n171 VDD.n128 4.5005
R1013 VDD.n177 VDD.n127 4.5005
R1014 VDD.n179 VDD.n178 4.5005
R1015 VDD.n148 VDD.n147 4.5005
R1016 VDD.n106 VDD.n104 4.5005
R1017 VDD.n203 VDD.n202 4.5005
R1018 VDD.n201 VDD.n105 4.5005
R1019 VDD.n200 VDD.n199 4.5005
R1020 VDD.n198 VDD.n110 4.5005
R1021 VDD.n197 VDD.n196 4.5005
R1022 VDD.n195 VDD.n111 4.5005
R1023 VDD.n194 VDD.n193 4.5005
R1024 VDD.n192 VDD.n116 4.5005
R1025 VDD.n191 VDD.n190 4.5005
R1026 VDD.n189 VDD.n117 4.5005
R1027 VDD.n188 VDD.n187 4.5005
R1028 VDD.n186 VDD.n122 4.5005
R1029 VDD.n185 VDD.n184 4.5005
R1030 VDD.n183 VDD.n123 4.5005
R1031 VDD.n145 VDD.n144 4.5005
R1032 VDD.n81 VDD.n80 4.5005
R1033 VDD.n60 VDD.n59 4.5005
R1034 VDD.n90 VDD.n89 4.5005
R1035 VDD.n91 VDD.n57 4.5005
R1036 VDD.n93 VDD.n92 4.5005
R1037 VDD.n94 VDD.n56 4.5005
R1038 VDD.n96 VDD.n95 4.5005
R1039 VDD.n97 VDD.n55 4.5005
R1040 VDD.n99 VDD.n98 4.5005
R1041 VDD.n100 VDD.n54 4.5005
R1042 VDD.n102 VDD.n101 4.5005
R1043 VDD.n103 VDD.n53 4.5005
R1044 VDD.n211 VDD.n210 4.5005
R1045 VDD.n79 VDD.n68 4.5005
R1046 VDD.n276 VDD.n24 4.5005
R1047 VDD.n276 VDD.n275 4.5005
R1048 VDD.n244 VDD.n241 4.5005
R1049 VDD.n244 VDD.n243 4.5005
R1050 VDD.n73 VDD.n71 4.5005
R1051 VDD.n72 VDD.n35 4.5005
R1052 VDD.n66 VDD.n36 4.5005
R1053 VDD.n42 VDD.n39 4.5005
R1054 VDD.n233 VDD.n232 4.5005
R1055 VDD.n231 VDD.n230 4.5005
R1056 VDD.n226 VDD.n0 4.5005
R1057 VDD.n5 VDD.n2 4.5005
R1058 VDD.n292 VDD.n291 4.5005
R1059 VDD.n290 VDD.n289 4.5005
R1060 VDD.n10 VDD.n8 4.5005
R1061 VDD.n18 VDD.n14 4.5005
R1062 VDD.n282 VDD.n281 4.5005
R1063 VDD.n280 VDD.n279 4.5005
R1064 VDD.n236 VDD.n235 4.0885
R1065 VDD.n235 VDD.n38 4.0885
R1066 VDD.n228 VDD.n1 4.0885
R1067 VDD.n11 VDD.n1 4.0885
R1068 VDD.n287 VDD.n12 4.0885
R1069 VDD.n287 VDD.n286 4.0885
R1070 VDD.n252 VDD.n251 4.0885
R1071 VDD.n252 VDD.n29 4.0885
R1072 VDD.n260 VDD.n259 4.0885
R1073 VDD.n262 VDD.n260 4.0885
R1074 VDD.n261 VDD.n26 4.0885
R1075 VDD.n270 VDD.n26 4.0885
R1076 VDD.n16 VDD.t8 3.9205
R1077 VDD.t5 VDD.n16 3.9205
R1078 VDD.n9 VDD.t11 3.9205
R1079 VDD.t8 VDD.n9 3.9205
R1080 VDD.t14 VDD.n293 3.9205
R1081 VDD.n293 VDD.t11 3.9205
R1082 VDD.n294 VDD.t17 3.9205
R1083 VDD.n294 VDD.t14 3.9205
R1084 VDD.n227 VDD.t20 3.9205
R1085 VDD.n227 VDD.t17 3.9205
R1086 VDD.t23 VDD.n40 3.9205
R1087 VDD.t20 VDD.n40 3.9205
R1088 VDD.t26 VDD.n69 3.9205
R1089 VDD.n69 VDD.t23 3.9205
R1090 VDD.t36 VDD.n266 3.9205
R1091 VDD.n266 VDD.t34 3.9205
R1092 VDD.n267 VDD.t38 3.9205
R1093 VDD.n267 VDD.t36 3.9205
R1094 VDD.n265 VDD.t40 3.9205
R1095 VDD.t38 VDD.n265 3.9205
R1096 VDD.t42 VDD.n255 3.9205
R1097 VDD.n255 VDD.t40 3.9205
R1098 VDD.n256 VDD.t44 3.9205
R1099 VDD.n256 VDD.t42 3.9205
R1100 VDD.n254 VDD.t46 3.9205
R1101 VDD.t44 VDD.n254 3.9205
R1102 VDD.n247 VDD.t48 3.9205
R1103 VDD.n247 VDD.t46 3.9205
R1104 VDD.n214 VDD.n212 3.69669
R1105 VDD.n76 VDD.n67 3.69669
R1106 VDD.n76 VDD.n75 2.42368
R1107 VDD.n215 VDD.n214 2.42368
R1108 VDD.n206 VDD.n205 0.8663
R1109 VDD.n246 VDD.n245 0.732757
R1110 VDD.n277 VDD.n22 0.732757
R1111 VDD.n245 VDD.n33 0.716145
R1112 VDD.n278 VDD.n277 0.716145
R1113 VDD.n208 VDD.n207 0.3605
R1114 VDD.n213 VDD.n21 0.263
R1115 VDD.n78 VDD.n77 0.263
R1116 VDD.n181 VDD.n180 0.2255
R1117 VDD.n146 VDD.n141 0.2255
R1118 VDD.n207 VDD.n206 0.2057
R1119 VDD.n81 VDD.n68 0.1445
R1120 VDD.n81 VDD.n60 0.1445
R1121 VDD.n89 VDD.n60 0.1445
R1122 VDD.n89 VDD.n57 0.1445
R1123 VDD.n93 VDD.n57 0.1445
R1124 VDD.n94 VDD.n93 0.1445
R1125 VDD.n95 VDD.n94 0.1445
R1126 VDD.n95 VDD.n55 0.1445
R1127 VDD.n99 VDD.n55 0.1445
R1128 VDD.n100 VDD.n99 0.1445
R1129 VDD.n101 VDD.n100 0.1445
R1130 VDD.n101 VDD.n53 0.1445
R1131 VDD.n211 VDD.n53 0.1445
R1132 VDD.n73 VDD.n72 0.1445
R1133 VDD.n72 VDD.n66 0.1445
R1134 VDD.n66 VDD.n42 0.1445
R1135 VDD.n232 VDD.n42 0.1445
R1136 VDD.n232 VDD.n231 0.1445
R1137 VDD.n231 VDD.n226 0.1445
R1138 VDD.n226 VDD.n5 0.1445
R1139 VDD.n291 VDD.n5 0.1445
R1140 VDD.n291 VDD.n290 0.1445
R1141 VDD.n290 VDD.n8 0.1445
R1142 VDD.n18 VDD.n8 0.1445
R1143 VDD.n281 VDD.n18 0.1445
R1144 VDD.n281 VDD.n280 0.1445
R1145 VDD.n148 VDD.n140 0.1445
R1146 VDD.n152 VDD.n140 0.1445
R1147 VDD.n152 VDD.n138 0.1445
R1148 VDD.n156 VDD.n138 0.1445
R1149 VDD.n156 VDD.n136 0.1445
R1150 VDD.n160 VDD.n136 0.1445
R1151 VDD.n160 VDD.n134 0.1445
R1152 VDD.n164 VDD.n134 0.1445
R1153 VDD.n164 VDD.n132 0.1445
R1154 VDD.n168 VDD.n132 0.1445
R1155 VDD.n168 VDD.n130 0.1445
R1156 VDD.n173 VDD.n130 0.1445
R1157 VDD.n173 VDD.n128 0.1445
R1158 VDD.n177 VDD.n128 0.1445
R1159 VDD.n178 VDD.n177 0.1445
R1160 VDD.n144 VDD.n106 0.1445
R1161 VDD.n202 VDD.n106 0.1445
R1162 VDD.n202 VDD.n201 0.1445
R1163 VDD.n201 VDD.n200 0.1445
R1164 VDD.n200 VDD.n110 0.1445
R1165 VDD.n196 VDD.n110 0.1445
R1166 VDD.n196 VDD.n195 0.1445
R1167 VDD.n195 VDD.n194 0.1445
R1168 VDD.n194 VDD.n116 0.1445
R1169 VDD.n190 VDD.n116 0.1445
R1170 VDD.n190 VDD.n189 0.1445
R1171 VDD.n189 VDD.n188 0.1445
R1172 VDD.n188 VDD.n122 0.1445
R1173 VDD.n184 VDD.n122 0.1445
R1174 VDD.n184 VDD.n183 0.1445
R1175 VDD.n147 VDD.n139 0.1445
R1176 VDD.n153 VDD.n139 0.1445
R1177 VDD.n154 VDD.n153 0.1445
R1178 VDD.n155 VDD.n154 0.1445
R1179 VDD.n155 VDD.n135 0.1445
R1180 VDD.n161 VDD.n135 0.1445
R1181 VDD.n162 VDD.n161 0.1445
R1182 VDD.n163 VDD.n162 0.1445
R1183 VDD.n163 VDD.n131 0.1445
R1184 VDD.n169 VDD.n131 0.1445
R1185 VDD.n170 VDD.n169 0.1445
R1186 VDD.n172 VDD.n170 0.1445
R1187 VDD.n172 VDD.n171 0.1445
R1188 VDD.n171 VDD.n127 0.1445
R1189 VDD.n179 VDD.n127 0.1445
R1190 VDD.n145 VDD.n104 0.1445
R1191 VDD.n203 VDD.n105 0.1445
R1192 VDD.n199 VDD.n105 0.1445
R1193 VDD.n199 VDD.n198 0.1445
R1194 VDD.n198 VDD.n197 0.1445
R1195 VDD.n197 VDD.n111 0.1445
R1196 VDD.n193 VDD.n111 0.1445
R1197 VDD.n193 VDD.n192 0.1445
R1198 VDD.n192 VDD.n191 0.1445
R1199 VDD.n191 VDD.n117 0.1445
R1200 VDD.n187 VDD.n117 0.1445
R1201 VDD.n187 VDD.n186 0.1445
R1202 VDD.n186 VDD.n185 0.1445
R1203 VDD.n185 VDD.n123 0.1445
R1204 VDD.n80 VDD.n79 0.1445
R1205 VDD.n80 VDD.n59 0.1445
R1206 VDD.n90 VDD.n59 0.1445
R1207 VDD.n91 VDD.n90 0.1445
R1208 VDD.n92 VDD.n91 0.1445
R1209 VDD.n92 VDD.n56 0.1445
R1210 VDD.n96 VDD.n56 0.1445
R1211 VDD.n97 VDD.n96 0.1445
R1212 VDD.n98 VDD.n97 0.1445
R1213 VDD.n98 VDD.n54 0.1445
R1214 VDD.n102 VDD.n54 0.1445
R1215 VDD.n103 VDD.n102 0.1445
R1216 VDD.n210 VDD.n103 0.1445
R1217 VDD.n210 VDD.n209 0.1193
R1218 VDD.n204 VDD.n203 0.1049
R1219 VDD.n276 VDD.n274 0.0424731
R1220 VDD.n244 VDD.n242 0.0424731
R1221 VDD.n204 VDD.n104 0.0401
R1222 VDD.n23 VDD.n15 0.032787
R1223 VDD.n240 VDD.n34 0.032787
R1224 VDD.n283 VDD.n15 0.0315762
R1225 VDD.n274 VDD.n273 0.0315762
R1226 VDD.n240 VDD.n239 0.0315762
R1227 VDD.n242 VDD.n32 0.0315762
R1228 VDD.n277 VDD.n23 0.0265314
R1229 VDD.n245 VDD.n34 0.0265314
R1230 VDD.n253 VDD.n31 0.0203347
R1231 VDD.n253 VDD.n30 0.0203347
R1232 VDD.n258 VDD.n28 0.0203347
R1233 VDD.n263 VDD.n28 0.0203347
R1234 VDD.n268 VDD.n27 0.0203347
R1235 VDD.n269 VDD.n268 0.0203347
R1236 VDD.n277 VDD.n276 0.0168453
R1237 VDD.n245 VDD.n244 0.0168453
R1238 VDD.n246 VDD.n32 0.0115331
R1239 VDD.n273 VDD.n22 0.0115331
R1240 VDD.n249 VDD.n248 0.0104174
R1241 VDD.n248 VDD.n31 0.0104174
R1242 VDD.n257 VDD.n30 0.0104174
R1243 VDD.n258 VDD.n257 0.0104174
R1244 VDD.n264 VDD.n263 0.0104174
R1245 VDD.n264 VDD.n27 0.0104174
R1246 VDD.n269 VDD.n25 0.0104174
R1247 VDD.n272 VDD.n25 0.0104174
R1248 VDD.n249 VDD.n32 0.00930165
R1249 VDD.n273 VDD.n272 0.00930165
R1250 VDD.n71 VDD.n70 0.0086448
R1251 VDD.n70 VDD.n35 0.0086448
R1252 VDD.n238 VDD.n36 0.0086448
R1253 VDD.n37 VDD.n36 0.0086448
R1254 VDD.n39 VDD.n37 0.0086448
R1255 VDD.n234 VDD.n39 0.0086448
R1256 VDD.n234 VDD.n233 0.0086448
R1257 VDD.n233 VDD.n41 0.0086448
R1258 VDD.n230 VDD.n41 0.0086448
R1259 VDD.n230 VDD.n229 0.0086448
R1260 VDD.n229 VDD.n0 0.0086448
R1261 VDD VDD.n0 0.0086448
R1262 VDD VDD.n2 0.0086448
R1263 VDD.n3 VDD.n2 0.0086448
R1264 VDD.n292 VDD.n3 0.0086448
R1265 VDD.n292 VDD.n4 0.0086448
R1266 VDD.n289 VDD.n4 0.0086448
R1267 VDD.n289 VDD.n288 0.0086448
R1268 VDD.n288 VDD.n10 0.0086448
R1269 VDD.n13 VDD.n10 0.0086448
R1270 VDD.n14 VDD.n13 0.0086448
R1271 VDD.n284 VDD.n14 0.0086448
R1272 VDD.n282 VDD.n17 0.0086448
R1273 VDD.n279 VDD.n17 0.0086448
R1274 VDD.n239 VDD.n238 0.00772851
R1275 VDD.n284 VDD.n283 0.00772851
R1276 VDD.n71 VDD.n33 0.00599774
R1277 VDD.n279 VDD.n278 0.00599774
R1278 VDD.n239 VDD.n35 0.00141629
R1279 VDD.n283 VDD.n282 0.00141629
R1280 VSS.n389 VSS.n388 29675.6
R1281 VSS.n387 VSS.n34 255.987
R1282 VSS.n32 VSS.n30 255.987
R1283 VSS.n387 VSS.n35 255.987
R1284 VSS.n391 VSS.n30 255.987
R1285 VSS.n388 VSS.n33 151.605
R1286 VSS.n417 VSS.n4 142.431
R1287 VSS.n415 VSS.n4 142.431
R1288 VSS.n239 VSS.n120 142.431
R1289 VSS.n199 VSS.n120 142.431
R1290 VSS.n390 VSS.n389 131.601
R1291 VSS.n211 VSS.n33 84.2247
R1292 VSS.n211 VSS.n207 84.2247
R1293 VSS.n220 VSS.n207 84.2247
R1294 VSS.n221 VSS.n220 84.2247
R1295 VSS.n223 VSS.n221 84.2247
R1296 VSS.n296 VSS.n294 84.2247
R1297 VSS.n298 VSS.n296 84.2247
R1298 VSS.n299 VSS.n298 84.2247
R1299 VSS.n299 VSS.n31 84.2247
R1300 VSS.n390 VSS.n31 84.2247
R1301 VSS.n222 VSS.n121 75.8023
R1302 VSS.n293 VSS.n6 75.8023
R1303 VSS.n238 VSS.n121 42.1126
R1304 VSS.n238 VSS.n237 42.1126
R1305 VSS.n237 VSS.n235 42.1126
R1306 VSS.n235 VSS.n112 42.1126
R1307 VSS.n251 VSS.n112 42.1126
R1308 VSS.n251 VSS.n113 42.1126
R1309 VSS.n116 VSS.n113 42.1126
R1310 VSS.n116 VSS.n115 42.1126
R1311 VSS.n115 VSS.n91 42.1126
R1312 VSS.n277 VSS.n91 42.1126
R1313 VSS.n277 VSS.n275 42.1126
R1314 VSS.n275 VSS.n82 42.1126
R1315 VSS.n328 VSS.n82 42.1126
R1316 VSS.n328 VSS.n327 42.1126
R1317 VSS.n327 VSS.n326 42.1126
R1318 VSS.n326 VSS.n74 42.1126
R1319 VSS.n338 VSS.n74 42.1126
R1320 VSS.n338 VSS.n75 42.1126
R1321 VSS.n75 VSS.n56 42.1126
R1322 VSS.n358 VSS.n56 42.1126
R1323 VSS.n358 VSS.n357 42.1126
R1324 VSS.n357 VSS.n12 42.1126
R1325 VSS.n407 VSS.n12 42.1126
R1326 VSS.n407 VSS.n406 42.1126
R1327 VSS.n406 VSS.n15 42.1126
R1328 VSS.n15 VSS.n5 42.1126
R1329 VSS.n416 VSS.n5 42.1126
R1330 VSS.n416 VSS.n6 42.1126
R1331 VSS.n189 VSS.n188 24.363
R1332 VSS.n161 VSS.n160 24.363
R1333 VSS.n389 VSS.n30 20.1144
R1334 VSS.n239 VSS.n114 15.5561
R1335 VSS.n250 VSS.n114 15.5561
R1336 VSS.n250 VSS.n117 15.5561
R1337 VSS.n246 VSS.n117 15.5561
R1338 VSS.n246 VSS.n81 15.5561
R1339 VSS.n329 VSS.n81 15.5561
R1340 VSS.n329 VSS.n76 15.5561
R1341 VSS.n337 VSS.n76 15.5561
R1342 VSS.n337 VSS.n77 15.5561
R1343 VSS.n77 VSS.n11 15.5561
R1344 VSS.n408 VSS.n11 15.5561
R1345 VSS.n408 VSS.n7 15.5561
R1346 VSS.n415 VSS.n7 15.5561
R1347 VSS.n199 VSS.n110 15.5561
R1348 VSS.n252 VSS.n110 15.5561
R1349 VSS.n252 VSS.n111 15.5561
R1350 VSS.n111 VSS.n92 15.5561
R1351 VSS.n274 VSS.n92 15.5561
R1352 VSS.n274 VSS.n83 15.5561
R1353 VSS.n83 VSS.n73 15.5561
R1354 VSS.n339 VSS.n73 15.5561
R1355 VSS.n339 VSS.n58 15.5561
R1356 VSS.n356 VSS.n58 15.5561
R1357 VSS.n356 VSS.n13 15.5561
R1358 VSS.n13 VSS.n3 15.5561
R1359 VSS.n417 VSS.n3 15.5561
R1360 VSS.n212 VSS.n34 15.5561
R1361 VSS.n212 VSS.n208 15.5561
R1362 VSS.n218 VSS.n208 15.5561
R1363 VSS.n218 VSS.n206 15.5561
R1364 VSS.n224 VSS.n206 15.5561
R1365 VSS.n224 VSS.n200 15.5561
R1366 VSS.n234 VSS.n200 15.5561
R1367 VSS.n234 VSS.n201 15.5561
R1368 VSS.n228 VSS.n201 15.5561
R1369 VSS.n228 VSS.n90 15.5561
R1370 VSS.n278 VSS.n90 15.5561
R1371 VSS.n278 VSS.n84 15.5561
R1372 VSS.n325 VSS.n84 15.5561
R1373 VSS.n325 VSS.n85 15.5561
R1374 VSS.n283 VSS.n85 15.5561
R1375 VSS.n283 VSS.n57 15.5561
R1376 VSS.n284 VSS.n57 15.5561
R1377 VSS.n284 VSS.n14 15.5561
R1378 VSS.n287 VSS.n14 15.5561
R1379 VSS.n288 VSS.n287 15.5561
R1380 VSS.n289 VSS.n288 15.5561
R1381 VSS.n295 VSS.n289 15.5561
R1382 VSS.n295 VSS.n292 15.5561
R1383 VSS.n300 VSS.n292 15.5561
R1384 VSS.n301 VSS.n300 15.5561
R1385 VSS.n301 VSS.n32 15.5561
R1386 VSS.n38 VSS.n35 15.5561
R1387 VSS.n39 VSS.n38 15.5561
R1388 VSS.n219 VSS.n39 15.5561
R1389 VSS.n219 VSS.n42 15.5561
R1390 VSS.n43 VSS.n42 15.5561
R1391 VSS.n44 VSS.n43 15.5561
R1392 VSS.n236 VSS.n44 15.5561
R1393 VSS.n236 VSS.n47 15.5561
R1394 VSS.n48 VSS.n47 15.5561
R1395 VSS.n49 VSS.n48 15.5561
R1396 VSS.n276 VSS.n49 15.5561
R1397 VSS.n276 VSS.n51 15.5561
R1398 VSS.n52 VSS.n51 15.5561
R1399 VSS.n53 VSS.n52 15.5561
R1400 VSS.n55 VSS.n53 15.5561
R1401 VSS.n359 VSS.n55 15.5561
R1402 VSS.n359 VSS.n16 15.5561
R1403 VSS.n405 VSS.n16 15.5561
R1404 VSS.n405 VSS.n17 15.5561
R1405 VSS.n22 VSS.n17 15.5561
R1406 VSS.n23 VSS.n22 15.5561
R1407 VSS.n24 VSS.n23 15.5561
R1408 VSS.n297 VSS.n24 15.5561
R1409 VSS.n297 VSS.n27 15.5561
R1410 VSS.n28 VSS.n27 15.5561
R1411 VSS.n391 VSS.n28 15.5561
R1412 VSS.n352 VSS.n351 12.5005
R1413 VSS.n154 VSS.n153 12.5005
R1414 VSS.n170 VSS.n147 12.5005
R1415 VSS.n172 VSS.n171 12.5005
R1416 VSS.n173 VSS.n145 12.5005
R1417 VSS.n174 VSS.n140 12.5005
R1418 VSS.n176 VSS.n175 12.5005
R1419 VSS.n142 VSS.n137 12.5005
R1420 VSS.n181 VSS.n132 12.5005
R1421 VSS.n183 VSS.n182 12.5005
R1422 VSS.n184 VSS.n130 12.5005
R1423 VSS.n186 VSS.n185 12.5005
R1424 VSS.n349 VSS.n61 12.5005
R1425 VSS.n347 VSS.n346 12.5005
R1426 VSS.n71 VSS.n67 12.5005
R1427 VSS.n268 VSS.n70 12.5005
R1428 VSS.n270 VSS.n269 12.5005
R1429 VSS.n266 VSS.n95 12.5005
R1430 VSS.n264 VSS.n263 12.5005
R1431 VSS.n261 VSS.n98 12.5005
R1432 VSS.n107 VSS.n106 12.5005
R1433 VSS.n104 VSS.n102 12.5005
R1434 VSS.n62 VSS.n0 12.1268
R1435 VSS.n196 VSS.n101 12.1268
R1436 VSS.n167 VSS.n166 12.1268
R1437 VSS.n133 VSS.n126 12.1268
R1438 Isum VSS.n420 11.9273
R1439 VSS.n104 VSS.n103 11.863
R1440 VSS.n106 VSS.n105 11.863
R1441 VSS.n264 VSS.n99 11.863
R1442 VSS.n266 VSS.n265 11.863
R1443 VSS.n268 VSS.n267 11.863
R1444 VSS.n67 VSS.n66 11.863
R1445 VSS.n349 VSS.n348 11.863
R1446 VSS.n351 VSS.n350 11.863
R1447 VSS.n185 VSS.n128 11.863
R1448 VSS.n184 VSS.n129 11.863
R1449 VSS.n132 VSS.n131 11.863
R1450 VSS.n142 VSS.n141 11.863
R1451 VSS.n174 VSS.n143 11.863
R1452 VSS.n173 VSS.n144 11.863
R1453 VSS.n147 VSS.n146 11.863
R1454 VSS.n153 VSS.n152 11.863
R1455 VSS.n190 VSS.n124 9.8285
R1456 VSS.n192 VSS.n124 9.8285
R1457 VSS.n163 VSS.n162 9.8285
R1458 VSS.n162 VSS.n159 9.8285
R1459 VSS.n353 VSS.n63 8.63568
R1460 VSS.n342 VSS.n341 8.63568
R1461 VSS.n258 VSS.n94 8.63568
R1462 VSS.n255 VSS.n254 8.63568
R1463 VSS.n169 VSS.n168 8.63568
R1464 VSS.n149 VSS.n148 8.63568
R1465 VSS.n180 VSS.n179 8.63568
R1466 VSS.n134 VSS.n127 8.63568
R1467 VSS.n346 VSS.n345 8.59884
R1468 VSS.n270 VSS.n96 8.59884
R1469 VSS.n261 VSS.n260 8.59884
R1470 VSS.n171 VSS.n151 8.59884
R1471 VSS.n177 VSS.n176 8.59884
R1472 VSS.n182 VSS.n136 8.59884
R1473 VSS.n223 VSS.n222 8.42292
R1474 VSS.n294 VSS.n293 8.42292
R1475 VSS.n106 VSS.n104 8.1765
R1476 VSS.n266 VSS.n264 8.1765
R1477 VSS.n268 VSS.n67 8.1765
R1478 VSS.n351 VSS.n349 8.1765
R1479 VSS.n185 VSS.n184 8.1765
R1480 VSS.n142 VSS.n132 8.1765
R1481 VSS.n174 VSS.n173 8.1765
R1482 VSS.n153 VSS.n147 8.1765
R1483 VSS.n386 VSS.n36 7.08143
R1484 VSS.n386 VSS.n385 7.08143
R1485 VSS.n303 VSS.n29 6.99336
R1486 VSS.n304 VSS.n303 6.99336
R1487 VSS.n413 VSS.n412 5.94383
R1488 VSS.n241 VSS.n119 5.94383
R1489 VSS.n412 VSS.n1 5.89523
R1490 VSS.n122 VSS.n119 5.89523
R1491 VSS.n418 VSS.n417 5.2005
R1492 VSS.n417 VSS.n416 5.2005
R1493 VSS.n3 VSS.n2 5.2005
R1494 VSS.n15 VSS.n3 5.2005
R1495 VSS.n354 VSS.n13 5.2005
R1496 VSS.n407 VSS.n13 5.2005
R1497 VSS.n356 VSS.n355 5.2005
R1498 VSS.n357 VSS.n356 5.2005
R1499 VSS.n59 VSS.n58 5.2005
R1500 VSS.n58 VSS.n56 5.2005
R1501 VSS.n340 VSS.n339 5.2005
R1502 VSS.n339 VSS.n338 5.2005
R1503 VSS.n73 VSS.n72 5.2005
R1504 VSS.n326 VSS.n73 5.2005
R1505 VSS.n272 VSS.n83 5.2005
R1506 VSS.n328 VSS.n83 5.2005
R1507 VSS.n274 VSS.n273 5.2005
R1508 VSS.n275 VSS.n274 5.2005
R1509 VSS.n93 VSS.n92 5.2005
R1510 VSS.n92 VSS.n91 5.2005
R1511 VSS.n111 VSS.n109 5.2005
R1512 VSS.n116 VSS.n111 5.2005
R1513 VSS.n253 VSS.n252 5.2005
R1514 VSS.n252 VSS.n251 5.2005
R1515 VSS.n110 VSS.n108 5.2005
R1516 VSS.n235 VSS.n110 5.2005
R1517 VSS.n199 VSS.n198 5.2005
R1518 VSS.n238 VSS.n199 5.2005
R1519 VSS.n415 VSS.n414 5.2005
R1520 VSS.n416 VSS.n415 5.2005
R1521 VSS.n8 VSS.n7 5.2005
R1522 VSS.n15 VSS.n7 5.2005
R1523 VSS.n409 VSS.n408 5.2005
R1524 VSS.n408 VSS.n407 5.2005
R1525 VSS.n11 VSS.n10 5.2005
R1526 VSS.n357 VSS.n11 5.2005
R1527 VSS.n335 VSS.n77 5.2005
R1528 VSS.n77 VSS.n56 5.2005
R1529 VSS.n337 VSS.n336 5.2005
R1530 VSS.n338 VSS.n337 5.2005
R1531 VSS.n78 VSS.n76 5.2005
R1532 VSS.n326 VSS.n76 5.2005
R1533 VSS.n330 VSS.n329 5.2005
R1534 VSS.n329 VSS.n328 5.2005
R1535 VSS.n81 VSS.n80 5.2005
R1536 VSS.n275 VSS.n81 5.2005
R1537 VSS.n247 VSS.n246 5.2005
R1538 VSS.n246 VSS.n91 5.2005
R1539 VSS.n248 VSS.n117 5.2005
R1540 VSS.n117 VSS.n116 5.2005
R1541 VSS.n250 VSS.n249 5.2005
R1542 VSS.n251 VSS.n250 5.2005
R1543 VSS.n118 VSS.n114 5.2005
R1544 VSS.n235 VSS.n114 5.2005
R1545 VSS.n240 VSS.n239 5.2005
R1546 VSS.n239 VSS.n238 5.2005
R1547 VSS.n210 VSS.n34 5.2005
R1548 VSS.n34 VSS.n33 5.2005
R1549 VSS.n213 VSS.n212 5.2005
R1550 VSS.n212 VSS.n211 5.2005
R1551 VSS.n209 VSS.n208 5.2005
R1552 VSS.n208 VSS.n207 5.2005
R1553 VSS.n218 VSS.n217 5.2005
R1554 VSS.n220 VSS.n218 5.2005
R1555 VSS.n206 VSS.n205 5.2005
R1556 VSS.n221 VSS.n206 5.2005
R1557 VSS.n225 VSS.n224 5.2005
R1558 VSS.n224 VSS.n223 5.2005
R1559 VSS.n202 VSS.n200 5.2005
R1560 VSS.n200 VSS.n121 5.2005
R1561 VSS.n234 VSS.n233 5.2005
R1562 VSS.n237 VSS.n234 5.2005
R1563 VSS.n203 VSS.n201 5.2005
R1564 VSS.n201 VSS.n112 5.2005
R1565 VSS.n229 VSS.n228 5.2005
R1566 VSS.n228 VSS.n113 5.2005
R1567 VSS.n90 VSS.n89 5.2005
R1568 VSS.n115 VSS.n90 5.2005
R1569 VSS.n279 VSS.n278 5.2005
R1570 VSS.n278 VSS.n277 5.2005
R1571 VSS.n86 VSS.n84 5.2005
R1572 VSS.n84 VSS.n82 5.2005
R1573 VSS.n325 VSS.n324 5.2005
R1574 VSS.n327 VSS.n325 5.2005
R1575 VSS.n87 VSS.n85 5.2005
R1576 VSS.n85 VSS.n74 5.2005
R1577 VSS.n320 VSS.n283 5.2005
R1578 VSS.n283 VSS.n75 5.2005
R1579 VSS.n319 VSS.n57 5.2005
R1580 VSS.n358 VSS.n57 5.2005
R1581 VSS.n318 VSS.n284 5.2005
R1582 VSS.n284 VSS.n12 5.2005
R1583 VSS.n285 VSS.n14 5.2005
R1584 VSS.n406 VSS.n14 5.2005
R1585 VSS.n314 VSS.n287 5.2005
R1586 VSS.n287 VSS.n5 5.2005
R1587 VSS.n313 VSS.n288 5.2005
R1588 VSS.n288 VSS.n6 5.2005
R1589 VSS.n312 VSS.n289 5.2005
R1590 VSS.n294 VSS.n289 5.2005
R1591 VSS.n295 VSS.n290 5.2005
R1592 VSS.n296 VSS.n295 5.2005
R1593 VSS.n308 VSS.n292 5.2005
R1594 VSS.n298 VSS.n292 5.2005
R1595 VSS.n307 VSS.n300 5.2005
R1596 VSS.n300 VSS.n299 5.2005
R1597 VSS.n306 VSS.n301 5.2005
R1598 VSS.n301 VSS.n31 5.2005
R1599 VSS.n302 VSS.n32 5.2005
R1600 VSS.n390 VSS.n32 5.2005
R1601 VSS.n392 VSS.n391 5.2005
R1602 VSS.n391 VSS.n390 5.2005
R1603 VSS.n393 VSS.n28 5.2005
R1604 VSS.n31 VSS.n28 5.2005
R1605 VSS.n394 VSS.n27 5.2005
R1606 VSS.n299 VSS.n27 5.2005
R1607 VSS.n297 VSS.n25 5.2005
R1608 VSS.n298 VSS.n297 5.2005
R1609 VSS.n398 VSS.n24 5.2005
R1610 VSS.n296 VSS.n24 5.2005
R1611 VSS.n399 VSS.n23 5.2005
R1612 VSS.n294 VSS.n23 5.2005
R1613 VSS.n400 VSS.n22 5.2005
R1614 VSS.n22 VSS.n6 5.2005
R1615 VSS.n19 VSS.n17 5.2005
R1616 VSS.n17 VSS.n5 5.2005
R1617 VSS.n405 VSS.n404 5.2005
R1618 VSS.n406 VSS.n405 5.2005
R1619 VSS.n18 VSS.n16 5.2005
R1620 VSS.n16 VSS.n12 5.2005
R1621 VSS.n360 VSS.n359 5.2005
R1622 VSS.n359 VSS.n358 5.2005
R1623 VSS.n55 VSS.n54 5.2005
R1624 VSS.n75 VSS.n55 5.2005
R1625 VSS.n364 VSS.n53 5.2005
R1626 VSS.n74 VSS.n53 5.2005
R1627 VSS.n365 VSS.n52 5.2005
R1628 VSS.n327 VSS.n52 5.2005
R1629 VSS.n366 VSS.n51 5.2005
R1630 VSS.n82 VSS.n51 5.2005
R1631 VSS.n276 VSS.n50 5.2005
R1632 VSS.n277 VSS.n276 5.2005
R1633 VSS.n370 VSS.n49 5.2005
R1634 VSS.n115 VSS.n49 5.2005
R1635 VSS.n371 VSS.n48 5.2005
R1636 VSS.n113 VSS.n48 5.2005
R1637 VSS.n372 VSS.n47 5.2005
R1638 VSS.n112 VSS.n47 5.2005
R1639 VSS.n236 VSS.n45 5.2005
R1640 VSS.n237 VSS.n236 5.2005
R1641 VSS.n376 VSS.n44 5.2005
R1642 VSS.n121 VSS.n44 5.2005
R1643 VSS.n377 VSS.n43 5.2005
R1644 VSS.n223 VSS.n43 5.2005
R1645 VSS.n378 VSS.n42 5.2005
R1646 VSS.n221 VSS.n42 5.2005
R1647 VSS.n219 VSS.n40 5.2005
R1648 VSS.n220 VSS.n219 5.2005
R1649 VSS.n382 VSS.n39 5.2005
R1650 VSS.n207 VSS.n39 5.2005
R1651 VSS.n383 VSS.n38 5.2005
R1652 VSS.n211 VSS.n38 5.2005
R1653 VSS.n384 VSS.n35 5.2005
R1654 VSS.n35 VSS.n33 5.2005
R1655 VSS.n193 VSS.n192 4.85463
R1656 VSS.n159 VSS.n158 4.85463
R1657 VSS.n190 VSS.n123 4.69811
R1658 VSS.n163 VSS.n157 4.69811
R1659 VSS.n242 VSS.n118 4.5005
R1660 VSS.n249 VSS.n243 4.5005
R1661 VSS.n248 VSS.n244 4.5005
R1662 VSS.n247 VSS.n245 4.5005
R1663 VSS.n80 VSS.n79 4.5005
R1664 VSS.n331 VSS.n330 4.5005
R1665 VSS.n332 VSS.n78 4.5005
R1666 VSS.n336 VSS.n333 4.5005
R1667 VSS.n335 VSS.n334 4.5005
R1668 VSS.n10 VSS.n9 4.5005
R1669 VSS.n410 VSS.n409 4.5005
R1670 VSS.n411 VSS.n8 4.5005
R1671 VSS.n414 VSS.n413 4.5005
R1672 VSS.n241 VSS.n240 4.5005
R1673 VSS.n164 VSS.n159 4.5005
R1674 VSS.n164 VSS.n163 4.5005
R1675 VSS.n192 VSS.n191 4.5005
R1676 VSS.n191 VSS.n190 4.5005
R1677 VSS.n195 VSS.n108 4.5005
R1678 VSS.n254 VSS.n253 4.5005
R1679 VSS.n109 VSS.n100 4.5005
R1680 VSS.n262 VSS.n93 4.5005
R1681 VSS.n273 VSS.n94 4.5005
R1682 VSS.n272 VSS.n271 4.5005
R1683 VSS.n97 VSS.n72 4.5005
R1684 VSS.n341 VSS.n340 4.5005
R1685 VSS.n68 VSS.n59 4.5005
R1686 VSS.n355 VSS.n60 4.5005
R1687 VSS.n354 VSS.n353 4.5005
R1688 VSS.n64 VSS.n2 4.5005
R1689 VSS.n419 VSS.n418 4.5005
R1690 VSS.n198 VSS.n197 4.5005
R1691 VSS.n210 VSS.n36 4.5005
R1692 VSS.n214 VSS.n213 4.5005
R1693 VSS.n215 VSS.n209 4.5005
R1694 VSS.n217 VSS.n216 4.5005
R1695 VSS.n205 VSS.n204 4.5005
R1696 VSS.n226 VSS.n225 4.5005
R1697 VSS.n227 VSS.n202 4.5005
R1698 VSS.n233 VSS.n232 4.5005
R1699 VSS.n231 VSS.n203 4.5005
R1700 VSS.n230 VSS.n229 4.5005
R1701 VSS.n89 VSS.n88 4.5005
R1702 VSS.n280 VSS.n279 4.5005
R1703 VSS.n281 VSS.n86 4.5005
R1704 VSS.n324 VSS.n323 4.5005
R1705 VSS.n322 VSS.n87 4.5005
R1706 VSS.n321 VSS.n320 4.5005
R1707 VSS.n319 VSS.n282 4.5005
R1708 VSS.n318 VSS.n317 4.5005
R1709 VSS.n316 VSS.n285 4.5005
R1710 VSS.n315 VSS.n314 4.5005
R1711 VSS.n313 VSS.n286 4.5005
R1712 VSS.n312 VSS.n311 4.5005
R1713 VSS.n310 VSS.n290 4.5005
R1714 VSS.n309 VSS.n308 4.5005
R1715 VSS.n307 VSS.n291 4.5005
R1716 VSS.n306 VSS.n305 4.5005
R1717 VSS.n304 VSS.n302 4.5005
R1718 VSS.n383 VSS.n37 4.5005
R1719 VSS.n382 VSS.n381 4.5005
R1720 VSS.n380 VSS.n40 4.5005
R1721 VSS.n379 VSS.n378 4.5005
R1722 VSS.n377 VSS.n41 4.5005
R1723 VSS.n376 VSS.n375 4.5005
R1724 VSS.n374 VSS.n45 4.5005
R1725 VSS.n373 VSS.n372 4.5005
R1726 VSS.n371 VSS.n46 4.5005
R1727 VSS.n370 VSS.n369 4.5005
R1728 VSS.n368 VSS.n50 4.5005
R1729 VSS.n367 VSS.n366 4.5005
R1730 VSS.n365 VSS 4.5005
R1731 VSS.n364 VSS.n363 4.5005
R1732 VSS.n362 VSS.n54 4.5005
R1733 VSS.n361 VSS.n360 4.5005
R1734 VSS.n20 VSS.n18 4.5005
R1735 VSS.n404 VSS.n403 4.5005
R1736 VSS.n402 VSS.n19 4.5005
R1737 VSS.n401 VSS.n400 4.5005
R1738 VSS.n399 VSS.n21 4.5005
R1739 VSS.n398 VSS.n397 4.5005
R1740 VSS.n396 VSS.n25 4.5005
R1741 VSS.n395 VSS.n394 4.5005
R1742 VSS.n393 VSS.n26 4.5005
R1743 VSS.n392 VSS.n29 4.5005
R1744 VSS.n385 VSS.n384 4.5005
R1745 VSS.n106 VSS.n98 4.0885
R1746 VSS.n264 VSS.n98 4.0885
R1747 VSS.n269 VSS.n266 4.0885
R1748 VSS.n269 VSS.n268 4.0885
R1749 VSS.n347 VSS.n67 4.0885
R1750 VSS.n349 VSS.n347 4.0885
R1751 VSS.n184 VSS.n183 4.0885
R1752 VSS.n183 VSS.n132 4.0885
R1753 VSS.n175 VSS.n142 4.0885
R1754 VSS.n175 VSS.n174 4.0885
R1755 VSS.n173 VSS.n172 4.0885
R1756 VSS.n172 VSS.n147 4.0885
R1757 VSS.n344 VSS.n63 3.5285
R1758 VSS.n63 VSS.n62 3.5285
R1759 VSS.n345 VSS.n343 3.5285
R1760 VSS.n345 VSS.n344 3.5285
R1761 VSS.n342 VSS.n69 3.5285
R1762 VSS.n343 VSS.n342 3.5285
R1763 VSS.n257 VSS.n96 3.5285
R1764 VSS.n96 VSS.n69 3.5285
R1765 VSS.n259 VSS.n258 3.5285
R1766 VSS.n258 VSS.n257 3.5285
R1767 VSS.n260 VSS.n256 3.5285
R1768 VSS.n260 VSS.n259 3.5285
R1769 VSS.n255 VSS.n101 3.5285
R1770 VSS.n256 VSS.n255 3.5285
R1771 VSS.n168 VSS.n155 3.5285
R1772 VSS.n168 VSS.n167 3.5285
R1773 VSS.n151 VSS.n150 3.5285
R1774 VSS.n155 VSS.n151 3.5285
R1775 VSS.n149 VSS.n139 3.5285
R1776 VSS.n150 VSS.n149 3.5285
R1777 VSS.n178 VSS.n177 3.5285
R1778 VSS.n177 VSS.n139 3.5285
R1779 VSS.n179 VSS.n138 3.5285
R1780 VSS.n179 VSS.n178 3.5285
R1781 VSS.n136 VSS.n135 3.5285
R1782 VSS.n138 VSS.n136 3.5285
R1783 VSS.n134 VSS.n133 3.5285
R1784 VSS.n135 VSS.n134 3.5285
R1785 VSS.n126 VSS.n125 0.732757
R1786 VSS.n166 VSS.n165 0.732757
R1787 VSS.n125 VSS.n122 0.716145
R1788 VSS.n165 VSS.n1 0.716145
R1789 VSS.n120 VSS.n119 0.217167
R1790 VSS.n222 VSS.n120 0.217167
R1791 VSS.n412 VSS.n4 0.217167
R1792 VSS.n293 VSS.n4 0.217167
R1793 VSS.n384 VSS.n383 0.1445
R1794 VSS.n383 VSS.n382 0.1445
R1795 VSS.n382 VSS.n40 0.1445
R1796 VSS.n378 VSS.n40 0.1445
R1797 VSS.n378 VSS.n377 0.1445
R1798 VSS.n377 VSS.n376 0.1445
R1799 VSS.n376 VSS.n45 0.1445
R1800 VSS.n372 VSS.n45 0.1445
R1801 VSS.n372 VSS.n371 0.1445
R1802 VSS.n371 VSS.n370 0.1445
R1803 VSS.n370 VSS.n50 0.1445
R1804 VSS.n366 VSS.n50 0.1445
R1805 VSS.n366 VSS.n365 0.1445
R1806 VSS.n365 VSS.n364 0.1445
R1807 VSS.n364 VSS.n54 0.1445
R1808 VSS.n360 VSS.n54 0.1445
R1809 VSS.n360 VSS.n18 0.1445
R1810 VSS.n404 VSS.n18 0.1445
R1811 VSS.n404 VSS.n19 0.1445
R1812 VSS.n400 VSS.n19 0.1445
R1813 VSS.n400 VSS.n399 0.1445
R1814 VSS.n399 VSS.n398 0.1445
R1815 VSS.n398 VSS.n25 0.1445
R1816 VSS.n394 VSS.n25 0.1445
R1817 VSS.n394 VSS.n393 0.1445
R1818 VSS.n393 VSS.n392 0.1445
R1819 VSS.n240 VSS.n118 0.1445
R1820 VSS.n249 VSS.n118 0.1445
R1821 VSS.n249 VSS.n248 0.1445
R1822 VSS.n248 VSS.n247 0.1445
R1823 VSS.n247 VSS.n80 0.1445
R1824 VSS.n330 VSS.n80 0.1445
R1825 VSS.n330 VSS.n78 0.1445
R1826 VSS.n336 VSS.n78 0.1445
R1827 VSS.n336 VSS.n335 0.1445
R1828 VSS.n335 VSS.n10 0.1445
R1829 VSS.n409 VSS.n10 0.1445
R1830 VSS.n409 VSS.n8 0.1445
R1831 VSS.n414 VSS.n8 0.1445
R1832 VSS.n242 VSS.n241 0.1445
R1833 VSS.n243 VSS.n242 0.1445
R1834 VSS.n244 VSS.n243 0.1445
R1835 VSS.n245 VSS.n244 0.1445
R1836 VSS.n245 VSS.n79 0.1445
R1837 VSS.n331 VSS.n79 0.1445
R1838 VSS.n332 VSS.n331 0.1445
R1839 VSS.n333 VSS.n332 0.1445
R1840 VSS.n334 VSS.n333 0.1445
R1841 VSS.n334 VSS.n9 0.1445
R1842 VSS.n410 VSS.n9 0.1445
R1843 VSS.n411 VSS.n410 0.1445
R1844 VSS.n413 VSS.n411 0.1445
R1845 VSS.n198 VSS.n108 0.1445
R1846 VSS.n253 VSS.n108 0.1445
R1847 VSS.n253 VSS.n109 0.1445
R1848 VSS.n109 VSS.n93 0.1445
R1849 VSS.n273 VSS.n93 0.1445
R1850 VSS.n273 VSS.n272 0.1445
R1851 VSS.n272 VSS.n72 0.1445
R1852 VSS.n340 VSS.n72 0.1445
R1853 VSS.n340 VSS.n59 0.1445
R1854 VSS.n355 VSS.n59 0.1445
R1855 VSS.n355 VSS.n354 0.1445
R1856 VSS.n354 VSS.n2 0.1445
R1857 VSS.n418 VSS.n2 0.1445
R1858 VSS.n213 VSS.n210 0.1445
R1859 VSS.n213 VSS.n209 0.1445
R1860 VSS.n217 VSS.n209 0.1445
R1861 VSS.n217 VSS.n205 0.1445
R1862 VSS.n225 VSS.n205 0.1445
R1863 VSS.n225 VSS.n202 0.1445
R1864 VSS.n233 VSS.n202 0.1445
R1865 VSS.n233 VSS.n203 0.1445
R1866 VSS.n229 VSS.n203 0.1445
R1867 VSS.n229 VSS.n89 0.1445
R1868 VSS.n279 VSS.n89 0.1445
R1869 VSS.n279 VSS.n86 0.1445
R1870 VSS.n324 VSS.n86 0.1445
R1871 VSS.n324 VSS.n87 0.1445
R1872 VSS.n320 VSS.n87 0.1445
R1873 VSS.n320 VSS.n319 0.1445
R1874 VSS.n319 VSS.n318 0.1445
R1875 VSS.n318 VSS.n285 0.1445
R1876 VSS.n314 VSS.n285 0.1445
R1877 VSS.n314 VSS.n313 0.1445
R1878 VSS.n313 VSS.n312 0.1445
R1879 VSS.n312 VSS.n290 0.1445
R1880 VSS.n308 VSS.n290 0.1445
R1881 VSS.n308 VSS.n307 0.1445
R1882 VSS.n307 VSS.n306 0.1445
R1883 VSS.n306 VSS.n302 0.1445
R1884 VSS.n214 VSS.n36 0.1445
R1885 VSS.n215 VSS.n214 0.1445
R1886 VSS.n216 VSS.n215 0.1445
R1887 VSS.n216 VSS.n204 0.1445
R1888 VSS.n226 VSS.n204 0.1445
R1889 VSS.n227 VSS.n226 0.1445
R1890 VSS.n232 VSS.n227 0.1445
R1891 VSS.n232 VSS.n231 0.1445
R1892 VSS.n231 VSS.n230 0.1445
R1893 VSS.n230 VSS.n88 0.1445
R1894 VSS.n280 VSS.n88 0.1445
R1895 VSS.n281 VSS.n280 0.1445
R1896 VSS.n323 VSS.n281 0.1445
R1897 VSS.n323 VSS.n322 0.1445
R1898 VSS.n322 VSS.n321 0.1445
R1899 VSS.n321 VSS.n282 0.1445
R1900 VSS.n317 VSS.n282 0.1445
R1901 VSS.n317 VSS.n316 0.1445
R1902 VSS.n316 VSS.n315 0.1445
R1903 VSS.n315 VSS.n286 0.1445
R1904 VSS.n311 VSS.n286 0.1445
R1905 VSS.n311 VSS.n310 0.1445
R1906 VSS.n310 VSS.n309 0.1445
R1907 VSS.n309 VSS.n291 0.1445
R1908 VSS.n305 VSS.n291 0.1445
R1909 VSS.n305 VSS.n304 0.1445
R1910 VSS.n385 VSS.n37 0.1445
R1911 VSS.n381 VSS.n37 0.1445
R1912 VSS.n381 VSS.n380 0.1445
R1913 VSS.n380 VSS.n379 0.1445
R1914 VSS.n379 VSS.n41 0.1445
R1915 VSS.n375 VSS.n41 0.1445
R1916 VSS.n375 VSS.n374 0.1445
R1917 VSS.n374 VSS.n373 0.1445
R1918 VSS.n373 VSS.n46 0.1445
R1919 VSS.n369 VSS.n46 0.1445
R1920 VSS.n369 VSS.n368 0.1445
R1921 VSS.n368 VSS.n367 0.1445
R1922 VSS.n367 VSS 0.1445
R1923 VSS.n363 VSS 0.1445
R1924 VSS.n363 VSS.n362 0.1445
R1925 VSS.n362 VSS.n361 0.1445
R1926 VSS.n361 VSS.n20 0.1445
R1927 VSS.n403 VSS.n20 0.1445
R1928 VSS.n403 VSS.n402 0.1445
R1929 VSS.n402 VSS.n401 0.1445
R1930 VSS.n401 VSS.n21 0.1445
R1931 VSS.n397 VSS.n21 0.1445
R1932 VSS.n397 VSS.n396 0.1445
R1933 VSS.n396 VSS.n395 0.1445
R1934 VSS.n395 VSS.n26 0.1445
R1935 VSS.n29 VSS.n26 0.1445
R1936 VSS.n303 VSS.n30 0.111138
R1937 VSS.n387 VSS.n386 0.111138
R1938 VSS.n388 VSS.n387 0.111138
R1939 VSS.n164 VSS.n161 0.0424731
R1940 VSS.n191 VSS.n189 0.0424731
R1941 VSS.n158 VSS.n157 0.032787
R1942 VSS.n193 VSS.n123 0.032787
R1943 VSS.n158 VSS.n65 0.0315762
R1944 VSS.n161 VSS.n156 0.0315762
R1945 VSS.n194 VSS.n193 0.0315762
R1946 VSS.n189 VSS.n187 0.0315762
R1947 VSS.n165 VSS.n157 0.0265314
R1948 VSS.n125 VSS.n123 0.0265314
R1949 VSS.n182 VSS.n130 0.0203347
R1950 VSS.n182 VSS.n181 0.0203347
R1951 VSS.n176 VSS.n137 0.0203347
R1952 VSS.n176 VSS.n140 0.0203347
R1953 VSS.n171 VSS.n145 0.0203347
R1954 VSS.n171 VSS.n170 0.0203347
R1955 VSS.n165 VSS.n164 0.0168453
R1956 VSS.n191 VSS.n125 0.0168453
R1957 VSS.n187 VSS.n126 0.0115331
R1958 VSS.n166 VSS.n156 0.0115331
R1959 VSS.n186 VSS.n127 0.0104174
R1960 VSS.n130 VSS.n127 0.0104174
R1961 VSS.n181 VSS.n180 0.0104174
R1962 VSS.n180 VSS.n137 0.0104174
R1963 VSS.n148 VSS.n140 0.0104174
R1964 VSS.n148 VSS.n145 0.0104174
R1965 VSS.n170 VSS.n169 0.0104174
R1966 VSS.n169 VSS.n154 0.0104174
R1967 VSS.n187 VSS.n186 0.00930165
R1968 VSS.n156 VSS.n154 0.00930165
R1969 VSS.n197 VSS.n196 0.0086448
R1970 VSS.n196 VSS.n195 0.0086448
R1971 VSS.n254 VSS.n102 0.0086448
R1972 VSS.n254 VSS.n107 0.0086448
R1973 VSS.n107 VSS.n100 0.0086448
R1974 VSS.n261 VSS.n100 0.0086448
R1975 VSS.n262 VSS.n261 0.0086448
R1976 VSS.n263 VSS.n262 0.0086448
R1977 VSS.n263 VSS.n94 0.0086448
R1978 VSS.n95 VSS.n94 0.0086448
R1979 VSS.n271 VSS.n95 0.0086448
R1980 VSS.n271 VSS.n270 0.0086448
R1981 VSS.n270 VSS.n97 0.0086448
R1982 VSS.n97 VSS.n70 0.0086448
R1983 VSS.n341 VSS.n70 0.0086448
R1984 VSS.n341 VSS.n71 0.0086448
R1985 VSS.n71 VSS.n68 0.0086448
R1986 VSS.n346 VSS.n68 0.0086448
R1987 VSS.n346 VSS.n60 0.0086448
R1988 VSS.n61 VSS.n60 0.0086448
R1989 VSS.n353 VSS.n61 0.0086448
R1990 VSS.n353 VSS.n352 0.0086448
R1991 VSS.n64 VSS.n0 0.0086448
R1992 VSS.n194 VSS.n102 0.00772851
R1993 VSS.n352 VSS.n65 0.00772851
R1994 VSS.n197 VSS.n122 0.00599774
R1995 VSS.n419 VSS.n1 0.00599774
R1996 VSS.n420 VSS.n419 0.00497964
R1997 VSS.n420 VSS.n0 0.00416516
R1998 VSS.n195 VSS.n194 0.00141629
R1999 VSS.n65 VSS.n64 0.00141629
C0 Isum VDD 7.18505f
C1 Vthr VDD 1.35344f
C2 Isyn VDD 3.09305f
C3 VDD a_n90_4665# 5.59586f
C4 Isum a_n90_4665# 2.43474f
C5 VT VDD 1.81726f
C6 Vthr VSS 7.28889f
C7 Isyn VSS 4.83308f
C8 VT VSS 7.13956f
C9 Isum VSS 16.35745f
C10 VDD VSS 49.07336f
C11 a_n90_4665# VSS 13.7798f
C12 VDD.t51 VSS 12.5661f
C13 Isum.n61 VSS 0.56282f
C14 Isum.n346 VSS 4.36413f
C15 Isum.n347 VSS 0.79779f
.ends
