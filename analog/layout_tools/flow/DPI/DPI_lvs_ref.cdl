* LVS reference for DPI.gds (glayout_floorplan.two_row)
* note: M1: 0.22/0.28 -> 0.5/0.64 (W/L kept)
* note: M2: 0.22/0.28 -> 0.5/0.64 (W/L kept)
* note: M3: 0.22/0.28 -> 0.5/0.64 (W/L kept)
* note: M4: 0.22/0.28 -> 0.5/0.64 (W/L kept)
.subckt DPI VDD Vthr Isyn Isum VT VSS
MM1 VDD Vthr Isum Isum nfet_03v3 L=0.64u W=0.5u nf=1
MM2 net1 net1 Isum Isum nfet_03v3 L=0.64u W=0.5u nf=1
MM3 net1 VT VDD VDD pfet_03v3 L=0.64u W=0.5u nf=1
MM4 Isyn net1 VDD VDD pfet_03v3 L=0.64u W=0.5u nf=1
C2 VDD net1 cap_mim_2f0fF W=22.18e-6 L=22.18e-6 m=1
MDNI0N0 Isum Isum Isum Isum nfet_03v3 L=0.64u W=0.5u nf=1
MDNI0N1 Isum Isum Isum Isum nfet_03v3 L=0.64u W=0.5u nf=1
MDNI0N2 Isum Isum Isum Isum nfet_03v3 L=0.64u W=0.5u nf=1
MDNI0N3 Isum Isum Isum Isum nfet_03v3 L=0.64u W=0.5u nf=1
MDNI0N4 Isum Isum Isum Isum nfet_03v3 L=0.64u W=0.5u nf=1
MDNI0N5 Isum Isum Isum Isum nfet_03v3 L=0.64u W=0.5u nf=1
MDNI0N6 Isum Isum Isum Isum nfet_03v3 L=0.64u W=0.5u nf=1
MDNI0N7 Isum Isum Isum Isum nfet_03v3 L=0.64u W=0.5u nf=1
MDNI0S0 Isum Isum Isum Isum nfet_03v3 L=0.64u W=0.5u nf=1
MDNI0S1 Isum Isum Isum Isum nfet_03v3 L=0.64u W=0.5u nf=1
MDNI0S2 Isum Isum Isum Isum nfet_03v3 L=0.64u W=0.5u nf=1
MDNI0S3 Isum Isum Isum Isum nfet_03v3 L=0.64u W=0.5u nf=1
MDNI0S4 Isum Isum Isum Isum nfet_03v3 L=0.64u W=0.5u nf=1
MDNI0S5 Isum Isum Isum Isum nfet_03v3 L=0.64u W=0.5u nf=1
MDNI0S6 Isum Isum Isum Isum nfet_03v3 L=0.64u W=0.5u nf=1
MDNI0S7 Isum Isum Isum Isum nfet_03v3 L=0.64u W=0.5u nf=1
MDNI0W0 Isum Isum Isum Isum nfet_03v3 L=0.64u W=0.5u nf=1
MDNI0E0 Isum Isum Isum Isum nfet_03v3 L=0.64u W=0.5u nf=1
MDPN0 VDD VDD VDD VDD pfet_03v3 L=0.64u W=0.5u nf=1
MDPN1 VDD VDD VDD VDD pfet_03v3 L=0.64u W=0.5u nf=1
MDPN2 VDD VDD VDD VDD pfet_03v3 L=0.64u W=0.5u nf=1
MDPN3 VDD VDD VDD VDD pfet_03v3 L=0.64u W=0.5u nf=1
MDPN4 VDD VDD VDD VDD pfet_03v3 L=0.64u W=0.5u nf=1
MDPN5 VDD VDD VDD VDD pfet_03v3 L=0.64u W=0.5u nf=1
MDPN6 VDD VDD VDD VDD pfet_03v3 L=0.64u W=0.5u nf=1
MDPN7 VDD VDD VDD VDD pfet_03v3 L=0.64u W=0.5u nf=1
MDPS0 VDD VDD VDD VDD pfet_03v3 L=0.64u W=0.5u nf=1
MDPS1 VDD VDD VDD VDD pfet_03v3 L=0.64u W=0.5u nf=1
MDPS2 VDD VDD VDD VDD pfet_03v3 L=0.64u W=0.5u nf=1
MDPS3 VDD VDD VDD VDD pfet_03v3 L=0.64u W=0.5u nf=1
MDPS4 VDD VDD VDD VDD pfet_03v3 L=0.64u W=0.5u nf=1
MDPS5 VDD VDD VDD VDD pfet_03v3 L=0.64u W=0.5u nf=1
MDPS6 VDD VDD VDD VDD pfet_03v3 L=0.64u W=0.5u nf=1
MDPS7 VDD VDD VDD VDD pfet_03v3 L=0.64u W=0.5u nf=1
MDPW0 VDD VDD VDD VDD pfet_03v3 L=0.64u W=0.5u nf=1
MDPE0 VDD VDD VDD VDD pfet_03v3 L=0.64u W=0.5u nf=1
.ends
