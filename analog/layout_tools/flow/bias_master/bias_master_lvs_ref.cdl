* LVS reference for bias_master.gds (glayout_floorplan.two_row)
* note: R: 2 x 585.38 um n-well resistor drawn as 12 bars in series (48.79, 48.79, 48.78, 48.78, 48.78, 48.78, 48.78, 48.78, 48.78, 48.78, 48.78, 48.78 um; joints R_j<k>)
* note: M3: m=4 x nf=1 -> nf=4, m=1 (parallel copies as fingers)
* note: M4: m=4 x nf=1 -> nf=4, m=1 (parallel copies as fingers)
* note: M2: m=64 x nf=1 -> nf=64, m=1 (parallel copies as fingers)
* note: M1: m=8 x nf=1 -> nf=8, m=1 (parallel copies as fingers)
* note: MS2: m=16 x nf=1 -> nf=16, m=1 (parallel copies as fingers)
* note: MREF: m=4 x nf=1 -> nf=4, m=1 (parallel copies as fingers)
* note: G2 common-centroid, 28 units: C B C A C B C C B C A C B C C B C A C B C C B C A C B C (A=MREF x4, B=M1 x8, C=MS2 x16)
.subckt bias_master VDD VSS Iref
MMS2_u0 X Vgn VSS VSS nfet_03v3 L=6u W=1u nf=1
MM1_u0 Vgn Vgn VSS VSS nfet_03v3 L=6u W=1u nf=1
MMS2_u1 X Vgn VSS VSS nfet_03v3 L=6u W=1u nf=1
MMREF_u0 Iref Vgn VSS VSS nfet_03v3 L=6u W=1u nf=1
MMS2_u2 X Vgn VSS VSS nfet_03v3 L=6u W=1u nf=1
MM1_u1 Vgn Vgn VSS VSS nfet_03v3 L=6u W=1u nf=1
MMS2_u3 X Vgn VSS VSS nfet_03v3 L=6u W=1u nf=1
MMS2_u4 X Vgn VSS VSS nfet_03v3 L=6u W=1u nf=1
MM1_u2 Vgn Vgn VSS VSS nfet_03v3 L=6u W=1u nf=1
MMS2_u5 X Vgn VSS VSS nfet_03v3 L=6u W=1u nf=1
MMREF_u1 Iref Vgn VSS VSS nfet_03v3 L=6u W=1u nf=1
MMS2_u6 X Vgn VSS VSS nfet_03v3 L=6u W=1u nf=1
MM1_u3 Vgn Vgn VSS VSS nfet_03v3 L=6u W=1u nf=1
MMS2_u7 X Vgn VSS VSS nfet_03v3 L=6u W=1u nf=1
MMS2_u8 X Vgn VSS VSS nfet_03v3 L=6u W=1u nf=1
MM1_u4 Vgn Vgn VSS VSS nfet_03v3 L=6u W=1u nf=1
MMS2_u9 X Vgn VSS VSS nfet_03v3 L=6u W=1u nf=1
MMREF_u2 Iref Vgn VSS VSS nfet_03v3 L=6u W=1u nf=1
MMS2_u10 X Vgn VSS VSS nfet_03v3 L=6u W=1u nf=1
MM1_u5 Vgn Vgn VSS VSS nfet_03v3 L=6u W=1u nf=1
MMS2_u11 X Vgn VSS VSS nfet_03v3 L=6u W=1u nf=1
MMS2_u12 X Vgn VSS VSS nfet_03v3 L=6u W=1u nf=1
MM1_u6 Vgn Vgn VSS VSS nfet_03v3 L=6u W=1u nf=1
MMS2_u13 X Vgn VSS VSS nfet_03v3 L=6u W=1u nf=1
MMREF_u3 Iref Vgn VSS VSS nfet_03v3 L=6u W=1u nf=1
MMS2_u14 X Vgn VSS VSS nfet_03v3 L=6u W=1u nf=1
MM1_u7 Vgn Vgn VSS VSS nfet_03v3 L=6u W=1u nf=1
MMS2_u15 X Vgn VSS VSS nfet_03v3 L=6u W=1u nf=1
MM2_f0 Vgp Vgn Vr VSS nfet_03v3 L=6u W=1u nf=1
MM2_f1 Vgp Vgn Vr VSS nfet_03v3 L=6u W=1u nf=1
MM2_f2 Vgp Vgn Vr VSS nfet_03v3 L=6u W=1u nf=1
MM2_f3 Vgp Vgn Vr VSS nfet_03v3 L=6u W=1u nf=1
MM2_f4 Vgp Vgn Vr VSS nfet_03v3 L=6u W=1u nf=1
MM2_f5 Vgp Vgn Vr VSS nfet_03v3 L=6u W=1u nf=1
MM2_f6 Vgp Vgn Vr VSS nfet_03v3 L=6u W=1u nf=1
MM2_f7 Vgp Vgn Vr VSS nfet_03v3 L=6u W=1u nf=1
MM2_f8 Vgp Vgn Vr VSS nfet_03v3 L=6u W=1u nf=1
MM2_f9 Vgp Vgn Vr VSS nfet_03v3 L=6u W=1u nf=1
MM2_f10 Vgp Vgn Vr VSS nfet_03v3 L=6u W=1u nf=1
MM2_f11 Vgp Vgn Vr VSS nfet_03v3 L=6u W=1u nf=1
MM2_f12 Vgp Vgn Vr VSS nfet_03v3 L=6u W=1u nf=1
MM2_f13 Vgp Vgn Vr VSS nfet_03v3 L=6u W=1u nf=1
MM2_f14 Vgp Vgn Vr VSS nfet_03v3 L=6u W=1u nf=1
MM2_f15 Vgp Vgn Vr VSS nfet_03v3 L=6u W=1u nf=1
MM2_f16 Vgp Vgn Vr VSS nfet_03v3 L=6u W=1u nf=1
MM2_f17 Vgp Vgn Vr VSS nfet_03v3 L=6u W=1u nf=1
MM2_f18 Vgp Vgn Vr VSS nfet_03v3 L=6u W=1u nf=1
MM2_f19 Vgp Vgn Vr VSS nfet_03v3 L=6u W=1u nf=1
MM2_f20 Vgp Vgn Vr VSS nfet_03v3 L=6u W=1u nf=1
MM2_f21 Vgp Vgn Vr VSS nfet_03v3 L=6u W=1u nf=1
MM2_f22 Vgp Vgn Vr VSS nfet_03v3 L=6u W=1u nf=1
MM2_f23 Vgp Vgn Vr VSS nfet_03v3 L=6u W=1u nf=1
MM2_f24 Vgp Vgn Vr VSS nfet_03v3 L=6u W=1u nf=1
MM2_f25 Vgp Vgn Vr VSS nfet_03v3 L=6u W=1u nf=1
MM2_f26 Vgp Vgn Vr VSS nfet_03v3 L=6u W=1u nf=1
MM2_f27 Vgp Vgn Vr VSS nfet_03v3 L=6u W=1u nf=1
MM2_f28 Vgp Vgn Vr VSS nfet_03v3 L=6u W=1u nf=1
MM2_f29 Vgp Vgn Vr VSS nfet_03v3 L=6u W=1u nf=1
MM2_f30 Vgp Vgn Vr VSS nfet_03v3 L=6u W=1u nf=1
MM2_f31 Vgp Vgn Vr VSS nfet_03v3 L=6u W=1u nf=1
MM2_f32 Vgp Vgn Vr VSS nfet_03v3 L=6u W=1u nf=1
MM2_f33 Vgp Vgn Vr VSS nfet_03v3 L=6u W=1u nf=1
MM2_f34 Vgp Vgn Vr VSS nfet_03v3 L=6u W=1u nf=1
MM2_f35 Vgp Vgn Vr VSS nfet_03v3 L=6u W=1u nf=1
MM2_f36 Vgp Vgn Vr VSS nfet_03v3 L=6u W=1u nf=1
MM2_f37 Vgp Vgn Vr VSS nfet_03v3 L=6u W=1u nf=1
MM2_f38 Vgp Vgn Vr VSS nfet_03v3 L=6u W=1u nf=1
MM2_f39 Vgp Vgn Vr VSS nfet_03v3 L=6u W=1u nf=1
MM2_f40 Vgp Vgn Vr VSS nfet_03v3 L=6u W=1u nf=1
MM2_f41 Vgp Vgn Vr VSS nfet_03v3 L=6u W=1u nf=1
MM2_f42 Vgp Vgn Vr VSS nfet_03v3 L=6u W=1u nf=1
MM2_f43 Vgp Vgn Vr VSS nfet_03v3 L=6u W=1u nf=1
MM2_f44 Vgp Vgn Vr VSS nfet_03v3 L=6u W=1u nf=1
MM2_f45 Vgp Vgn Vr VSS nfet_03v3 L=6u W=1u nf=1
MM2_f46 Vgp Vgn Vr VSS nfet_03v3 L=6u W=1u nf=1
MM2_f47 Vgp Vgn Vr VSS nfet_03v3 L=6u W=1u nf=1
MM2_f48 Vgp Vgn Vr VSS nfet_03v3 L=6u W=1u nf=1
MM2_f49 Vgp Vgn Vr VSS nfet_03v3 L=6u W=1u nf=1
MM2_f50 Vgp Vgn Vr VSS nfet_03v3 L=6u W=1u nf=1
MM2_f51 Vgp Vgn Vr VSS nfet_03v3 L=6u W=1u nf=1
MM2_f52 Vgp Vgn Vr VSS nfet_03v3 L=6u W=1u nf=1
MM2_f53 Vgp Vgn Vr VSS nfet_03v3 L=6u W=1u nf=1
MM2_f54 Vgp Vgn Vr VSS nfet_03v3 L=6u W=1u nf=1
MM2_f55 Vgp Vgn Vr VSS nfet_03v3 L=6u W=1u nf=1
MM2_f56 Vgp Vgn Vr VSS nfet_03v3 L=6u W=1u nf=1
MM2_f57 Vgp Vgn Vr VSS nfet_03v3 L=6u W=1u nf=1
MM2_f58 Vgp Vgn Vr VSS nfet_03v3 L=6u W=1u nf=1
MM2_f59 Vgp Vgn Vr VSS nfet_03v3 L=6u W=1u nf=1
MM2_f60 Vgp Vgn Vr VSS nfet_03v3 L=6u W=1u nf=1
MM2_f61 Vgp Vgn Vr VSS nfet_03v3 L=6u W=1u nf=1
MM2_f62 Vgp Vgn Vr VSS nfet_03v3 L=6u W=1u nf=1
MM2_f63 Vgp Vgn Vr VSS nfet_03v3 L=6u W=1u nf=1
MMS3 Vgp X VSS VSS nfet_03v3 L=4u W=0.5u nf=1
MM3_f0 Vgp Vgp VDD VDD pfet_03v3 L=6u W=1u nf=1
MM3_f1 Vgp Vgp VDD VDD pfet_03v3 L=6u W=1u nf=1
MM3_f2 Vgp Vgp VDD VDD pfet_03v3 L=6u W=1u nf=1
MM3_f3 Vgp Vgp VDD VDD pfet_03v3 L=6u W=1u nf=1
MM4_f0 Vgn Vgp VDD VDD pfet_03v3 L=6u W=1u nf=1
MM4_f1 Vgn Vgp VDD VDD pfet_03v3 L=6u W=1u nf=1
MM4_f2 Vgn Vgp VDD VDD pfet_03v3 L=6u W=1u nf=1
MM4_f3 Vgn Vgp VDD VDD pfet_03v3 L=6u W=1u nf=1
MMS1_0 net1 VSS VDD VDD pfet_03v3 L=45.45u W=0.5u nf=1
MMS1_1 net2 VSS net1 VDD pfet_03v3 L=45.45u W=0.5u nf=1
MMS1_2 net3 VSS net2 VDD pfet_03v3 L=45.45u W=0.5u nf=1
MMS1_3 s4 VSS net3 VDD pfet_03v3 L=45.45u W=0.5u nf=1
MMS1_4 net4 VSS s4 VDD pfet_03v3 L=45.45u W=0.5u nf=1
MMS1_5 net5 VSS net4 VDD pfet_03v3 L=45.45u W=0.5u nf=1
MMS1_6 net6 VSS net5 VDD pfet_03v3 L=45.45u W=0.5u nf=1
MMS1_7 net7 VSS net6 VDD pfet_03v3 L=45.45u W=0.5u nf=1
MMS1_8 net8 VSS net7 VDD pfet_03v3 L=45.45u W=0.5u nf=1
MMS1_9 X VSS net8 VDD pfet_03v3 L=45.45u W=0.5u nf=1
R_s0 VSS R_j0 VSS nwell W=2e-6 L=48.79e-6
R_s1 R_j0 R_j1 VSS nwell W=2e-6 L=48.79e-6
R_s2 R_j1 R_j2 VSS nwell W=2e-6 L=48.78e-6
R_s3 R_j2 R_j3 VSS nwell W=2e-6 L=48.78e-6
R_s4 R_j3 R_j4 VSS nwell W=2e-6 L=48.78e-6
R_s5 R_j4 R_j5 VSS nwell W=2e-6 L=48.78e-6
R_s6 R_j5 R_j6 VSS nwell W=2e-6 L=48.78e-6
R_s7 R_j6 R_j7 VSS nwell W=2e-6 L=48.78e-6
R_s8 R_j7 R_j8 VSS nwell W=2e-6 L=48.78e-6
R_s9 R_j8 R_j9 VSS nwell W=2e-6 L=48.78e-6
R_s10 R_j9 R_j10 VSS nwell W=2e-6 L=48.78e-6
R_s11 R_j10 Vr VSS nwell W=2e-6 L=48.78e-6
MDNN0 VSS VSS VSS VSS nfet_03v3 L=2u W=0.5u nf=1
MDNN1 VSS VSS VSS VSS nfet_03v3 L=2u W=0.5u nf=1
MDNN2 VSS VSS VSS VSS nfet_03v3 L=2u W=0.5u nf=1
MDNN3 VSS VSS VSS VSS nfet_03v3 L=2u W=0.5u nf=1
MDNN4 VSS VSS VSS VSS nfet_03v3 L=2u W=0.5u nf=1
MDNN5 VSS VSS VSS VSS nfet_03v3 L=2u W=0.5u nf=1
MDNN6 VSS VSS VSS VSS nfet_03v3 L=2u W=0.5u nf=1
MDNN7 VSS VSS VSS VSS nfet_03v3 L=2u W=0.5u nf=1
MDNN8 VSS VSS VSS VSS nfet_03v3 L=2u W=0.5u nf=1
MDNN9 VSS VSS VSS VSS nfet_03v3 L=2u W=0.5u nf=1
MDNN10 VSS VSS VSS VSS nfet_03v3 L=2u W=0.5u nf=1
MDNN11 VSS VSS VSS VSS nfet_03v3 L=2u W=0.5u nf=1
MDNN12 VSS VSS VSS VSS nfet_03v3 L=2u W=0.5u nf=1
MDNN13 VSS VSS VSS VSS nfet_03v3 L=2u W=0.5u nf=1
MDNN14 VSS VSS VSS VSS nfet_03v3 L=2u W=0.5u nf=1
MDNN15 VSS VSS VSS VSS nfet_03v3 L=2u W=0.5u nf=1
MDNN16 VSS VSS VSS VSS nfet_03v3 L=2u W=0.5u nf=1
MDNN17 VSS VSS VSS VSS nfet_03v3 L=2u W=0.5u nf=1
MDNN18 VSS VSS VSS VSS nfet_03v3 L=2u W=0.5u nf=1
MDNN19 VSS VSS VSS VSS nfet_03v3 L=2u W=0.5u nf=1
MDNN20 VSS VSS VSS VSS nfet_03v3 L=2u W=0.5u nf=1
MDNN21 VSS VSS VSS VSS nfet_03v3 L=2u W=0.5u nf=1
MDNN22 VSS VSS VSS VSS nfet_03v3 L=2u W=0.5u nf=1
MDNN23 VSS VSS VSS VSS nfet_03v3 L=2u W=0.5u nf=1
MDNN24 VSS VSS VSS VSS nfet_03v3 L=2u W=0.5u nf=1
MDNN25 VSS VSS VSS VSS nfet_03v3 L=2u W=0.5u nf=1
MDNN26 VSS VSS VSS VSS nfet_03v3 L=2u W=0.5u nf=1
MDNN27 VSS VSS VSS VSS nfet_03v3 L=2u W=0.5u nf=1
MDNN28 VSS VSS VSS VSS nfet_03v3 L=2u W=0.5u nf=1
MDNN29 VSS VSS VSS VSS nfet_03v3 L=2u W=0.5u nf=1
MDNN30 VSS VSS VSS VSS nfet_03v3 L=2u W=0.5u nf=1
MDNN31 VSS VSS VSS VSS nfet_03v3 L=2u W=0.5u nf=1
MDNN32 VSS VSS VSS VSS nfet_03v3 L=2u W=0.5u nf=1
MDNN33 VSS VSS VSS VSS nfet_03v3 L=2u W=0.5u nf=1
MDNN34 VSS VSS VSS VSS nfet_03v3 L=2u W=0.5u nf=1
MDNN35 VSS VSS VSS VSS nfet_03v3 L=2u W=0.5u nf=1
MDNN36 VSS VSS VSS VSS nfet_03v3 L=2u W=0.5u nf=1
MDNN37 VSS VSS VSS VSS nfet_03v3 L=2u W=0.5u nf=1
MDNN38 VSS VSS VSS VSS nfet_03v3 L=2u W=0.5u nf=1
MDNN39 VSS VSS VSS VSS nfet_03v3 L=2u W=0.5u nf=1
MDNN40 VSS VSS VSS VSS nfet_03v3 L=2u W=0.5u nf=1
MDNN41 VSS VSS VSS VSS nfet_03v3 L=2u W=0.5u nf=1
MDNN42 VSS VSS VSS VSS nfet_03v3 L=2u W=0.5u nf=1
MDNN43 VSS VSS VSS VSS nfet_03v3 L=2u W=0.5u nf=1
MDNN44 VSS VSS VSS VSS nfet_03v3 L=2u W=0.5u nf=1
MDNN45 VSS VSS VSS VSS nfet_03v3 L=2u W=0.5u nf=1
MDNN46 VSS VSS VSS VSS nfet_03v3 L=2u W=0.5u nf=1
MDNN47 VSS VSS VSS VSS nfet_03v3 L=2u W=0.5u nf=1
MDNN48 VSS VSS VSS VSS nfet_03v3 L=2u W=0.5u nf=1
MDNN49 VSS VSS VSS VSS nfet_03v3 L=2u W=0.5u nf=1
MDNN50 VSS VSS VSS VSS nfet_03v3 L=2u W=0.5u nf=1
MDNN51 VSS VSS VSS VSS nfet_03v3 L=2u W=0.5u nf=1
MDNN52 VSS VSS VSS VSS nfet_03v3 L=2u W=0.5u nf=1
MDNN53 VSS VSS VSS VSS nfet_03v3 L=2u W=0.5u nf=1
MDNN54 VSS VSS VSS VSS nfet_03v3 L=2u W=0.5u nf=1
MDNN55 VSS VSS VSS VSS nfet_03v3 L=2u W=0.5u nf=1
MDNN56 VSS VSS VSS VSS nfet_03v3 L=2u W=0.5u nf=1
MDNN57 VSS VSS VSS VSS nfet_03v3 L=2u W=0.5u nf=1
MDNN58 VSS VSS VSS VSS nfet_03v3 L=2u W=0.5u nf=1
MDNN59 VSS VSS VSS VSS nfet_03v3 L=2u W=0.5u nf=1
MDNN60 VSS VSS VSS VSS nfet_03v3 L=2u W=0.5u nf=1
MDNN61 VSS VSS VSS VSS nfet_03v3 L=2u W=0.5u nf=1
MDNN62 VSS VSS VSS VSS nfet_03v3 L=2u W=0.5u nf=1
MDNN63 VSS VSS VSS VSS nfet_03v3 L=2u W=0.5u nf=1
MDNN64 VSS VSS VSS VSS nfet_03v3 L=2u W=0.5u nf=1
MDNN65 VSS VSS VSS VSS nfet_03v3 L=2u W=0.5u nf=1
MDNN66 VSS VSS VSS VSS nfet_03v3 L=2u W=0.5u nf=1
MDNN67 VSS VSS VSS VSS nfet_03v3 L=2u W=0.5u nf=1
MDNN68 VSS VSS VSS VSS nfet_03v3 L=2u W=0.5u nf=1
MDNN69 VSS VSS VSS VSS nfet_03v3 L=2u W=0.5u nf=1
MDNN70 VSS VSS VSS VSS nfet_03v3 L=2u W=0.5u nf=1
MDNN71 VSS VSS VSS VSS nfet_03v3 L=2u W=0.5u nf=1
MDNN72 VSS VSS VSS VSS nfet_03v3 L=2u W=0.5u nf=1
MDNN73 VSS VSS VSS VSS nfet_03v3 L=2u W=0.5u nf=1
MDNN74 VSS VSS VSS VSS nfet_03v3 L=2u W=0.5u nf=1
MDNN75 VSS VSS VSS VSS nfet_03v3 L=2u W=0.5u nf=1
MDNN76 VSS VSS VSS VSS nfet_03v3 L=2u W=0.5u nf=1
MDNN77 VSS VSS VSS VSS nfet_03v3 L=2u W=0.5u nf=1
MDNN78 VSS VSS VSS VSS nfet_03v3 L=2u W=0.5u nf=1
MDNN79 VSS VSS VSS VSS nfet_03v3 L=2u W=0.5u nf=1
MDNN80 VSS VSS VSS VSS nfet_03v3 L=2u W=0.5u nf=1
MDNN81 VSS VSS VSS VSS nfet_03v3 L=2u W=0.5u nf=1
MDNN82 VSS VSS VSS VSS nfet_03v3 L=2u W=0.5u nf=1
MDNN83 VSS VSS VSS VSS nfet_03v3 L=2u W=0.5u nf=1
MDNN84 VSS VSS VSS VSS nfet_03v3 L=2u W=0.5u nf=1
MDNN85 VSS VSS VSS VSS nfet_03v3 L=2u W=0.5u nf=1
MDNN86 VSS VSS VSS VSS nfet_03v3 L=2u W=0.5u nf=1
MDNN87 VSS VSS VSS VSS nfet_03v3 L=2u W=0.5u nf=1
MDNN88 VSS VSS VSS VSS nfet_03v3 L=2u W=0.5u nf=1
MDNN89 VSS VSS VSS VSS nfet_03v3 L=2u W=0.5u nf=1
MDNN90 VSS VSS VSS VSS nfet_03v3 L=2u W=0.5u nf=1
MDNN91 VSS VSS VSS VSS nfet_03v3 L=2u W=0.5u nf=1
MDNN92 VSS VSS VSS VSS nfet_03v3 L=2u W=0.5u nf=1
MDNN93 VSS VSS VSS VSS nfet_03v3 L=2u W=0.5u nf=1
MDNN94 VSS VSS VSS VSS nfet_03v3 L=2u W=0.5u nf=1
MDNN95 VSS VSS VSS VSS nfet_03v3 L=2u W=0.5u nf=1
MDNN96 VSS VSS VSS VSS nfet_03v3 L=2u W=0.5u nf=1
MDNN97 VSS VSS VSS VSS nfet_03v3 L=2u W=0.5u nf=1
MDNN98 VSS VSS VSS VSS nfet_03v3 L=2u W=0.5u nf=1
MDNN99 VSS VSS VSS VSS nfet_03v3 L=2u W=0.5u nf=1
MDNN100 VSS VSS VSS VSS nfet_03v3 L=2u W=0.5u nf=1
MDNN101 VSS VSS VSS VSS nfet_03v3 L=2u W=0.5u nf=1
MDNN102 VSS VSS VSS VSS nfet_03v3 L=2u W=0.5u nf=1
MDNN103 VSS VSS VSS VSS nfet_03v3 L=2u W=0.5u nf=1
MDNN104 VSS VSS VSS VSS nfet_03v3 L=2u W=0.5u nf=1
MDNN105 VSS VSS VSS VSS nfet_03v3 L=2u W=0.5u nf=1
MDNN106 VSS VSS VSS VSS nfet_03v3 L=2u W=0.5u nf=1
MDNN107 VSS VSS VSS VSS nfet_03v3 L=2u W=0.5u nf=1
MDNN108 VSS VSS VSS VSS nfet_03v3 L=2u W=0.5u nf=1
MDNN109 VSS VSS VSS VSS nfet_03v3 L=2u W=0.5u nf=1
MDNN110 VSS VSS VSS VSS nfet_03v3 L=2u W=0.5u nf=1
MDNN111 VSS VSS VSS VSS nfet_03v3 L=2u W=0.5u nf=1
MDNN112 VSS VSS VSS VSS nfet_03v3 L=2u W=0.5u nf=1
MDNN113 VSS VSS VSS VSS nfet_03v3 L=2u W=0.5u nf=1
MDNN114 VSS VSS VSS VSS nfet_03v3 L=2u W=0.5u nf=1
MDNN115 VSS VSS VSS VSS nfet_03v3 L=2u W=0.5u nf=1
MDNN116 VSS VSS VSS VSS nfet_03v3 L=2u W=0.5u nf=1
MDNN117 VSS VSS VSS VSS nfet_03v3 L=2u W=0.5u nf=1
MDNN118 VSS VSS VSS VSS nfet_03v3 L=2u W=0.5u nf=1
MDNN119 VSS VSS VSS VSS nfet_03v3 L=2u W=0.5u nf=1
MDNN120 VSS VSS VSS VSS nfet_03v3 L=2u W=0.5u nf=1
MDNN121 VSS VSS VSS VSS nfet_03v3 L=2u W=0.5u nf=1
MDNN122 VSS VSS VSS VSS nfet_03v3 L=2u W=0.5u nf=1
MDNN123 VSS VSS VSS VSS nfet_03v3 L=2u W=0.5u nf=1
MDNN124 VSS VSS VSS VSS nfet_03v3 L=2u W=0.5u nf=1
MDNN125 VSS VSS VSS VSS nfet_03v3 L=2u W=0.5u nf=1
MDNN126 VSS VSS VSS VSS nfet_03v3 L=2u W=0.5u nf=1
MDNN127 VSS VSS VSS VSS nfet_03v3 L=2u W=0.5u nf=1
MDNN128 VSS VSS VSS VSS nfet_03v3 L=2u W=0.5u nf=1
MDNN129 VSS VSS VSS VSS nfet_03v3 L=2u W=0.5u nf=1
MDNN130 VSS VSS VSS VSS nfet_03v3 L=2u W=0.5u nf=1
MDNN131 VSS VSS VSS VSS nfet_03v3 L=2u W=0.5u nf=1
MDNN132 VSS VSS VSS VSS nfet_03v3 L=2u W=0.5u nf=1
MDNN133 VSS VSS VSS VSS nfet_03v3 L=2u W=0.5u nf=1
MDNN134 VSS VSS VSS VSS nfet_03v3 L=2u W=0.5u nf=1
MDNN135 VSS VSS VSS VSS nfet_03v3 L=2u W=0.5u nf=1
MDNN136 VSS VSS VSS VSS nfet_03v3 L=2u W=0.5u nf=1
MDNN137 VSS VSS VSS VSS nfet_03v3 L=2u W=0.5u nf=1
MDNN138 VSS VSS VSS VSS nfet_03v3 L=2u W=0.5u nf=1
MDNN139 VSS VSS VSS VSS nfet_03v3 L=2u W=0.5u nf=1
MDNN140 VSS VSS VSS VSS nfet_03v3 L=2u W=0.5u nf=1
MDNN141 VSS VSS VSS VSS nfet_03v3 L=2u W=0.5u nf=1
MDNN142 VSS VSS VSS VSS nfet_03v3 L=2u W=0.5u nf=1
MDNN143 VSS VSS VSS VSS nfet_03v3 L=2u W=0.5u nf=1
MDNN144 VSS VSS VSS VSS nfet_03v3 L=2u W=0.5u nf=1
MDNN145 VSS VSS VSS VSS nfet_03v3 L=2u W=0.5u nf=1
MDNN146 VSS VSS VSS VSS nfet_03v3 L=2u W=0.5u nf=1
MDNN147 VSS VSS VSS VSS nfet_03v3 L=2u W=0.5u nf=1
MDNN148 VSS VSS VSS VSS nfet_03v3 L=2u W=0.5u nf=1
MDNN149 VSS VSS VSS VSS nfet_03v3 L=2u W=0.5u nf=1
MDNN150 VSS VSS VSS VSS nfet_03v3 L=2u W=0.5u nf=1
MDNN151 VSS VSS VSS VSS nfet_03v3 L=2u W=0.5u nf=1
MDNN152 VSS VSS VSS VSS nfet_03v3 L=2u W=0.5u nf=1
MDNN153 VSS VSS VSS VSS nfet_03v3 L=2u W=0.5u nf=1
MDNN154 VSS VSS VSS VSS nfet_03v3 L=2u W=0.5u nf=1
MDNN155 VSS VSS VSS VSS nfet_03v3 L=2u W=0.5u nf=1
MDNN156 VSS VSS VSS VSS nfet_03v3 L=2u W=0.5u nf=1
MDNN157 VSS VSS VSS VSS nfet_03v3 L=2u W=0.5u nf=1
MDNN158 VSS VSS VSS VSS nfet_03v3 L=2u W=0.5u nf=1
MDNN159 VSS VSS VSS VSS nfet_03v3 L=2u W=0.5u nf=1
MDNN160 VSS VSS VSS VSS nfet_03v3 L=2u W=0.5u nf=1
MDNN161 VSS VSS VSS VSS nfet_03v3 L=2u W=0.5u nf=1
MDNN162 VSS VSS VSS VSS nfet_03v3 L=2u W=0.5u nf=1
MDNN163 VSS VSS VSS VSS nfet_03v3 L=2u W=0.5u nf=1
MDNN164 VSS VSS VSS VSS nfet_03v3 L=2u W=0.5u nf=1
MDNN165 VSS VSS VSS VSS nfet_03v3 L=2u W=0.5u nf=1
MDNN166 VSS VSS VSS VSS nfet_03v3 L=2u W=0.5u nf=1
MDNN167 VSS VSS VSS VSS nfet_03v3 L=2u W=0.5u nf=1
MDNN168 VSS VSS VSS VSS nfet_03v3 L=2u W=0.5u nf=1
MDNN169 VSS VSS VSS VSS nfet_03v3 L=2u W=0.5u nf=1
MDNN170 VSS VSS VSS VSS nfet_03v3 L=2u W=0.5u nf=1
MDNN171 VSS VSS VSS VSS nfet_03v3 L=2u W=0.5u nf=1
MDNN172 VSS VSS VSS VSS nfet_03v3 L=2u W=0.5u nf=1
MDNN173 VSS VSS VSS VSS nfet_03v3 L=2u W=0.5u nf=1
MDNN174 VSS VSS VSS VSS nfet_03v3 L=2u W=0.5u nf=1
MDNN175 VSS VSS VSS VSS nfet_03v3 L=2u W=0.5u nf=1
MDNN176 VSS VSS VSS VSS nfet_03v3 L=2u W=0.5u nf=1
MDNN177 VSS VSS VSS VSS nfet_03v3 L=2u W=0.5u nf=1
MDNN178 VSS VSS VSS VSS nfet_03v3 L=2u W=0.5u nf=1
MDNN179 VSS VSS VSS VSS nfet_03v3 L=2u W=0.5u nf=1
MDNN180 VSS VSS VSS VSS nfet_03v3 L=2u W=0.5u nf=1
MDNN181 VSS VSS VSS VSS nfet_03v3 L=2u W=0.5u nf=1
MDNN182 VSS VSS VSS VSS nfet_03v3 L=2u W=0.5u nf=1
MDNN183 VSS VSS VSS VSS nfet_03v3 L=2u W=0.5u nf=1
MDNN184 VSS VSS VSS VSS nfet_03v3 L=2u W=0.5u nf=1
MDNN185 VSS VSS VSS VSS nfet_03v3 L=2u W=0.5u nf=1
MDNN186 VSS VSS VSS VSS nfet_03v3 L=2u W=0.5u nf=1
MDNN187 VSS VSS VSS VSS nfet_03v3 L=2u W=0.5u nf=1
MDNN188 VSS VSS VSS VSS nfet_03v3 L=2u W=0.5u nf=1
MDNN189 VSS VSS VSS VSS nfet_03v3 L=2u W=0.5u nf=1
MDNN190 VSS VSS VSS VSS nfet_03v3 L=2u W=0.5u nf=1
MDNN191 VSS VSS VSS VSS nfet_03v3 L=2u W=0.5u nf=1
MDNN192 VSS VSS VSS VSS nfet_03v3 L=2u W=0.5u nf=1
MDNN193 VSS VSS VSS VSS nfet_03v3 L=2u W=0.5u nf=1
MDNN194 VSS VSS VSS VSS nfet_03v3 L=2u W=0.5u nf=1
MDNN195 VSS VSS VSS VSS nfet_03v3 L=2u W=0.5u nf=1
MDNN196 VSS VSS VSS VSS nfet_03v3 L=2u W=0.5u nf=1
MDNN197 VSS VSS VSS VSS nfet_03v3 L=2u W=0.5u nf=1
MDNN198 VSS VSS VSS VSS nfet_03v3 L=2u W=0.5u nf=1
MDNN199 VSS VSS VSS VSS nfet_03v3 L=2u W=0.5u nf=1
MDNN200 VSS VSS VSS VSS nfet_03v3 L=2u W=0.5u nf=1
MDNN201 VSS VSS VSS VSS nfet_03v3 L=2u W=0.5u nf=1
MDNN202 VSS VSS VSS VSS nfet_03v3 L=2u W=0.5u nf=1
MDNN203 VSS VSS VSS VSS nfet_03v3 L=2u W=0.5u nf=1
MDNN204 VSS VSS VSS VSS nfet_03v3 L=2u W=0.5u nf=1
MDNN205 VSS VSS VSS VSS nfet_03v3 L=2u W=0.5u nf=1
MDNN206 VSS VSS VSS VSS nfet_03v3 L=2u W=0.5u nf=1
MDNN207 VSS VSS VSS VSS nfet_03v3 L=2u W=0.5u nf=1
MDNN208 VSS VSS VSS VSS nfet_03v3 L=2u W=0.5u nf=1
MDNN209 VSS VSS VSS VSS nfet_03v3 L=2u W=0.5u nf=1
MDNN210 VSS VSS VSS VSS nfet_03v3 L=2u W=0.5u nf=1
MDNN211 VSS VSS VSS VSS nfet_03v3 L=2u W=0.5u nf=1
MDNN212 VSS VSS VSS VSS nfet_03v3 L=2u W=0.5u nf=1
MDNN213 VSS VSS VSS VSS nfet_03v3 L=2u W=0.5u nf=1
MDNN214 VSS VSS VSS VSS nfet_03v3 L=2u W=0.5u nf=1
MDNN215 VSS VSS VSS VSS nfet_03v3 L=2u W=0.5u nf=1
MDNN216 VSS VSS VSS VSS nfet_03v3 L=2u W=0.5u nf=1
MDNN217 VSS VSS VSS VSS nfet_03v3 L=2u W=0.5u nf=1
MDNN218 VSS VSS VSS VSS nfet_03v3 L=2u W=0.5u nf=1
MDNN219 VSS VSS VSS VSS nfet_03v3 L=2u W=0.5u nf=1
MDNN220 VSS VSS VSS VSS nfet_03v3 L=2u W=0.5u nf=1
MDNN221 VSS VSS VSS VSS nfet_03v3 L=2u W=0.5u nf=1
MDNN222 VSS VSS VSS VSS nfet_03v3 L=2u W=0.5u nf=1
MDNN223 VSS VSS VSS VSS nfet_03v3 L=2u W=0.5u nf=1
MDNN224 VSS VSS VSS VSS nfet_03v3 L=2u W=0.5u nf=1
MDNN225 VSS VSS VSS VSS nfet_03v3 L=2u W=0.5u nf=1
MDNN226 VSS VSS VSS VSS nfet_03v3 L=2u W=0.5u nf=1
MDNN227 VSS VSS VSS VSS nfet_03v3 L=2u W=0.5u nf=1
MDNN228 VSS VSS VSS VSS nfet_03v3 L=2u W=0.5u nf=1
MDNN229 VSS VSS VSS VSS nfet_03v3 L=2u W=0.5u nf=1
MDNN230 VSS VSS VSS VSS nfet_03v3 L=2u W=0.5u nf=1
MDNN231 VSS VSS VSS VSS nfet_03v3 L=2u W=0.5u nf=1
MDNN232 VSS VSS VSS VSS nfet_03v3 L=2u W=0.5u nf=1
MDNN233 VSS VSS VSS VSS nfet_03v3 L=2u W=0.5u nf=1
MDNN234 VSS VSS VSS VSS nfet_03v3 L=2u W=0.5u nf=1
MDNN235 VSS VSS VSS VSS nfet_03v3 L=2u W=0.5u nf=1
MDNN236 VSS VSS VSS VSS nfet_03v3 L=2u W=0.5u nf=1
MDNN237 VSS VSS VSS VSS nfet_03v3 L=2u W=0.5u nf=1
MDNN238 VSS VSS VSS VSS nfet_03v3 L=2u W=0.5u nf=1
MDNN239 VSS VSS VSS VSS nfet_03v3 L=2u W=0.5u nf=1
MDNN240 VSS VSS VSS VSS nfet_03v3 L=2u W=0.5u nf=1
MDNN241 VSS VSS VSS VSS nfet_03v3 L=2u W=0.5u nf=1
MDNN242 VSS VSS VSS VSS nfet_03v3 L=2u W=0.5u nf=1
MDNN243 VSS VSS VSS VSS nfet_03v3 L=2u W=0.5u nf=1
MDNN244 VSS VSS VSS VSS nfet_03v3 L=2u W=0.5u nf=1
MDNN245 VSS VSS VSS VSS nfet_03v3 L=2u W=0.5u nf=1
MDNN246 VSS VSS VSS VSS nfet_03v3 L=2u W=0.5u nf=1
MDNN247 VSS VSS VSS VSS nfet_03v3 L=2u W=0.5u nf=1
MDNN248 VSS VSS VSS VSS nfet_03v3 L=2u W=0.5u nf=1
MDNN249 VSS VSS VSS VSS nfet_03v3 L=2u W=0.5u nf=1
MDNN250 VSS VSS VSS VSS nfet_03v3 L=2u W=0.5u nf=1
MDNN251 VSS VSS VSS VSS nfet_03v3 L=2u W=0.5u nf=1
MDNN252 VSS VSS VSS VSS nfet_03v3 L=2u W=0.5u nf=1
MDNN253 VSS VSS VSS VSS nfet_03v3 L=2u W=0.5u nf=1
MDNN254 VSS VSS VSS VSS nfet_03v3 L=2u W=0.5u nf=1
MDNN255 VSS VSS VSS VSS nfet_03v3 L=2u W=0.5u nf=1
MDNN256 VSS VSS VSS VSS nfet_03v3 L=2u W=0.5u nf=1
MDNN257 VSS VSS VSS VSS nfet_03v3 L=2u W=0.5u nf=1
MDNN258 VSS VSS VSS VSS nfet_03v3 L=2u W=0.5u nf=1
MDNN259 VSS VSS VSS VSS nfet_03v3 L=2u W=0.5u nf=1
MDNN260 VSS VSS VSS VSS nfet_03v3 L=2u W=0.5u nf=1
MDNN261 VSS VSS VSS VSS nfet_03v3 L=2u W=0.5u nf=1
MDNS0 VSS VSS VSS VSS nfet_03v3 L=2u W=0.5u nf=1
MDNS1 VSS VSS VSS VSS nfet_03v3 L=2u W=0.5u nf=1
MDNS2 VSS VSS VSS VSS nfet_03v3 L=2u W=0.5u nf=1
MDNS3 VSS VSS VSS VSS nfet_03v3 L=2u W=0.5u nf=1
MDNS4 VSS VSS VSS VSS nfet_03v3 L=2u W=0.5u nf=1
MDNS5 VSS VSS VSS VSS nfet_03v3 L=2u W=0.5u nf=1
MDNS6 VSS VSS VSS VSS nfet_03v3 L=2u W=0.5u nf=1
MDNS7 VSS VSS VSS VSS nfet_03v3 L=2u W=0.5u nf=1
MDNS8 VSS VSS VSS VSS nfet_03v3 L=2u W=0.5u nf=1
MDNS9 VSS VSS VSS VSS nfet_03v3 L=2u W=0.5u nf=1
MDNS10 VSS VSS VSS VSS nfet_03v3 L=2u W=0.5u nf=1
MDNS11 VSS VSS VSS VSS nfet_03v3 L=2u W=0.5u nf=1
MDNS12 VSS VSS VSS VSS nfet_03v3 L=2u W=0.5u nf=1
MDNS13 VSS VSS VSS VSS nfet_03v3 L=2u W=0.5u nf=1
MDNS14 VSS VSS VSS VSS nfet_03v3 L=2u W=0.5u nf=1
MDNS15 VSS VSS VSS VSS nfet_03v3 L=2u W=0.5u nf=1
MDNS16 VSS VSS VSS VSS nfet_03v3 L=2u W=0.5u nf=1
MDNS17 VSS VSS VSS VSS nfet_03v3 L=2u W=0.5u nf=1
MDNS18 VSS VSS VSS VSS nfet_03v3 L=2u W=0.5u nf=1
MDNS19 VSS VSS VSS VSS nfet_03v3 L=2u W=0.5u nf=1
MDNS20 VSS VSS VSS VSS nfet_03v3 L=2u W=0.5u nf=1
MDNS21 VSS VSS VSS VSS nfet_03v3 L=2u W=0.5u nf=1
MDNS22 VSS VSS VSS VSS nfet_03v3 L=2u W=0.5u nf=1
MDNS23 VSS VSS VSS VSS nfet_03v3 L=2u W=0.5u nf=1
MDNS24 VSS VSS VSS VSS nfet_03v3 L=2u W=0.5u nf=1
MDNS25 VSS VSS VSS VSS nfet_03v3 L=2u W=0.5u nf=1
MDNS26 VSS VSS VSS VSS nfet_03v3 L=2u W=0.5u nf=1
MDNS27 VSS VSS VSS VSS nfet_03v3 L=2u W=0.5u nf=1
MDNS28 VSS VSS VSS VSS nfet_03v3 L=2u W=0.5u nf=1
MDNS29 VSS VSS VSS VSS nfet_03v3 L=2u W=0.5u nf=1
MDNS30 VSS VSS VSS VSS nfet_03v3 L=2u W=0.5u nf=1
MDNS31 VSS VSS VSS VSS nfet_03v3 L=2u W=0.5u nf=1
MDNS32 VSS VSS VSS VSS nfet_03v3 L=2u W=0.5u nf=1
MDNS33 VSS VSS VSS VSS nfet_03v3 L=2u W=0.5u nf=1
MDNS34 VSS VSS VSS VSS nfet_03v3 L=2u W=0.5u nf=1
MDNS35 VSS VSS VSS VSS nfet_03v3 L=2u W=0.5u nf=1
MDNS36 VSS VSS VSS VSS nfet_03v3 L=2u W=0.5u nf=1
MDNS37 VSS VSS VSS VSS nfet_03v3 L=2u W=0.5u nf=1
MDNS38 VSS VSS VSS VSS nfet_03v3 L=2u W=0.5u nf=1
MDNS39 VSS VSS VSS VSS nfet_03v3 L=2u W=0.5u nf=1
MDNS40 VSS VSS VSS VSS nfet_03v3 L=2u W=0.5u nf=1
MDNS41 VSS VSS VSS VSS nfet_03v3 L=2u W=0.5u nf=1
MDNS42 VSS VSS VSS VSS nfet_03v3 L=2u W=0.5u nf=1
MDNS43 VSS VSS VSS VSS nfet_03v3 L=2u W=0.5u nf=1
MDNS44 VSS VSS VSS VSS nfet_03v3 L=2u W=0.5u nf=1
MDNS45 VSS VSS VSS VSS nfet_03v3 L=2u W=0.5u nf=1
MDNS46 VSS VSS VSS VSS nfet_03v3 L=2u W=0.5u nf=1
MDNS47 VSS VSS VSS VSS nfet_03v3 L=2u W=0.5u nf=1
MDNS48 VSS VSS VSS VSS nfet_03v3 L=2u W=0.5u nf=1
MDNS49 VSS VSS VSS VSS nfet_03v3 L=2u W=0.5u nf=1
MDNS50 VSS VSS VSS VSS nfet_03v3 L=2u W=0.5u nf=1
MDNS51 VSS VSS VSS VSS nfet_03v3 L=2u W=0.5u nf=1
MDNS52 VSS VSS VSS VSS nfet_03v3 L=2u W=0.5u nf=1
MDNS53 VSS VSS VSS VSS nfet_03v3 L=2u W=0.5u nf=1
MDNS54 VSS VSS VSS VSS nfet_03v3 L=2u W=0.5u nf=1
MDNS55 VSS VSS VSS VSS nfet_03v3 L=2u W=0.5u nf=1
MDNS56 VSS VSS VSS VSS nfet_03v3 L=2u W=0.5u nf=1
MDNS57 VSS VSS VSS VSS nfet_03v3 L=2u W=0.5u nf=1
MDNS58 VSS VSS VSS VSS nfet_03v3 L=2u W=0.5u nf=1
MDNS59 VSS VSS VSS VSS nfet_03v3 L=2u W=0.5u nf=1
MDNS60 VSS VSS VSS VSS nfet_03v3 L=2u W=0.5u nf=1
MDNS61 VSS VSS VSS VSS nfet_03v3 L=2u W=0.5u nf=1
MDNS62 VSS VSS VSS VSS nfet_03v3 L=2u W=0.5u nf=1
MDNS63 VSS VSS VSS VSS nfet_03v3 L=2u W=0.5u nf=1
MDNS64 VSS VSS VSS VSS nfet_03v3 L=2u W=0.5u nf=1
MDNS65 VSS VSS VSS VSS nfet_03v3 L=2u W=0.5u nf=1
MDNS66 VSS VSS VSS VSS nfet_03v3 L=2u W=0.5u nf=1
MDNS67 VSS VSS VSS VSS nfet_03v3 L=2u W=0.5u nf=1
MDNS68 VSS VSS VSS VSS nfet_03v3 L=2u W=0.5u nf=1
MDNS69 VSS VSS VSS VSS nfet_03v3 L=2u W=0.5u nf=1
MDNS70 VSS VSS VSS VSS nfet_03v3 L=2u W=0.5u nf=1
MDNS71 VSS VSS VSS VSS nfet_03v3 L=2u W=0.5u nf=1
MDNS72 VSS VSS VSS VSS nfet_03v3 L=2u W=0.5u nf=1
MDNS73 VSS VSS VSS VSS nfet_03v3 L=2u W=0.5u nf=1
MDNS74 VSS VSS VSS VSS nfet_03v3 L=2u W=0.5u nf=1
MDNS75 VSS VSS VSS VSS nfet_03v3 L=2u W=0.5u nf=1
MDNS76 VSS VSS VSS VSS nfet_03v3 L=2u W=0.5u nf=1
MDNS77 VSS VSS VSS VSS nfet_03v3 L=2u W=0.5u nf=1
MDNS78 VSS VSS VSS VSS nfet_03v3 L=2u W=0.5u nf=1
MDNS79 VSS VSS VSS VSS nfet_03v3 L=2u W=0.5u nf=1
MDNS80 VSS VSS VSS VSS nfet_03v3 L=2u W=0.5u nf=1
MDNS81 VSS VSS VSS VSS nfet_03v3 L=2u W=0.5u nf=1
MDNS82 VSS VSS VSS VSS nfet_03v3 L=2u W=0.5u nf=1
MDNS83 VSS VSS VSS VSS nfet_03v3 L=2u W=0.5u nf=1
MDNS84 VSS VSS VSS VSS nfet_03v3 L=2u W=0.5u nf=1
MDNS85 VSS VSS VSS VSS nfet_03v3 L=2u W=0.5u nf=1
MDNS86 VSS VSS VSS VSS nfet_03v3 L=2u W=0.5u nf=1
MDNS87 VSS VSS VSS VSS nfet_03v3 L=2u W=0.5u nf=1
MDNS88 VSS VSS VSS VSS nfet_03v3 L=2u W=0.5u nf=1
MDNS89 VSS VSS VSS VSS nfet_03v3 L=2u W=0.5u nf=1
MDNS90 VSS VSS VSS VSS nfet_03v3 L=2u W=0.5u nf=1
MDNS91 VSS VSS VSS VSS nfet_03v3 L=2u W=0.5u nf=1
MDNS92 VSS VSS VSS VSS nfet_03v3 L=2u W=0.5u nf=1
MDNS93 VSS VSS VSS VSS nfet_03v3 L=2u W=0.5u nf=1
MDNS94 VSS VSS VSS VSS nfet_03v3 L=2u W=0.5u nf=1
MDNS95 VSS VSS VSS VSS nfet_03v3 L=2u W=0.5u nf=1
MDNS96 VSS VSS VSS VSS nfet_03v3 L=2u W=0.5u nf=1
MDNS97 VSS VSS VSS VSS nfet_03v3 L=2u W=0.5u nf=1
MDNS98 VSS VSS VSS VSS nfet_03v3 L=2u W=0.5u nf=1
MDNS99 VSS VSS VSS VSS nfet_03v3 L=2u W=0.5u nf=1
MDNS100 VSS VSS VSS VSS nfet_03v3 L=2u W=0.5u nf=1
MDNS101 VSS VSS VSS VSS nfet_03v3 L=2u W=0.5u nf=1
MDNS102 VSS VSS VSS VSS nfet_03v3 L=2u W=0.5u nf=1
MDNS103 VSS VSS VSS VSS nfet_03v3 L=2u W=0.5u nf=1
MDNS104 VSS VSS VSS VSS nfet_03v3 L=2u W=0.5u nf=1
MDNS105 VSS VSS VSS VSS nfet_03v3 L=2u W=0.5u nf=1
MDNS106 VSS VSS VSS VSS nfet_03v3 L=2u W=0.5u nf=1
MDNS107 VSS VSS VSS VSS nfet_03v3 L=2u W=0.5u nf=1
MDNS108 VSS VSS VSS VSS nfet_03v3 L=2u W=0.5u nf=1
MDNS109 VSS VSS VSS VSS nfet_03v3 L=2u W=0.5u nf=1
MDNS110 VSS VSS VSS VSS nfet_03v3 L=2u W=0.5u nf=1
MDNS111 VSS VSS VSS VSS nfet_03v3 L=2u W=0.5u nf=1
MDNS112 VSS VSS VSS VSS nfet_03v3 L=2u W=0.5u nf=1
MDNS113 VSS VSS VSS VSS nfet_03v3 L=2u W=0.5u nf=1
MDNS114 VSS VSS VSS VSS nfet_03v3 L=2u W=0.5u nf=1
MDNS115 VSS VSS VSS VSS nfet_03v3 L=2u W=0.5u nf=1
MDNS116 VSS VSS VSS VSS nfet_03v3 L=2u W=0.5u nf=1
MDNS117 VSS VSS VSS VSS nfet_03v3 L=2u W=0.5u nf=1
MDNS118 VSS VSS VSS VSS nfet_03v3 L=2u W=0.5u nf=1
MDNS119 VSS VSS VSS VSS nfet_03v3 L=2u W=0.5u nf=1
MDNS120 VSS VSS VSS VSS nfet_03v3 L=2u W=0.5u nf=1
MDNS121 VSS VSS VSS VSS nfet_03v3 L=2u W=0.5u nf=1
MDNS122 VSS VSS VSS VSS nfet_03v3 L=2u W=0.5u nf=1
MDNS123 VSS VSS VSS VSS nfet_03v3 L=2u W=0.5u nf=1
MDNS124 VSS VSS VSS VSS nfet_03v3 L=2u W=0.5u nf=1
MDNS125 VSS VSS VSS VSS nfet_03v3 L=2u W=0.5u nf=1
MDNS126 VSS VSS VSS VSS nfet_03v3 L=2u W=0.5u nf=1
MDNS127 VSS VSS VSS VSS nfet_03v3 L=2u W=0.5u nf=1
MDNS128 VSS VSS VSS VSS nfet_03v3 L=2u W=0.5u nf=1
MDNS129 VSS VSS VSS VSS nfet_03v3 L=2u W=0.5u nf=1
MDNS130 VSS VSS VSS VSS nfet_03v3 L=2u W=0.5u nf=1
MDNS131 VSS VSS VSS VSS nfet_03v3 L=2u W=0.5u nf=1
MDNS132 VSS VSS VSS VSS nfet_03v3 L=2u W=0.5u nf=1
MDNS133 VSS VSS VSS VSS nfet_03v3 L=2u W=0.5u nf=1
MDNS134 VSS VSS VSS VSS nfet_03v3 L=2u W=0.5u nf=1
MDNS135 VSS VSS VSS VSS nfet_03v3 L=2u W=0.5u nf=1
MDNS136 VSS VSS VSS VSS nfet_03v3 L=2u W=0.5u nf=1
MDNS137 VSS VSS VSS VSS nfet_03v3 L=2u W=0.5u nf=1
MDNS138 VSS VSS VSS VSS nfet_03v3 L=2u W=0.5u nf=1
MDNS139 VSS VSS VSS VSS nfet_03v3 L=2u W=0.5u nf=1
MDNS140 VSS VSS VSS VSS nfet_03v3 L=2u W=0.5u nf=1
MDNS141 VSS VSS VSS VSS nfet_03v3 L=2u W=0.5u nf=1
MDNS142 VSS VSS VSS VSS nfet_03v3 L=2u W=0.5u nf=1
MDNS143 VSS VSS VSS VSS nfet_03v3 L=2u W=0.5u nf=1
MDNS144 VSS VSS VSS VSS nfet_03v3 L=2u W=0.5u nf=1
MDNS145 VSS VSS VSS VSS nfet_03v3 L=2u W=0.5u nf=1
MDNS146 VSS VSS VSS VSS nfet_03v3 L=2u W=0.5u nf=1
MDNS147 VSS VSS VSS VSS nfet_03v3 L=2u W=0.5u nf=1
MDNS148 VSS VSS VSS VSS nfet_03v3 L=2u W=0.5u nf=1
MDNS149 VSS VSS VSS VSS nfet_03v3 L=2u W=0.5u nf=1
MDNS150 VSS VSS VSS VSS nfet_03v3 L=2u W=0.5u nf=1
MDNS151 VSS VSS VSS VSS nfet_03v3 L=2u W=0.5u nf=1
MDNS152 VSS VSS VSS VSS nfet_03v3 L=2u W=0.5u nf=1
MDNS153 VSS VSS VSS VSS nfet_03v3 L=2u W=0.5u nf=1
MDNS154 VSS VSS VSS VSS nfet_03v3 L=2u W=0.5u nf=1
MDNS155 VSS VSS VSS VSS nfet_03v3 L=2u W=0.5u nf=1
MDNS156 VSS VSS VSS VSS nfet_03v3 L=2u W=0.5u nf=1
MDNS157 VSS VSS VSS VSS nfet_03v3 L=2u W=0.5u nf=1
MDNS158 VSS VSS VSS VSS nfet_03v3 L=2u W=0.5u nf=1
MDNS159 VSS VSS VSS VSS nfet_03v3 L=2u W=0.5u nf=1
MDNS160 VSS VSS VSS VSS nfet_03v3 L=2u W=0.5u nf=1
MDNS161 VSS VSS VSS VSS nfet_03v3 L=2u W=0.5u nf=1
MDNS162 VSS VSS VSS VSS nfet_03v3 L=2u W=0.5u nf=1
MDNS163 VSS VSS VSS VSS nfet_03v3 L=2u W=0.5u nf=1
MDNS164 VSS VSS VSS VSS nfet_03v3 L=2u W=0.5u nf=1
MDNS165 VSS VSS VSS VSS nfet_03v3 L=2u W=0.5u nf=1
MDNS166 VSS VSS VSS VSS nfet_03v3 L=2u W=0.5u nf=1
MDNS167 VSS VSS VSS VSS nfet_03v3 L=2u W=0.5u nf=1
MDNS168 VSS VSS VSS VSS nfet_03v3 L=2u W=0.5u nf=1
MDNS169 VSS VSS VSS VSS nfet_03v3 L=2u W=0.5u nf=1
MDNS170 VSS VSS VSS VSS nfet_03v3 L=2u W=0.5u nf=1
MDNS171 VSS VSS VSS VSS nfet_03v3 L=2u W=0.5u nf=1
MDNS172 VSS VSS VSS VSS nfet_03v3 L=2u W=0.5u nf=1
MDNS173 VSS VSS VSS VSS nfet_03v3 L=2u W=0.5u nf=1
MDNS174 VSS VSS VSS VSS nfet_03v3 L=2u W=0.5u nf=1
MDNS175 VSS VSS VSS VSS nfet_03v3 L=2u W=0.5u nf=1
MDNS176 VSS VSS VSS VSS nfet_03v3 L=2u W=0.5u nf=1
MDNS177 VSS VSS VSS VSS nfet_03v3 L=2u W=0.5u nf=1
MDNS178 VSS VSS VSS VSS nfet_03v3 L=2u W=0.5u nf=1
MDNS179 VSS VSS VSS VSS nfet_03v3 L=2u W=0.5u nf=1
MDNS180 VSS VSS VSS VSS nfet_03v3 L=2u W=0.5u nf=1
MDNS181 VSS VSS VSS VSS nfet_03v3 L=2u W=0.5u nf=1
MDNS182 VSS VSS VSS VSS nfet_03v3 L=2u W=0.5u nf=1
MDNS183 VSS VSS VSS VSS nfet_03v3 L=2u W=0.5u nf=1
MDNS184 VSS VSS VSS VSS nfet_03v3 L=2u W=0.5u nf=1
MDNS185 VSS VSS VSS VSS nfet_03v3 L=2u W=0.5u nf=1
MDNS186 VSS VSS VSS VSS nfet_03v3 L=2u W=0.5u nf=1
MDNS187 VSS VSS VSS VSS nfet_03v3 L=2u W=0.5u nf=1
MDNS188 VSS VSS VSS VSS nfet_03v3 L=2u W=0.5u nf=1
MDNS189 VSS VSS VSS VSS nfet_03v3 L=2u W=0.5u nf=1
MDNS190 VSS VSS VSS VSS nfet_03v3 L=2u W=0.5u nf=1
MDNS191 VSS VSS VSS VSS nfet_03v3 L=2u W=0.5u nf=1
MDNS192 VSS VSS VSS VSS nfet_03v3 L=2u W=0.5u nf=1
MDNS193 VSS VSS VSS VSS nfet_03v3 L=2u W=0.5u nf=1
MDNS194 VSS VSS VSS VSS nfet_03v3 L=2u W=0.5u nf=1
MDNS195 VSS VSS VSS VSS nfet_03v3 L=2u W=0.5u nf=1
MDNS196 VSS VSS VSS VSS nfet_03v3 L=2u W=0.5u nf=1
MDNS197 VSS VSS VSS VSS nfet_03v3 L=2u W=0.5u nf=1
MDNS198 VSS VSS VSS VSS nfet_03v3 L=2u W=0.5u nf=1
MDNS199 VSS VSS VSS VSS nfet_03v3 L=2u W=0.5u nf=1
MDNS200 VSS VSS VSS VSS nfet_03v3 L=2u W=0.5u nf=1
MDNS201 VSS VSS VSS VSS nfet_03v3 L=2u W=0.5u nf=1
MDNS202 VSS VSS VSS VSS nfet_03v3 L=2u W=0.5u nf=1
MDNS203 VSS VSS VSS VSS nfet_03v3 L=2u W=0.5u nf=1
MDNS204 VSS VSS VSS VSS nfet_03v3 L=2u W=0.5u nf=1
MDNS205 VSS VSS VSS VSS nfet_03v3 L=2u W=0.5u nf=1
MDNS206 VSS VSS VSS VSS nfet_03v3 L=2u W=0.5u nf=1
MDNS207 VSS VSS VSS VSS nfet_03v3 L=2u W=0.5u nf=1
MDNS208 VSS VSS VSS VSS nfet_03v3 L=2u W=0.5u nf=1
MDNS209 VSS VSS VSS VSS nfet_03v3 L=2u W=0.5u nf=1
MDNS210 VSS VSS VSS VSS nfet_03v3 L=2u W=0.5u nf=1
MDNS211 VSS VSS VSS VSS nfet_03v3 L=2u W=0.5u nf=1
MDNS212 VSS VSS VSS VSS nfet_03v3 L=2u W=0.5u nf=1
MDNS213 VSS VSS VSS VSS nfet_03v3 L=2u W=0.5u nf=1
MDNS214 VSS VSS VSS VSS nfet_03v3 L=2u W=0.5u nf=1
MDNS215 VSS VSS VSS VSS nfet_03v3 L=2u W=0.5u nf=1
MDNS216 VSS VSS VSS VSS nfet_03v3 L=2u W=0.5u nf=1
MDNS217 VSS VSS VSS VSS nfet_03v3 L=2u W=0.5u nf=1
MDNS218 VSS VSS VSS VSS nfet_03v3 L=2u W=0.5u nf=1
MDNS219 VSS VSS VSS VSS nfet_03v3 L=2u W=0.5u nf=1
MDNS220 VSS VSS VSS VSS nfet_03v3 L=2u W=0.5u nf=1
MDNS221 VSS VSS VSS VSS nfet_03v3 L=2u W=0.5u nf=1
MDNS222 VSS VSS VSS VSS nfet_03v3 L=2u W=0.5u nf=1
MDNS223 VSS VSS VSS VSS nfet_03v3 L=2u W=0.5u nf=1
MDNS224 VSS VSS VSS VSS nfet_03v3 L=2u W=0.5u nf=1
MDNS225 VSS VSS VSS VSS nfet_03v3 L=2u W=0.5u nf=1
MDNS226 VSS VSS VSS VSS nfet_03v3 L=2u W=0.5u nf=1
MDNS227 VSS VSS VSS VSS nfet_03v3 L=2u W=0.5u nf=1
MDNS228 VSS VSS VSS VSS nfet_03v3 L=2u W=0.5u nf=1
MDNS229 VSS VSS VSS VSS nfet_03v3 L=2u W=0.5u nf=1
MDNS230 VSS VSS VSS VSS nfet_03v3 L=2u W=0.5u nf=1
MDNS231 VSS VSS VSS VSS nfet_03v3 L=2u W=0.5u nf=1
MDNS232 VSS VSS VSS VSS nfet_03v3 L=2u W=0.5u nf=1
MDNS233 VSS VSS VSS VSS nfet_03v3 L=2u W=0.5u nf=1
MDNS234 VSS VSS VSS VSS nfet_03v3 L=2u W=0.5u nf=1
MDNS235 VSS VSS VSS VSS nfet_03v3 L=2u W=0.5u nf=1
MDNS236 VSS VSS VSS VSS nfet_03v3 L=2u W=0.5u nf=1
MDNS237 VSS VSS VSS VSS nfet_03v3 L=2u W=0.5u nf=1
MDNS238 VSS VSS VSS VSS nfet_03v3 L=2u W=0.5u nf=1
MDNS239 VSS VSS VSS VSS nfet_03v3 L=2u W=0.5u nf=1
MDNS240 VSS VSS VSS VSS nfet_03v3 L=2u W=0.5u nf=1
MDNS241 VSS VSS VSS VSS nfet_03v3 L=2u W=0.5u nf=1
MDNS242 VSS VSS VSS VSS nfet_03v3 L=2u W=0.5u nf=1
MDNS243 VSS VSS VSS VSS nfet_03v3 L=2u W=0.5u nf=1
MDNS244 VSS VSS VSS VSS nfet_03v3 L=2u W=0.5u nf=1
MDNS245 VSS VSS VSS VSS nfet_03v3 L=2u W=0.5u nf=1
MDNS246 VSS VSS VSS VSS nfet_03v3 L=2u W=0.5u nf=1
MDNS247 VSS VSS VSS VSS nfet_03v3 L=2u W=0.5u nf=1
MDNS248 VSS VSS VSS VSS nfet_03v3 L=2u W=0.5u nf=1
MDNS249 VSS VSS VSS VSS nfet_03v3 L=2u W=0.5u nf=1
MDNS250 VSS VSS VSS VSS nfet_03v3 L=2u W=0.5u nf=1
MDNS251 VSS VSS VSS VSS nfet_03v3 L=2u W=0.5u nf=1
MDNS252 VSS VSS VSS VSS nfet_03v3 L=2u W=0.5u nf=1
MDNS253 VSS VSS VSS VSS nfet_03v3 L=2u W=0.5u nf=1
MDNS254 VSS VSS VSS VSS nfet_03v3 L=2u W=0.5u nf=1
MDNS255 VSS VSS VSS VSS nfet_03v3 L=2u W=0.5u nf=1
MDNS256 VSS VSS VSS VSS nfet_03v3 L=2u W=0.5u nf=1
MDNS257 VSS VSS VSS VSS nfet_03v3 L=2u W=0.5u nf=1
MDNS258 VSS VSS VSS VSS nfet_03v3 L=2u W=0.5u nf=1
MDNS259 VSS VSS VSS VSS nfet_03v3 L=2u W=0.5u nf=1
MDNS260 VSS VSS VSS VSS nfet_03v3 L=2u W=0.5u nf=1
MDNS261 VSS VSS VSS VSS nfet_03v3 L=2u W=0.5u nf=1
MDNW0 VSS VSS VSS VSS nfet_03v3 L=2u W=1u nf=1
MDNE0 VSS VSS VSS VSS nfet_03v3 L=2u W=1u nf=1
MDPN0 VDD VDD VDD VDD pfet_03v3 L=2u W=0.5u nf=1
MDPN1 VDD VDD VDD VDD pfet_03v3 L=2u W=0.5u nf=1
MDPN2 VDD VDD VDD VDD pfet_03v3 L=2u W=0.5u nf=1
MDPN3 VDD VDD VDD VDD pfet_03v3 L=2u W=0.5u nf=1
MDPN4 VDD VDD VDD VDD pfet_03v3 L=2u W=0.5u nf=1
MDPN5 VDD VDD VDD VDD pfet_03v3 L=2u W=0.5u nf=1
MDPN6 VDD VDD VDD VDD pfet_03v3 L=2u W=0.5u nf=1
MDPN7 VDD VDD VDD VDD pfet_03v3 L=2u W=0.5u nf=1
MDPN8 VDD VDD VDD VDD pfet_03v3 L=2u W=0.5u nf=1
MDPN9 VDD VDD VDD VDD pfet_03v3 L=2u W=0.5u nf=1
MDPN10 VDD VDD VDD VDD pfet_03v3 L=2u W=0.5u nf=1
MDPN11 VDD VDD VDD VDD pfet_03v3 L=2u W=0.5u nf=1
MDPN12 VDD VDD VDD VDD pfet_03v3 L=2u W=0.5u nf=1
MDPN13 VDD VDD VDD VDD pfet_03v3 L=2u W=0.5u nf=1
MDPN14 VDD VDD VDD VDD pfet_03v3 L=2u W=0.5u nf=1
MDPN15 VDD VDD VDD VDD pfet_03v3 L=2u W=0.5u nf=1
MDPN16 VDD VDD VDD VDD pfet_03v3 L=2u W=0.5u nf=1
MDPN17 VDD VDD VDD VDD pfet_03v3 L=2u W=0.5u nf=1
MDPN18 VDD VDD VDD VDD pfet_03v3 L=2u W=0.5u nf=1
MDPN19 VDD VDD VDD VDD pfet_03v3 L=2u W=0.5u nf=1
MDPN20 VDD VDD VDD VDD pfet_03v3 L=2u W=0.5u nf=1
MDPN21 VDD VDD VDD VDD pfet_03v3 L=2u W=0.5u nf=1
MDPN22 VDD VDD VDD VDD pfet_03v3 L=2u W=0.5u nf=1
MDPN23 VDD VDD VDD VDD pfet_03v3 L=2u W=0.5u nf=1
MDPN24 VDD VDD VDD VDD pfet_03v3 L=2u W=0.5u nf=1
MDPN25 VDD VDD VDD VDD pfet_03v3 L=2u W=0.5u nf=1
MDPN26 VDD VDD VDD VDD pfet_03v3 L=2u W=0.5u nf=1
MDPN27 VDD VDD VDD VDD pfet_03v3 L=2u W=0.5u nf=1
MDPN28 VDD VDD VDD VDD pfet_03v3 L=2u W=0.5u nf=1
MDPN29 VDD VDD VDD VDD pfet_03v3 L=2u W=0.5u nf=1
MDPN30 VDD VDD VDD VDD pfet_03v3 L=2u W=0.5u nf=1
MDPN31 VDD VDD VDD VDD pfet_03v3 L=2u W=0.5u nf=1
MDPN32 VDD VDD VDD VDD pfet_03v3 L=2u W=0.5u nf=1
MDPN33 VDD VDD VDD VDD pfet_03v3 L=2u W=0.5u nf=1
MDPN34 VDD VDD VDD VDD pfet_03v3 L=2u W=0.5u nf=1
MDPN35 VDD VDD VDD VDD pfet_03v3 L=2u W=0.5u nf=1
MDPN36 VDD VDD VDD VDD pfet_03v3 L=2u W=0.5u nf=1
MDPN37 VDD VDD VDD VDD pfet_03v3 L=2u W=0.5u nf=1
MDPN38 VDD VDD VDD VDD pfet_03v3 L=2u W=0.5u nf=1
MDPN39 VDD VDD VDD VDD pfet_03v3 L=2u W=0.5u nf=1
MDPN40 VDD VDD VDD VDD pfet_03v3 L=2u W=0.5u nf=1
MDPN41 VDD VDD VDD VDD pfet_03v3 L=2u W=0.5u nf=1
MDPN42 VDD VDD VDD VDD pfet_03v3 L=2u W=0.5u nf=1
MDPN43 VDD VDD VDD VDD pfet_03v3 L=2u W=0.5u nf=1
MDPN44 VDD VDD VDD VDD pfet_03v3 L=2u W=0.5u nf=1
MDPN45 VDD VDD VDD VDD pfet_03v3 L=2u W=0.5u nf=1
MDPN46 VDD VDD VDD VDD pfet_03v3 L=2u W=0.5u nf=1
MDPN47 VDD VDD VDD VDD pfet_03v3 L=2u W=0.5u nf=1
MDPN48 VDD VDD VDD VDD pfet_03v3 L=2u W=0.5u nf=1
MDPN49 VDD VDD VDD VDD pfet_03v3 L=2u W=0.5u nf=1
MDPN50 VDD VDD VDD VDD pfet_03v3 L=2u W=0.5u nf=1
MDPN51 VDD VDD VDD VDD pfet_03v3 L=2u W=0.5u nf=1
MDPN52 VDD VDD VDD VDD pfet_03v3 L=2u W=0.5u nf=1
MDPN53 VDD VDD VDD VDD pfet_03v3 L=2u W=0.5u nf=1
MDPN54 VDD VDD VDD VDD pfet_03v3 L=2u W=0.5u nf=1
MDPN55 VDD VDD VDD VDD pfet_03v3 L=2u W=0.5u nf=1
MDPN56 VDD VDD VDD VDD pfet_03v3 L=2u W=0.5u nf=1
MDPN57 VDD VDD VDD VDD pfet_03v3 L=2u W=0.5u nf=1
MDPN58 VDD VDD VDD VDD pfet_03v3 L=2u W=0.5u nf=1
MDPN59 VDD VDD VDD VDD pfet_03v3 L=2u W=0.5u nf=1
MDPN60 VDD VDD VDD VDD pfet_03v3 L=2u W=0.5u nf=1
MDPN61 VDD VDD VDD VDD pfet_03v3 L=2u W=0.5u nf=1
MDPN62 VDD VDD VDD VDD pfet_03v3 L=2u W=0.5u nf=1
MDPN63 VDD VDD VDD VDD pfet_03v3 L=2u W=0.5u nf=1
MDPN64 VDD VDD VDD VDD pfet_03v3 L=2u W=0.5u nf=1
MDPN65 VDD VDD VDD VDD pfet_03v3 L=2u W=0.5u nf=1
MDPN66 VDD VDD VDD VDD pfet_03v3 L=2u W=0.5u nf=1
MDPN67 VDD VDD VDD VDD pfet_03v3 L=2u W=0.5u nf=1
MDPN68 VDD VDD VDD VDD pfet_03v3 L=2u W=0.5u nf=1
MDPN69 VDD VDD VDD VDD pfet_03v3 L=2u W=0.5u nf=1
MDPN70 VDD VDD VDD VDD pfet_03v3 L=2u W=0.5u nf=1
MDPN71 VDD VDD VDD VDD pfet_03v3 L=2u W=0.5u nf=1
MDPN72 VDD VDD VDD VDD pfet_03v3 L=2u W=0.5u nf=1
MDPN73 VDD VDD VDD VDD pfet_03v3 L=2u W=0.5u nf=1
MDPN74 VDD VDD VDD VDD pfet_03v3 L=2u W=0.5u nf=1
MDPN75 VDD VDD VDD VDD pfet_03v3 L=2u W=0.5u nf=1
MDPN76 VDD VDD VDD VDD pfet_03v3 L=2u W=0.5u nf=1
MDPN77 VDD VDD VDD VDD pfet_03v3 L=2u W=0.5u nf=1
MDPN78 VDD VDD VDD VDD pfet_03v3 L=2u W=0.5u nf=1
MDPN79 VDD VDD VDD VDD pfet_03v3 L=2u W=0.5u nf=1
MDPN80 VDD VDD VDD VDD pfet_03v3 L=2u W=0.5u nf=1
MDPN81 VDD VDD VDD VDD pfet_03v3 L=2u W=0.5u nf=1
MDPN82 VDD VDD VDD VDD pfet_03v3 L=2u W=0.5u nf=1
MDPN83 VDD VDD VDD VDD pfet_03v3 L=2u W=0.5u nf=1
MDPN84 VDD VDD VDD VDD pfet_03v3 L=2u W=0.5u nf=1
MDPN85 VDD VDD VDD VDD pfet_03v3 L=2u W=0.5u nf=1
MDPN86 VDD VDD VDD VDD pfet_03v3 L=2u W=0.5u nf=1
MDPN87 VDD VDD VDD VDD pfet_03v3 L=2u W=0.5u nf=1
MDPN88 VDD VDD VDD VDD pfet_03v3 L=2u W=0.5u nf=1
MDPN89 VDD VDD VDD VDD pfet_03v3 L=2u W=0.5u nf=1
MDPN90 VDD VDD VDD VDD pfet_03v3 L=2u W=0.5u nf=1
MDPN91 VDD VDD VDD VDD pfet_03v3 L=2u W=0.5u nf=1
MDPN92 VDD VDD VDD VDD pfet_03v3 L=2u W=0.5u nf=1
MDPN93 VDD VDD VDD VDD pfet_03v3 L=2u W=0.5u nf=1
MDPN94 VDD VDD VDD VDD pfet_03v3 L=2u W=0.5u nf=1
MDPN95 VDD VDD VDD VDD pfet_03v3 L=2u W=0.5u nf=1
MDPN96 VDD VDD VDD VDD pfet_03v3 L=2u W=0.5u nf=1
MDPN97 VDD VDD VDD VDD pfet_03v3 L=2u W=0.5u nf=1
MDPN98 VDD VDD VDD VDD pfet_03v3 L=2u W=0.5u nf=1
MDPN99 VDD VDD VDD VDD pfet_03v3 L=2u W=0.5u nf=1
MDPN100 VDD VDD VDD VDD pfet_03v3 L=2u W=0.5u nf=1
MDPN101 VDD VDD VDD VDD pfet_03v3 L=2u W=0.5u nf=1
MDPN102 VDD VDD VDD VDD pfet_03v3 L=2u W=0.5u nf=1
MDPN103 VDD VDD VDD VDD pfet_03v3 L=2u W=0.5u nf=1
MDPN104 VDD VDD VDD VDD pfet_03v3 L=2u W=0.5u nf=1
MDPN105 VDD VDD VDD VDD pfet_03v3 L=2u W=0.5u nf=1
MDPN106 VDD VDD VDD VDD pfet_03v3 L=2u W=0.5u nf=1
MDPN107 VDD VDD VDD VDD pfet_03v3 L=2u W=0.5u nf=1
MDPN108 VDD VDD VDD VDD pfet_03v3 L=2u W=0.5u nf=1
MDPN109 VDD VDD VDD VDD pfet_03v3 L=2u W=0.5u nf=1
MDPN110 VDD VDD VDD VDD pfet_03v3 L=2u W=0.5u nf=1
MDPN111 VDD VDD VDD VDD pfet_03v3 L=2u W=0.5u nf=1
MDPN112 VDD VDD VDD VDD pfet_03v3 L=2u W=0.5u nf=1
MDPN113 VDD VDD VDD VDD pfet_03v3 L=2u W=0.5u nf=1
MDPN114 VDD VDD VDD VDD pfet_03v3 L=2u W=0.5u nf=1
MDPN115 VDD VDD VDD VDD pfet_03v3 L=2u W=0.5u nf=1
MDPN116 VDD VDD VDD VDD pfet_03v3 L=2u W=0.5u nf=1
MDPN117 VDD VDD VDD VDD pfet_03v3 L=2u W=0.5u nf=1
MDPN118 VDD VDD VDD VDD pfet_03v3 L=2u W=0.5u nf=1
MDPN119 VDD VDD VDD VDD pfet_03v3 L=2u W=0.5u nf=1
MDPN120 VDD VDD VDD VDD pfet_03v3 L=2u W=0.5u nf=1
MDPN121 VDD VDD VDD VDD pfet_03v3 L=2u W=0.5u nf=1
MDPN122 VDD VDD VDD VDD pfet_03v3 L=2u W=0.5u nf=1
MDPN123 VDD VDD VDD VDD pfet_03v3 L=2u W=0.5u nf=1
MDPN124 VDD VDD VDD VDD pfet_03v3 L=2u W=0.5u nf=1
MDPN125 VDD VDD VDD VDD pfet_03v3 L=2u W=0.5u nf=1
MDPN126 VDD VDD VDD VDD pfet_03v3 L=2u W=0.5u nf=1
MDPN127 VDD VDD VDD VDD pfet_03v3 L=2u W=0.5u nf=1
MDPN128 VDD VDD VDD VDD pfet_03v3 L=2u W=0.5u nf=1
MDPN129 VDD VDD VDD VDD pfet_03v3 L=2u W=0.5u nf=1
MDPN130 VDD VDD VDD VDD pfet_03v3 L=2u W=0.5u nf=1
MDPN131 VDD VDD VDD VDD pfet_03v3 L=2u W=0.5u nf=1
MDPN132 VDD VDD VDD VDD pfet_03v3 L=2u W=0.5u nf=1
MDPN133 VDD VDD VDD VDD pfet_03v3 L=2u W=0.5u nf=1
MDPN134 VDD VDD VDD VDD pfet_03v3 L=2u W=0.5u nf=1
MDPN135 VDD VDD VDD VDD pfet_03v3 L=2u W=0.5u nf=1
MDPN136 VDD VDD VDD VDD pfet_03v3 L=2u W=0.5u nf=1
MDPN137 VDD VDD VDD VDD pfet_03v3 L=2u W=0.5u nf=1
MDPN138 VDD VDD VDD VDD pfet_03v3 L=2u W=0.5u nf=1
MDPN139 VDD VDD VDD VDD pfet_03v3 L=2u W=0.5u nf=1
MDPN140 VDD VDD VDD VDD pfet_03v3 L=2u W=0.5u nf=1
MDPN141 VDD VDD VDD VDD pfet_03v3 L=2u W=0.5u nf=1
MDPN142 VDD VDD VDD VDD pfet_03v3 L=2u W=0.5u nf=1
MDPN143 VDD VDD VDD VDD pfet_03v3 L=2u W=0.5u nf=1
MDPN144 VDD VDD VDD VDD pfet_03v3 L=2u W=0.5u nf=1
MDPN145 VDD VDD VDD VDD pfet_03v3 L=2u W=0.5u nf=1
MDPN146 VDD VDD VDD VDD pfet_03v3 L=2u W=0.5u nf=1
MDPN147 VDD VDD VDD VDD pfet_03v3 L=2u W=0.5u nf=1
MDPN148 VDD VDD VDD VDD pfet_03v3 L=2u W=0.5u nf=1
MDPN149 VDD VDD VDD VDD pfet_03v3 L=2u W=0.5u nf=1
MDPN150 VDD VDD VDD VDD pfet_03v3 L=2u W=0.5u nf=1
MDPN151 VDD VDD VDD VDD pfet_03v3 L=2u W=0.5u nf=1
MDPN152 VDD VDD VDD VDD pfet_03v3 L=2u W=0.5u nf=1
MDPN153 VDD VDD VDD VDD pfet_03v3 L=2u W=0.5u nf=1
MDPN154 VDD VDD VDD VDD pfet_03v3 L=2u W=0.5u nf=1
MDPN155 VDD VDD VDD VDD pfet_03v3 L=2u W=0.5u nf=1
MDPN156 VDD VDD VDD VDD pfet_03v3 L=2u W=0.5u nf=1
MDPN157 VDD VDD VDD VDD pfet_03v3 L=2u W=0.5u nf=1
MDPN158 VDD VDD VDD VDD pfet_03v3 L=2u W=0.5u nf=1
MDPN159 VDD VDD VDD VDD pfet_03v3 L=2u W=0.5u nf=1
MDPN160 VDD VDD VDD VDD pfet_03v3 L=2u W=0.5u nf=1
MDPN161 VDD VDD VDD VDD pfet_03v3 L=2u W=0.5u nf=1
MDPN162 VDD VDD VDD VDD pfet_03v3 L=2u W=0.5u nf=1
MDPN163 VDD VDD VDD VDD pfet_03v3 L=2u W=0.5u nf=1
MDPN164 VDD VDD VDD VDD pfet_03v3 L=2u W=0.5u nf=1
MDPN165 VDD VDD VDD VDD pfet_03v3 L=2u W=0.5u nf=1
MDPN166 VDD VDD VDD VDD pfet_03v3 L=2u W=0.5u nf=1
MDPN167 VDD VDD VDD VDD pfet_03v3 L=2u W=0.5u nf=1
MDPN168 VDD VDD VDD VDD pfet_03v3 L=2u W=0.5u nf=1
MDPN169 VDD VDD VDD VDD pfet_03v3 L=2u W=0.5u nf=1
MDPN170 VDD VDD VDD VDD pfet_03v3 L=2u W=0.5u nf=1
MDPN171 VDD VDD VDD VDD pfet_03v3 L=2u W=0.5u nf=1
MDPN172 VDD VDD VDD VDD pfet_03v3 L=2u W=0.5u nf=1
MDPN173 VDD VDD VDD VDD pfet_03v3 L=2u W=0.5u nf=1
MDPN174 VDD VDD VDD VDD pfet_03v3 L=2u W=0.5u nf=1
MDPN175 VDD VDD VDD VDD pfet_03v3 L=2u W=0.5u nf=1
MDPN176 VDD VDD VDD VDD pfet_03v3 L=2u W=0.5u nf=1
MDPN177 VDD VDD VDD VDD pfet_03v3 L=2u W=0.5u nf=1
MDPN178 VDD VDD VDD VDD pfet_03v3 L=2u W=0.5u nf=1
MDPN179 VDD VDD VDD VDD pfet_03v3 L=2u W=0.5u nf=1
MDPN180 VDD VDD VDD VDD pfet_03v3 L=2u W=0.5u nf=1
MDPN181 VDD VDD VDD VDD pfet_03v3 L=2u W=0.5u nf=1
MDPN182 VDD VDD VDD VDD pfet_03v3 L=2u W=0.5u nf=1
MDPN183 VDD VDD VDD VDD pfet_03v3 L=2u W=0.5u nf=1
MDPN184 VDD VDD VDD VDD pfet_03v3 L=2u W=0.5u nf=1
MDPN185 VDD VDD VDD VDD pfet_03v3 L=2u W=0.5u nf=1
MDPN186 VDD VDD VDD VDD pfet_03v3 L=2u W=0.5u nf=1
MDPN187 VDD VDD VDD VDD pfet_03v3 L=2u W=0.5u nf=1
MDPN188 VDD VDD VDD VDD pfet_03v3 L=2u W=0.5u nf=1
MDPN189 VDD VDD VDD VDD pfet_03v3 L=2u W=0.5u nf=1
MDPN190 VDD VDD VDD VDD pfet_03v3 L=2u W=0.5u nf=1
MDPN191 VDD VDD VDD VDD pfet_03v3 L=2u W=0.5u nf=1
MDPN192 VDD VDD VDD VDD pfet_03v3 L=2u W=0.5u nf=1
MDPN193 VDD VDD VDD VDD pfet_03v3 L=2u W=0.5u nf=1
MDPN194 VDD VDD VDD VDD pfet_03v3 L=2u W=0.5u nf=1
MDPN195 VDD VDD VDD VDD pfet_03v3 L=2u W=0.5u nf=1
MDPN196 VDD VDD VDD VDD pfet_03v3 L=2u W=0.5u nf=1
MDPN197 VDD VDD VDD VDD pfet_03v3 L=2u W=0.5u nf=1
MDPN198 VDD VDD VDD VDD pfet_03v3 L=2u W=0.5u nf=1
MDPN199 VDD VDD VDD VDD pfet_03v3 L=2u W=0.5u nf=1
MDPN200 VDD VDD VDD VDD pfet_03v3 L=2u W=0.5u nf=1
MDPN201 VDD VDD VDD VDD pfet_03v3 L=2u W=0.5u nf=1
MDPN202 VDD VDD VDD VDD pfet_03v3 L=2u W=0.5u nf=1
MDPN203 VDD VDD VDD VDD pfet_03v3 L=2u W=0.5u nf=1
MDPN204 VDD VDD VDD VDD pfet_03v3 L=2u W=0.5u nf=1
MDPN205 VDD VDD VDD VDD pfet_03v3 L=2u W=0.5u nf=1
MDPN206 VDD VDD VDD VDD pfet_03v3 L=2u W=0.5u nf=1
MDPN207 VDD VDD VDD VDD pfet_03v3 L=2u W=0.5u nf=1
MDPN208 VDD VDD VDD VDD pfet_03v3 L=2u W=0.5u nf=1
MDPN209 VDD VDD VDD VDD pfet_03v3 L=2u W=0.5u nf=1
MDPN210 VDD VDD VDD VDD pfet_03v3 L=2u W=0.5u nf=1
MDPS0 VDD VDD VDD VDD pfet_03v3 L=2u W=0.5u nf=1
MDPS1 VDD VDD VDD VDD pfet_03v3 L=2u W=0.5u nf=1
MDPS2 VDD VDD VDD VDD pfet_03v3 L=2u W=0.5u nf=1
MDPS3 VDD VDD VDD VDD pfet_03v3 L=2u W=0.5u nf=1
MDPS4 VDD VDD VDD VDD pfet_03v3 L=2u W=0.5u nf=1
MDPS5 VDD VDD VDD VDD pfet_03v3 L=2u W=0.5u nf=1
MDPS6 VDD VDD VDD VDD pfet_03v3 L=2u W=0.5u nf=1
MDPS7 VDD VDD VDD VDD pfet_03v3 L=2u W=0.5u nf=1
MDPS8 VDD VDD VDD VDD pfet_03v3 L=2u W=0.5u nf=1
MDPS9 VDD VDD VDD VDD pfet_03v3 L=2u W=0.5u nf=1
MDPS10 VDD VDD VDD VDD pfet_03v3 L=2u W=0.5u nf=1
MDPS11 VDD VDD VDD VDD pfet_03v3 L=2u W=0.5u nf=1
MDPS12 VDD VDD VDD VDD pfet_03v3 L=2u W=0.5u nf=1
MDPS13 VDD VDD VDD VDD pfet_03v3 L=2u W=0.5u nf=1
MDPS14 VDD VDD VDD VDD pfet_03v3 L=2u W=0.5u nf=1
MDPS15 VDD VDD VDD VDD pfet_03v3 L=2u W=0.5u nf=1
MDPS16 VDD VDD VDD VDD pfet_03v3 L=2u W=0.5u nf=1
MDPS17 VDD VDD VDD VDD pfet_03v3 L=2u W=0.5u nf=1
MDPS18 VDD VDD VDD VDD pfet_03v3 L=2u W=0.5u nf=1
MDPS19 VDD VDD VDD VDD pfet_03v3 L=2u W=0.5u nf=1
MDPS20 VDD VDD VDD VDD pfet_03v3 L=2u W=0.5u nf=1
MDPS21 VDD VDD VDD VDD pfet_03v3 L=2u W=0.5u nf=1
MDPS22 VDD VDD VDD VDD pfet_03v3 L=2u W=0.5u nf=1
MDPS23 VDD VDD VDD VDD pfet_03v3 L=2u W=0.5u nf=1
MDPS24 VDD VDD VDD VDD pfet_03v3 L=2u W=0.5u nf=1
MDPS25 VDD VDD VDD VDD pfet_03v3 L=2u W=0.5u nf=1
MDPS26 VDD VDD VDD VDD pfet_03v3 L=2u W=0.5u nf=1
MDPS27 VDD VDD VDD VDD pfet_03v3 L=2u W=0.5u nf=1
MDPS28 VDD VDD VDD VDD pfet_03v3 L=2u W=0.5u nf=1
MDPS29 VDD VDD VDD VDD pfet_03v3 L=2u W=0.5u nf=1
MDPS30 VDD VDD VDD VDD pfet_03v3 L=2u W=0.5u nf=1
MDPS31 VDD VDD VDD VDD pfet_03v3 L=2u W=0.5u nf=1
MDPS32 VDD VDD VDD VDD pfet_03v3 L=2u W=0.5u nf=1
MDPS33 VDD VDD VDD VDD pfet_03v3 L=2u W=0.5u nf=1
MDPS34 VDD VDD VDD VDD pfet_03v3 L=2u W=0.5u nf=1
MDPS35 VDD VDD VDD VDD pfet_03v3 L=2u W=0.5u nf=1
MDPS36 VDD VDD VDD VDD pfet_03v3 L=2u W=0.5u nf=1
MDPS37 VDD VDD VDD VDD pfet_03v3 L=2u W=0.5u nf=1
MDPS38 VDD VDD VDD VDD pfet_03v3 L=2u W=0.5u nf=1
MDPS39 VDD VDD VDD VDD pfet_03v3 L=2u W=0.5u nf=1
MDPS40 VDD VDD VDD VDD pfet_03v3 L=2u W=0.5u nf=1
MDPS41 VDD VDD VDD VDD pfet_03v3 L=2u W=0.5u nf=1
MDPS42 VDD VDD VDD VDD pfet_03v3 L=2u W=0.5u nf=1
MDPS43 VDD VDD VDD VDD pfet_03v3 L=2u W=0.5u nf=1
MDPS44 VDD VDD VDD VDD pfet_03v3 L=2u W=0.5u nf=1
MDPS45 VDD VDD VDD VDD pfet_03v3 L=2u W=0.5u nf=1
MDPS46 VDD VDD VDD VDD pfet_03v3 L=2u W=0.5u nf=1
MDPS47 VDD VDD VDD VDD pfet_03v3 L=2u W=0.5u nf=1
MDPS48 VDD VDD VDD VDD pfet_03v3 L=2u W=0.5u nf=1
MDPS49 VDD VDD VDD VDD pfet_03v3 L=2u W=0.5u nf=1
MDPS50 VDD VDD VDD VDD pfet_03v3 L=2u W=0.5u nf=1
MDPS51 VDD VDD VDD VDD pfet_03v3 L=2u W=0.5u nf=1
MDPS52 VDD VDD VDD VDD pfet_03v3 L=2u W=0.5u nf=1
MDPS53 VDD VDD VDD VDD pfet_03v3 L=2u W=0.5u nf=1
MDPS54 VDD VDD VDD VDD pfet_03v3 L=2u W=0.5u nf=1
MDPS55 VDD VDD VDD VDD pfet_03v3 L=2u W=0.5u nf=1
MDPS56 VDD VDD VDD VDD pfet_03v3 L=2u W=0.5u nf=1
MDPS57 VDD VDD VDD VDD pfet_03v3 L=2u W=0.5u nf=1
MDPS58 VDD VDD VDD VDD pfet_03v3 L=2u W=0.5u nf=1
MDPS59 VDD VDD VDD VDD pfet_03v3 L=2u W=0.5u nf=1
MDPS60 VDD VDD VDD VDD pfet_03v3 L=2u W=0.5u nf=1
MDPS61 VDD VDD VDD VDD pfet_03v3 L=2u W=0.5u nf=1
MDPS62 VDD VDD VDD VDD pfet_03v3 L=2u W=0.5u nf=1
MDPS63 VDD VDD VDD VDD pfet_03v3 L=2u W=0.5u nf=1
MDPS64 VDD VDD VDD VDD pfet_03v3 L=2u W=0.5u nf=1
MDPS65 VDD VDD VDD VDD pfet_03v3 L=2u W=0.5u nf=1
MDPS66 VDD VDD VDD VDD pfet_03v3 L=2u W=0.5u nf=1
MDPS67 VDD VDD VDD VDD pfet_03v3 L=2u W=0.5u nf=1
MDPS68 VDD VDD VDD VDD pfet_03v3 L=2u W=0.5u nf=1
MDPS69 VDD VDD VDD VDD pfet_03v3 L=2u W=0.5u nf=1
MDPS70 VDD VDD VDD VDD pfet_03v3 L=2u W=0.5u nf=1
MDPS71 VDD VDD VDD VDD pfet_03v3 L=2u W=0.5u nf=1
MDPS72 VDD VDD VDD VDD pfet_03v3 L=2u W=0.5u nf=1
MDPS73 VDD VDD VDD VDD pfet_03v3 L=2u W=0.5u nf=1
MDPS74 VDD VDD VDD VDD pfet_03v3 L=2u W=0.5u nf=1
MDPS75 VDD VDD VDD VDD pfet_03v3 L=2u W=0.5u nf=1
MDPS76 VDD VDD VDD VDD pfet_03v3 L=2u W=0.5u nf=1
MDPS77 VDD VDD VDD VDD pfet_03v3 L=2u W=0.5u nf=1
MDPS78 VDD VDD VDD VDD pfet_03v3 L=2u W=0.5u nf=1
MDPS79 VDD VDD VDD VDD pfet_03v3 L=2u W=0.5u nf=1
MDPS80 VDD VDD VDD VDD pfet_03v3 L=2u W=0.5u nf=1
MDPS81 VDD VDD VDD VDD pfet_03v3 L=2u W=0.5u nf=1
MDPS82 VDD VDD VDD VDD pfet_03v3 L=2u W=0.5u nf=1
MDPS83 VDD VDD VDD VDD pfet_03v3 L=2u W=0.5u nf=1
MDPS84 VDD VDD VDD VDD pfet_03v3 L=2u W=0.5u nf=1
MDPS85 VDD VDD VDD VDD pfet_03v3 L=2u W=0.5u nf=1
MDPS86 VDD VDD VDD VDD pfet_03v3 L=2u W=0.5u nf=1
MDPS87 VDD VDD VDD VDD pfet_03v3 L=2u W=0.5u nf=1
MDPS88 VDD VDD VDD VDD pfet_03v3 L=2u W=0.5u nf=1
MDPS89 VDD VDD VDD VDD pfet_03v3 L=2u W=0.5u nf=1
MDPS90 VDD VDD VDD VDD pfet_03v3 L=2u W=0.5u nf=1
MDPS91 VDD VDD VDD VDD pfet_03v3 L=2u W=0.5u nf=1
MDPS92 VDD VDD VDD VDD pfet_03v3 L=2u W=0.5u nf=1
MDPS93 VDD VDD VDD VDD pfet_03v3 L=2u W=0.5u nf=1
MDPS94 VDD VDD VDD VDD pfet_03v3 L=2u W=0.5u nf=1
MDPS95 VDD VDD VDD VDD pfet_03v3 L=2u W=0.5u nf=1
MDPS96 VDD VDD VDD VDD pfet_03v3 L=2u W=0.5u nf=1
MDPS97 VDD VDD VDD VDD pfet_03v3 L=2u W=0.5u nf=1
MDPS98 VDD VDD VDD VDD pfet_03v3 L=2u W=0.5u nf=1
MDPS99 VDD VDD VDD VDD pfet_03v3 L=2u W=0.5u nf=1
MDPS100 VDD VDD VDD VDD pfet_03v3 L=2u W=0.5u nf=1
MDPS101 VDD VDD VDD VDD pfet_03v3 L=2u W=0.5u nf=1
MDPS102 VDD VDD VDD VDD pfet_03v3 L=2u W=0.5u nf=1
MDPS103 VDD VDD VDD VDD pfet_03v3 L=2u W=0.5u nf=1
MDPS104 VDD VDD VDD VDD pfet_03v3 L=2u W=0.5u nf=1
MDPS105 VDD VDD VDD VDD pfet_03v3 L=2u W=0.5u nf=1
MDPS106 VDD VDD VDD VDD pfet_03v3 L=2u W=0.5u nf=1
MDPS107 VDD VDD VDD VDD pfet_03v3 L=2u W=0.5u nf=1
MDPS108 VDD VDD VDD VDD pfet_03v3 L=2u W=0.5u nf=1
MDPS109 VDD VDD VDD VDD pfet_03v3 L=2u W=0.5u nf=1
MDPS110 VDD VDD VDD VDD pfet_03v3 L=2u W=0.5u nf=1
MDPS111 VDD VDD VDD VDD pfet_03v3 L=2u W=0.5u nf=1
MDPS112 VDD VDD VDD VDD pfet_03v3 L=2u W=0.5u nf=1
MDPS113 VDD VDD VDD VDD pfet_03v3 L=2u W=0.5u nf=1
MDPS114 VDD VDD VDD VDD pfet_03v3 L=2u W=0.5u nf=1
MDPS115 VDD VDD VDD VDD pfet_03v3 L=2u W=0.5u nf=1
MDPS116 VDD VDD VDD VDD pfet_03v3 L=2u W=0.5u nf=1
MDPS117 VDD VDD VDD VDD pfet_03v3 L=2u W=0.5u nf=1
MDPS118 VDD VDD VDD VDD pfet_03v3 L=2u W=0.5u nf=1
MDPS119 VDD VDD VDD VDD pfet_03v3 L=2u W=0.5u nf=1
MDPS120 VDD VDD VDD VDD pfet_03v3 L=2u W=0.5u nf=1
MDPS121 VDD VDD VDD VDD pfet_03v3 L=2u W=0.5u nf=1
MDPS122 VDD VDD VDD VDD pfet_03v3 L=2u W=0.5u nf=1
MDPS123 VDD VDD VDD VDD pfet_03v3 L=2u W=0.5u nf=1
MDPS124 VDD VDD VDD VDD pfet_03v3 L=2u W=0.5u nf=1
MDPS125 VDD VDD VDD VDD pfet_03v3 L=2u W=0.5u nf=1
MDPS126 VDD VDD VDD VDD pfet_03v3 L=2u W=0.5u nf=1
MDPS127 VDD VDD VDD VDD pfet_03v3 L=2u W=0.5u nf=1
MDPS128 VDD VDD VDD VDD pfet_03v3 L=2u W=0.5u nf=1
MDPS129 VDD VDD VDD VDD pfet_03v3 L=2u W=0.5u nf=1
MDPS130 VDD VDD VDD VDD pfet_03v3 L=2u W=0.5u nf=1
MDPS131 VDD VDD VDD VDD pfet_03v3 L=2u W=0.5u nf=1
MDPS132 VDD VDD VDD VDD pfet_03v3 L=2u W=0.5u nf=1
MDPS133 VDD VDD VDD VDD pfet_03v3 L=2u W=0.5u nf=1
MDPS134 VDD VDD VDD VDD pfet_03v3 L=2u W=0.5u nf=1
MDPS135 VDD VDD VDD VDD pfet_03v3 L=2u W=0.5u nf=1
MDPS136 VDD VDD VDD VDD pfet_03v3 L=2u W=0.5u nf=1
MDPS137 VDD VDD VDD VDD pfet_03v3 L=2u W=0.5u nf=1
MDPS138 VDD VDD VDD VDD pfet_03v3 L=2u W=0.5u nf=1
MDPS139 VDD VDD VDD VDD pfet_03v3 L=2u W=0.5u nf=1
MDPS140 VDD VDD VDD VDD pfet_03v3 L=2u W=0.5u nf=1
MDPS141 VDD VDD VDD VDD pfet_03v3 L=2u W=0.5u nf=1
MDPS142 VDD VDD VDD VDD pfet_03v3 L=2u W=0.5u nf=1
MDPS143 VDD VDD VDD VDD pfet_03v3 L=2u W=0.5u nf=1
MDPS144 VDD VDD VDD VDD pfet_03v3 L=2u W=0.5u nf=1
MDPS145 VDD VDD VDD VDD pfet_03v3 L=2u W=0.5u nf=1
MDPS146 VDD VDD VDD VDD pfet_03v3 L=2u W=0.5u nf=1
MDPS147 VDD VDD VDD VDD pfet_03v3 L=2u W=0.5u nf=1
MDPS148 VDD VDD VDD VDD pfet_03v3 L=2u W=0.5u nf=1
MDPS149 VDD VDD VDD VDD pfet_03v3 L=2u W=0.5u nf=1
MDPS150 VDD VDD VDD VDD pfet_03v3 L=2u W=0.5u nf=1
MDPS151 VDD VDD VDD VDD pfet_03v3 L=2u W=0.5u nf=1
MDPS152 VDD VDD VDD VDD pfet_03v3 L=2u W=0.5u nf=1
MDPS153 VDD VDD VDD VDD pfet_03v3 L=2u W=0.5u nf=1
MDPS154 VDD VDD VDD VDD pfet_03v3 L=2u W=0.5u nf=1
MDPS155 VDD VDD VDD VDD pfet_03v3 L=2u W=0.5u nf=1
MDPS156 VDD VDD VDD VDD pfet_03v3 L=2u W=0.5u nf=1
MDPS157 VDD VDD VDD VDD pfet_03v3 L=2u W=0.5u nf=1
MDPS158 VDD VDD VDD VDD pfet_03v3 L=2u W=0.5u nf=1
MDPS159 VDD VDD VDD VDD pfet_03v3 L=2u W=0.5u nf=1
MDPS160 VDD VDD VDD VDD pfet_03v3 L=2u W=0.5u nf=1
MDPS161 VDD VDD VDD VDD pfet_03v3 L=2u W=0.5u nf=1
MDPS162 VDD VDD VDD VDD pfet_03v3 L=2u W=0.5u nf=1
MDPS163 VDD VDD VDD VDD pfet_03v3 L=2u W=0.5u nf=1
MDPS164 VDD VDD VDD VDD pfet_03v3 L=2u W=0.5u nf=1
MDPS165 VDD VDD VDD VDD pfet_03v3 L=2u W=0.5u nf=1
MDPS166 VDD VDD VDD VDD pfet_03v3 L=2u W=0.5u nf=1
MDPS167 VDD VDD VDD VDD pfet_03v3 L=2u W=0.5u nf=1
MDPS168 VDD VDD VDD VDD pfet_03v3 L=2u W=0.5u nf=1
MDPS169 VDD VDD VDD VDD pfet_03v3 L=2u W=0.5u nf=1
MDPS170 VDD VDD VDD VDD pfet_03v3 L=2u W=0.5u nf=1
MDPS171 VDD VDD VDD VDD pfet_03v3 L=2u W=0.5u nf=1
MDPS172 VDD VDD VDD VDD pfet_03v3 L=2u W=0.5u nf=1
MDPS173 VDD VDD VDD VDD pfet_03v3 L=2u W=0.5u nf=1
MDPS174 VDD VDD VDD VDD pfet_03v3 L=2u W=0.5u nf=1
MDPS175 VDD VDD VDD VDD pfet_03v3 L=2u W=0.5u nf=1
MDPS176 VDD VDD VDD VDD pfet_03v3 L=2u W=0.5u nf=1
MDPS177 VDD VDD VDD VDD pfet_03v3 L=2u W=0.5u nf=1
MDPS178 VDD VDD VDD VDD pfet_03v3 L=2u W=0.5u nf=1
MDPS179 VDD VDD VDD VDD pfet_03v3 L=2u W=0.5u nf=1
MDPS180 VDD VDD VDD VDD pfet_03v3 L=2u W=0.5u nf=1
MDPS181 VDD VDD VDD VDD pfet_03v3 L=2u W=0.5u nf=1
MDPS182 VDD VDD VDD VDD pfet_03v3 L=2u W=0.5u nf=1
MDPS183 VDD VDD VDD VDD pfet_03v3 L=2u W=0.5u nf=1
MDPS184 VDD VDD VDD VDD pfet_03v3 L=2u W=0.5u nf=1
MDPS185 VDD VDD VDD VDD pfet_03v3 L=2u W=0.5u nf=1
MDPS186 VDD VDD VDD VDD pfet_03v3 L=2u W=0.5u nf=1
MDPS187 VDD VDD VDD VDD pfet_03v3 L=2u W=0.5u nf=1
MDPS188 VDD VDD VDD VDD pfet_03v3 L=2u W=0.5u nf=1
MDPS189 VDD VDD VDD VDD pfet_03v3 L=2u W=0.5u nf=1
MDPS190 VDD VDD VDD VDD pfet_03v3 L=2u W=0.5u nf=1
MDPS191 VDD VDD VDD VDD pfet_03v3 L=2u W=0.5u nf=1
MDPS192 VDD VDD VDD VDD pfet_03v3 L=2u W=0.5u nf=1
MDPS193 VDD VDD VDD VDD pfet_03v3 L=2u W=0.5u nf=1
MDPS194 VDD VDD VDD VDD pfet_03v3 L=2u W=0.5u nf=1
MDPS195 VDD VDD VDD VDD pfet_03v3 L=2u W=0.5u nf=1
MDPS196 VDD VDD VDD VDD pfet_03v3 L=2u W=0.5u nf=1
MDPS197 VDD VDD VDD VDD pfet_03v3 L=2u W=0.5u nf=1
MDPS198 VDD VDD VDD VDD pfet_03v3 L=2u W=0.5u nf=1
MDPS199 VDD VDD VDD VDD pfet_03v3 L=2u W=0.5u nf=1
MDPS200 VDD VDD VDD VDD pfet_03v3 L=2u W=0.5u nf=1
MDPS201 VDD VDD VDD VDD pfet_03v3 L=2u W=0.5u nf=1
MDPS202 VDD VDD VDD VDD pfet_03v3 L=2u W=0.5u nf=1
MDPS203 VDD VDD VDD VDD pfet_03v3 L=2u W=0.5u nf=1
MDPS204 VDD VDD VDD VDD pfet_03v3 L=2u W=0.5u nf=1
MDPS205 VDD VDD VDD VDD pfet_03v3 L=2u W=0.5u nf=1
MDPS206 VDD VDD VDD VDD pfet_03v3 L=2u W=0.5u nf=1
MDPS207 VDD VDD VDD VDD pfet_03v3 L=2u W=0.5u nf=1
MDPS208 VDD VDD VDD VDD pfet_03v3 L=2u W=0.5u nf=1
MDPS209 VDD VDD VDD VDD pfet_03v3 L=2u W=0.5u nf=1
MDPS210 VDD VDD VDD VDD pfet_03v3 L=2u W=0.5u nf=1
MDPW0 VDD VDD VDD VDD pfet_03v3 L=2u W=1u nf=1
MDPE0 VDD VDD VDD VDD pfet_03v3 L=2u W=1u nf=1
.ends
