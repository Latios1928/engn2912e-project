* LVS reference for bias_master.gds (glayout_floorplan.two_row)
* note: R: 2 x 585.38 um n-well resistor drawn as 12 bars in series (48.79, 48.79, 48.78, 48.78, 48.78, 48.78, 48.78, 48.78, 48.78, 48.78, 48.78, 48.78 um; joints R_j<k>)
* note: M3: m=4 x nf=1 -> nf=4, m=1 (parallel copies as fingers)
* note: M4: m=4 x nf=1 -> nf=4, m=1 (parallel copies as fingers)
* note: M2: m=64 x nf=1 -> nf=64, m=1 (parallel copies as fingers)
* note: M1: m=8 x nf=1 -> nf=8, m=1 (parallel copies as fingers)
* note: MS2: m=16 x nf=1 -> nf=16, m=1 (parallel copies as fingers)
* note: MREF: m=4 x nf=1 -> nf=4, m=1 (parallel copies as fingers)
* note: G2 common-centroid, 28 units: C B C A C B C C B C A C B C C B C A C B C C B C A C B C (A=MREF x4, B=M1 x8, C=MS2 x16)
.subckt bias_master VDD VSS Iref
XMS2_u0 X Vgn VSS VSS nfet_03v3 L=6u W=1u nf=1
XM1_u0 Vgn Vgn VSS VSS nfet_03v3 L=6u W=1u nf=1
XMS2_u1 X Vgn VSS VSS nfet_03v3 L=6u W=1u nf=1
XMREF_u0 Iref Vgn VSS VSS nfet_03v3 L=6u W=1u nf=1
XMS2_u2 X Vgn VSS VSS nfet_03v3 L=6u W=1u nf=1
XM1_u1 Vgn Vgn VSS VSS nfet_03v3 L=6u W=1u nf=1
XMS2_u3 X Vgn VSS VSS nfet_03v3 L=6u W=1u nf=1
XMS2_u4 X Vgn VSS VSS nfet_03v3 L=6u W=1u nf=1
XM1_u2 Vgn Vgn VSS VSS nfet_03v3 L=6u W=1u nf=1
XMS2_u5 X Vgn VSS VSS nfet_03v3 L=6u W=1u nf=1
XMREF_u1 Iref Vgn VSS VSS nfet_03v3 L=6u W=1u nf=1
XMS2_u6 X Vgn VSS VSS nfet_03v3 L=6u W=1u nf=1
XM1_u3 Vgn Vgn VSS VSS nfet_03v3 L=6u W=1u nf=1
XMS2_u7 X Vgn VSS VSS nfet_03v3 L=6u W=1u nf=1
XMS2_u8 X Vgn VSS VSS nfet_03v3 L=6u W=1u nf=1
XM1_u4 Vgn Vgn VSS VSS nfet_03v3 L=6u W=1u nf=1
XMS2_u9 X Vgn VSS VSS nfet_03v3 L=6u W=1u nf=1
XMREF_u2 Iref Vgn VSS VSS nfet_03v3 L=6u W=1u nf=1
XMS2_u10 X Vgn VSS VSS nfet_03v3 L=6u W=1u nf=1
XM1_u5 Vgn Vgn VSS VSS nfet_03v3 L=6u W=1u nf=1
XMS2_u11 X Vgn VSS VSS nfet_03v3 L=6u W=1u nf=1
XMS2_u12 X Vgn VSS VSS nfet_03v3 L=6u W=1u nf=1
XM1_u6 Vgn Vgn VSS VSS nfet_03v3 L=6u W=1u nf=1
XMS2_u13 X Vgn VSS VSS nfet_03v3 L=6u W=1u nf=1
XMREF_u3 Iref Vgn VSS VSS nfet_03v3 L=6u W=1u nf=1
XMS2_u14 X Vgn VSS VSS nfet_03v3 L=6u W=1u nf=1
XM1_u7 Vgn Vgn VSS VSS nfet_03v3 L=6u W=1u nf=1
XMS2_u15 X Vgn VSS VSS nfet_03v3 L=6u W=1u nf=1
XM2_f0 Vgp Vgn Vr VSS nfet_03v3 L=6u W=1u nf=1
XM2_f1 Vgp Vgn Vr VSS nfet_03v3 L=6u W=1u nf=1
XM2_f2 Vgp Vgn Vr VSS nfet_03v3 L=6u W=1u nf=1
XM2_f3 Vgp Vgn Vr VSS nfet_03v3 L=6u W=1u nf=1
XM2_f4 Vgp Vgn Vr VSS nfet_03v3 L=6u W=1u nf=1
XM2_f5 Vgp Vgn Vr VSS nfet_03v3 L=6u W=1u nf=1
XM2_f6 Vgp Vgn Vr VSS nfet_03v3 L=6u W=1u nf=1
XM2_f7 Vgp Vgn Vr VSS nfet_03v3 L=6u W=1u nf=1
XM2_f8 Vgp Vgn Vr VSS nfet_03v3 L=6u W=1u nf=1
XM2_f9 Vgp Vgn Vr VSS nfet_03v3 L=6u W=1u nf=1
XM2_f10 Vgp Vgn Vr VSS nfet_03v3 L=6u W=1u nf=1
XM2_f11 Vgp Vgn Vr VSS nfet_03v3 L=6u W=1u nf=1
XM2_f12 Vgp Vgn Vr VSS nfet_03v3 L=6u W=1u nf=1
XM2_f13 Vgp Vgn Vr VSS nfet_03v3 L=6u W=1u nf=1
XM2_f14 Vgp Vgn Vr VSS nfet_03v3 L=6u W=1u nf=1
XM2_f15 Vgp Vgn Vr VSS nfet_03v3 L=6u W=1u nf=1
XM2_f16 Vgp Vgn Vr VSS nfet_03v3 L=6u W=1u nf=1
XM2_f17 Vgp Vgn Vr VSS nfet_03v3 L=6u W=1u nf=1
XM2_f18 Vgp Vgn Vr VSS nfet_03v3 L=6u W=1u nf=1
XM2_f19 Vgp Vgn Vr VSS nfet_03v3 L=6u W=1u nf=1
XM2_f20 Vgp Vgn Vr VSS nfet_03v3 L=6u W=1u nf=1
XM2_f21 Vgp Vgn Vr VSS nfet_03v3 L=6u W=1u nf=1
XM2_f22 Vgp Vgn Vr VSS nfet_03v3 L=6u W=1u nf=1
XM2_f23 Vgp Vgn Vr VSS nfet_03v3 L=6u W=1u nf=1
XM2_f24 Vgp Vgn Vr VSS nfet_03v3 L=6u W=1u nf=1
XM2_f25 Vgp Vgn Vr VSS nfet_03v3 L=6u W=1u nf=1
XM2_f26 Vgp Vgn Vr VSS nfet_03v3 L=6u W=1u nf=1
XM2_f27 Vgp Vgn Vr VSS nfet_03v3 L=6u W=1u nf=1
XM2_f28 Vgp Vgn Vr VSS nfet_03v3 L=6u W=1u nf=1
XM2_f29 Vgp Vgn Vr VSS nfet_03v3 L=6u W=1u nf=1
XM2_f30 Vgp Vgn Vr VSS nfet_03v3 L=6u W=1u nf=1
XM2_f31 Vgp Vgn Vr VSS nfet_03v3 L=6u W=1u nf=1
XM2_f32 Vgp Vgn Vr VSS nfet_03v3 L=6u W=1u nf=1
XM2_f33 Vgp Vgn Vr VSS nfet_03v3 L=6u W=1u nf=1
XM2_f34 Vgp Vgn Vr VSS nfet_03v3 L=6u W=1u nf=1
XM2_f35 Vgp Vgn Vr VSS nfet_03v3 L=6u W=1u nf=1
XM2_f36 Vgp Vgn Vr VSS nfet_03v3 L=6u W=1u nf=1
XM2_f37 Vgp Vgn Vr VSS nfet_03v3 L=6u W=1u nf=1
XM2_f38 Vgp Vgn Vr VSS nfet_03v3 L=6u W=1u nf=1
XM2_f39 Vgp Vgn Vr VSS nfet_03v3 L=6u W=1u nf=1
XM2_f40 Vgp Vgn Vr VSS nfet_03v3 L=6u W=1u nf=1
XM2_f41 Vgp Vgn Vr VSS nfet_03v3 L=6u W=1u nf=1
XM2_f42 Vgp Vgn Vr VSS nfet_03v3 L=6u W=1u nf=1
XM2_f43 Vgp Vgn Vr VSS nfet_03v3 L=6u W=1u nf=1
XM2_f44 Vgp Vgn Vr VSS nfet_03v3 L=6u W=1u nf=1
XM2_f45 Vgp Vgn Vr VSS nfet_03v3 L=6u W=1u nf=1
XM2_f46 Vgp Vgn Vr VSS nfet_03v3 L=6u W=1u nf=1
XM2_f47 Vgp Vgn Vr VSS nfet_03v3 L=6u W=1u nf=1
XM2_f48 Vgp Vgn Vr VSS nfet_03v3 L=6u W=1u nf=1
XM2_f49 Vgp Vgn Vr VSS nfet_03v3 L=6u W=1u nf=1
XM2_f50 Vgp Vgn Vr VSS nfet_03v3 L=6u W=1u nf=1
XM2_f51 Vgp Vgn Vr VSS nfet_03v3 L=6u W=1u nf=1
XM2_f52 Vgp Vgn Vr VSS nfet_03v3 L=6u W=1u nf=1
XM2_f53 Vgp Vgn Vr VSS nfet_03v3 L=6u W=1u nf=1
XM2_f54 Vgp Vgn Vr VSS nfet_03v3 L=6u W=1u nf=1
XM2_f55 Vgp Vgn Vr VSS nfet_03v3 L=6u W=1u nf=1
XM2_f56 Vgp Vgn Vr VSS nfet_03v3 L=6u W=1u nf=1
XM2_f57 Vgp Vgn Vr VSS nfet_03v3 L=6u W=1u nf=1
XM2_f58 Vgp Vgn Vr VSS nfet_03v3 L=6u W=1u nf=1
XM2_f59 Vgp Vgn Vr VSS nfet_03v3 L=6u W=1u nf=1
XM2_f60 Vgp Vgn Vr VSS nfet_03v3 L=6u W=1u nf=1
XM2_f61 Vgp Vgn Vr VSS nfet_03v3 L=6u W=1u nf=1
XM2_f62 Vgp Vgn Vr VSS nfet_03v3 L=6u W=1u nf=1
XM2_f63 Vgp Vgn Vr VSS nfet_03v3 L=6u W=1u nf=1
XMS3 Vgp X VSS VSS nfet_03v3 L=4u W=0.5u nf=1
XM3_f0 Vgp Vgp VDD VDD pfet_03v3 L=6u W=1u nf=1
XM3_f1 Vgp Vgp VDD VDD pfet_03v3 L=6u W=1u nf=1
XM3_f2 Vgp Vgp VDD VDD pfet_03v3 L=6u W=1u nf=1
XM3_f3 Vgp Vgp VDD VDD pfet_03v3 L=6u W=1u nf=1
XM4_f0 Vgn Vgp VDD VDD pfet_03v3 L=6u W=1u nf=1
XM4_f1 Vgn Vgp VDD VDD pfet_03v3 L=6u W=1u nf=1
XM4_f2 Vgn Vgp VDD VDD pfet_03v3 L=6u W=1u nf=1
XM4_f3 Vgn Vgp VDD VDD pfet_03v3 L=6u W=1u nf=1
XMS1_0 net1 VSS VDD VDD pfet_03v3 L=45.45u W=0.5u nf=1
XMS1_1 net2 VSS net1 VDD pfet_03v3 L=45.45u W=0.5u nf=1
XMS1_2 net3 VSS net2 VDD pfet_03v3 L=45.45u W=0.5u nf=1
XMS1_3 s4 VSS net3 VDD pfet_03v3 L=45.45u W=0.5u nf=1
XMS1_4 net4 VSS s4 VDD pfet_03v3 L=45.45u W=0.5u nf=1
XMS1_5 net5 VSS net4 VDD pfet_03v3 L=45.45u W=0.5u nf=1
XMS1_6 net6 VSS net5 VDD pfet_03v3 L=45.45u W=0.5u nf=1
XMS1_7 net7 VSS net6 VDD pfet_03v3 L=45.45u W=0.5u nf=1
XMS1_8 net8 VSS net7 VDD pfet_03v3 L=45.45u W=0.5u nf=1
XMS1_9 X VSS net8 VDD pfet_03v3 L=45.45u W=0.5u nf=1
XR_s0 VSS R_j0 VSS nwell r_width=2e-6 r_length=48.79e-6
XR_s1 R_j0 R_j1 VSS nwell r_width=2e-6 r_length=48.79e-6
XR_s2 R_j1 R_j2 VSS nwell r_width=2e-6 r_length=48.78e-6
XR_s3 R_j2 R_j3 VSS nwell r_width=2e-6 r_length=48.78e-6
XR_s4 R_j3 R_j4 VSS nwell r_width=2e-6 r_length=48.78e-6
XR_s5 R_j4 R_j5 VSS nwell r_width=2e-6 r_length=48.78e-6
XR_s6 R_j5 R_j6 VSS nwell r_width=2e-6 r_length=48.78e-6
XR_s7 R_j6 R_j7 VSS nwell r_width=2e-6 r_length=48.78e-6
XR_s8 R_j7 R_j8 VSS nwell r_width=2e-6 r_length=48.78e-6
XR_s9 R_j8 R_j9 VSS nwell r_width=2e-6 r_length=48.78e-6
XR_s10 R_j9 R_j10 VSS nwell r_width=2e-6 r_length=48.78e-6
XR_s11 R_j10 Vr VSS nwell r_width=2e-6 r_length=48.78e-6
XDNN0 VSS VSS VSS VSS nfet_03v3 L=2u W=0.5u nf=1
XDNN1 VSS VSS VSS VSS nfet_03v3 L=2u W=0.5u nf=1
XDNN2 VSS VSS VSS VSS nfet_03v3 L=2u W=0.5u nf=1
XDNN3 VSS VSS VSS VSS nfet_03v3 L=2u W=0.5u nf=1
XDNN4 VSS VSS VSS VSS nfet_03v3 L=2u W=0.5u nf=1
XDNN5 VSS VSS VSS VSS nfet_03v3 L=2u W=0.5u nf=1
XDNN6 VSS VSS VSS VSS nfet_03v3 L=2u W=0.5u nf=1
XDNN7 VSS VSS VSS VSS nfet_03v3 L=2u W=0.5u nf=1
XDNN8 VSS VSS VSS VSS nfet_03v3 L=2u W=0.5u nf=1
XDNN9 VSS VSS VSS VSS nfet_03v3 L=2u W=0.5u nf=1
XDNN10 VSS VSS VSS VSS nfet_03v3 L=2u W=0.5u nf=1
XDNN11 VSS VSS VSS VSS nfet_03v3 L=2u W=0.5u nf=1
XDNN12 VSS VSS VSS VSS nfet_03v3 L=2u W=0.5u nf=1
XDNN13 VSS VSS VSS VSS nfet_03v3 L=2u W=0.5u nf=1
XDNN14 VSS VSS VSS VSS nfet_03v3 L=2u W=0.5u nf=1
XDNN15 VSS VSS VSS VSS nfet_03v3 L=2u W=0.5u nf=1
XDNN16 VSS VSS VSS VSS nfet_03v3 L=2u W=0.5u nf=1
XDNN17 VSS VSS VSS VSS nfet_03v3 L=2u W=0.5u nf=1
XDNN18 VSS VSS VSS VSS nfet_03v3 L=2u W=0.5u nf=1
XDNN19 VSS VSS VSS VSS nfet_03v3 L=2u W=0.5u nf=1
XDNN20 VSS VSS VSS VSS nfet_03v3 L=2u W=0.5u nf=1
XDNN21 VSS VSS VSS VSS nfet_03v3 L=2u W=0.5u nf=1
XDNN22 VSS VSS VSS VSS nfet_03v3 L=2u W=0.5u nf=1
XDNN23 VSS VSS VSS VSS nfet_03v3 L=2u W=0.5u nf=1
XDNN24 VSS VSS VSS VSS nfet_03v3 L=2u W=0.5u nf=1
XDNN25 VSS VSS VSS VSS nfet_03v3 L=2u W=0.5u nf=1
XDNN26 VSS VSS VSS VSS nfet_03v3 L=2u W=0.5u nf=1
XDNN27 VSS VSS VSS VSS nfet_03v3 L=2u W=0.5u nf=1
XDNN28 VSS VSS VSS VSS nfet_03v3 L=2u W=0.5u nf=1
XDNN29 VSS VSS VSS VSS nfet_03v3 L=2u W=0.5u nf=1
XDNN30 VSS VSS VSS VSS nfet_03v3 L=2u W=0.5u nf=1
XDNN31 VSS VSS VSS VSS nfet_03v3 L=2u W=0.5u nf=1
XDNN32 VSS VSS VSS VSS nfet_03v3 L=2u W=0.5u nf=1
XDNN33 VSS VSS VSS VSS nfet_03v3 L=2u W=0.5u nf=1
XDNN34 VSS VSS VSS VSS nfet_03v3 L=2u W=0.5u nf=1
XDNN35 VSS VSS VSS VSS nfet_03v3 L=2u W=0.5u nf=1
XDNN36 VSS VSS VSS VSS nfet_03v3 L=2u W=0.5u nf=1
XDNN37 VSS VSS VSS VSS nfet_03v3 L=2u W=0.5u nf=1
XDNN38 VSS VSS VSS VSS nfet_03v3 L=2u W=0.5u nf=1
XDNN39 VSS VSS VSS VSS nfet_03v3 L=2u W=0.5u nf=1
XDNN40 VSS VSS VSS VSS nfet_03v3 L=2u W=0.5u nf=1
XDNN41 VSS VSS VSS VSS nfet_03v3 L=2u W=0.5u nf=1
XDNN42 VSS VSS VSS VSS nfet_03v3 L=2u W=0.5u nf=1
XDNN43 VSS VSS VSS VSS nfet_03v3 L=2u W=0.5u nf=1
XDNN44 VSS VSS VSS VSS nfet_03v3 L=2u W=0.5u nf=1
XDNN45 VSS VSS VSS VSS nfet_03v3 L=2u W=0.5u nf=1
XDNN46 VSS VSS VSS VSS nfet_03v3 L=2u W=0.5u nf=1
XDNN47 VSS VSS VSS VSS nfet_03v3 L=2u W=0.5u nf=1
XDNN48 VSS VSS VSS VSS nfet_03v3 L=2u W=0.5u nf=1
XDNN49 VSS VSS VSS VSS nfet_03v3 L=2u W=0.5u nf=1
XDNN50 VSS VSS VSS VSS nfet_03v3 L=2u W=0.5u nf=1
XDNN51 VSS VSS VSS VSS nfet_03v3 L=2u W=0.5u nf=1
XDNN52 VSS VSS VSS VSS nfet_03v3 L=2u W=0.5u nf=1
XDNN53 VSS VSS VSS VSS nfet_03v3 L=2u W=0.5u nf=1
XDNN54 VSS VSS VSS VSS nfet_03v3 L=2u W=0.5u nf=1
XDNN55 VSS VSS VSS VSS nfet_03v3 L=2u W=0.5u nf=1
XDNN56 VSS VSS VSS VSS nfet_03v3 L=2u W=0.5u nf=1
XDNN57 VSS VSS VSS VSS nfet_03v3 L=2u W=0.5u nf=1
XDNN58 VSS VSS VSS VSS nfet_03v3 L=2u W=0.5u nf=1
XDNN59 VSS VSS VSS VSS nfet_03v3 L=2u W=0.5u nf=1
XDNN60 VSS VSS VSS VSS nfet_03v3 L=2u W=0.5u nf=1
XDNN61 VSS VSS VSS VSS nfet_03v3 L=2u W=0.5u nf=1
XDNN62 VSS VSS VSS VSS nfet_03v3 L=2u W=0.5u nf=1
XDNN63 VSS VSS VSS VSS nfet_03v3 L=2u W=0.5u nf=1
XDNN64 VSS VSS VSS VSS nfet_03v3 L=2u W=0.5u nf=1
XDNN65 VSS VSS VSS VSS nfet_03v3 L=2u W=0.5u nf=1
XDNN66 VSS VSS VSS VSS nfet_03v3 L=2u W=0.5u nf=1
XDNN67 VSS VSS VSS VSS nfet_03v3 L=2u W=0.5u nf=1
XDNN68 VSS VSS VSS VSS nfet_03v3 L=2u W=0.5u nf=1
XDNN69 VSS VSS VSS VSS nfet_03v3 L=2u W=0.5u nf=1
XDNN70 VSS VSS VSS VSS nfet_03v3 L=2u W=0.5u nf=1
XDNN71 VSS VSS VSS VSS nfet_03v3 L=2u W=0.5u nf=1
XDNN72 VSS VSS VSS VSS nfet_03v3 L=2u W=0.5u nf=1
XDNN73 VSS VSS VSS VSS nfet_03v3 L=2u W=0.5u nf=1
XDNN74 VSS VSS VSS VSS nfet_03v3 L=2u W=0.5u nf=1
XDNN75 VSS VSS VSS VSS nfet_03v3 L=2u W=0.5u nf=1
XDNN76 VSS VSS VSS VSS nfet_03v3 L=2u W=0.5u nf=1
XDNN77 VSS VSS VSS VSS nfet_03v3 L=2u W=0.5u nf=1
XDNN78 VSS VSS VSS VSS nfet_03v3 L=2u W=0.5u nf=1
XDNN79 VSS VSS VSS VSS nfet_03v3 L=2u W=0.5u nf=1
XDNN80 VSS VSS VSS VSS nfet_03v3 L=2u W=0.5u nf=1
XDNN81 VSS VSS VSS VSS nfet_03v3 L=2u W=0.5u nf=1
XDNN82 VSS VSS VSS VSS nfet_03v3 L=2u W=0.5u nf=1
XDNN83 VSS VSS VSS VSS nfet_03v3 L=2u W=0.5u nf=1
XDNN84 VSS VSS VSS VSS nfet_03v3 L=2u W=0.5u nf=1
XDNN85 VSS VSS VSS VSS nfet_03v3 L=2u W=0.5u nf=1
XDNN86 VSS VSS VSS VSS nfet_03v3 L=2u W=0.5u nf=1
XDNN87 VSS VSS VSS VSS nfet_03v3 L=2u W=0.5u nf=1
XDNN88 VSS VSS VSS VSS nfet_03v3 L=2u W=0.5u nf=1
XDNN89 VSS VSS VSS VSS nfet_03v3 L=2u W=0.5u nf=1
XDNN90 VSS VSS VSS VSS nfet_03v3 L=2u W=0.5u nf=1
XDNN91 VSS VSS VSS VSS nfet_03v3 L=2u W=0.5u nf=1
XDNN92 VSS VSS VSS VSS nfet_03v3 L=2u W=0.5u nf=1
XDNN93 VSS VSS VSS VSS nfet_03v3 L=2u W=0.5u nf=1
XDNN94 VSS VSS VSS VSS nfet_03v3 L=2u W=0.5u nf=1
XDNN95 VSS VSS VSS VSS nfet_03v3 L=2u W=0.5u nf=1
XDNN96 VSS VSS VSS VSS nfet_03v3 L=2u W=0.5u nf=1
XDNN97 VSS VSS VSS VSS nfet_03v3 L=2u W=0.5u nf=1
XDNN98 VSS VSS VSS VSS nfet_03v3 L=2u W=0.5u nf=1
XDNN99 VSS VSS VSS VSS nfet_03v3 L=2u W=0.5u nf=1
XDNN100 VSS VSS VSS VSS nfet_03v3 L=2u W=0.5u nf=1
XDNN101 VSS VSS VSS VSS nfet_03v3 L=2u W=0.5u nf=1
XDNN102 VSS VSS VSS VSS nfet_03v3 L=2u W=0.5u nf=1
XDNN103 VSS VSS VSS VSS nfet_03v3 L=2u W=0.5u nf=1
XDNN104 VSS VSS VSS VSS nfet_03v3 L=2u W=0.5u nf=1
XDNN105 VSS VSS VSS VSS nfet_03v3 L=2u W=0.5u nf=1
XDNN106 VSS VSS VSS VSS nfet_03v3 L=2u W=0.5u nf=1
XDNN107 VSS VSS VSS VSS nfet_03v3 L=2u W=0.5u nf=1
XDNN108 VSS VSS VSS VSS nfet_03v3 L=2u W=0.5u nf=1
XDNN109 VSS VSS VSS VSS nfet_03v3 L=2u W=0.5u nf=1
XDNN110 VSS VSS VSS VSS nfet_03v3 L=2u W=0.5u nf=1
XDNN111 VSS VSS VSS VSS nfet_03v3 L=2u W=0.5u nf=1
XDNN112 VSS VSS VSS VSS nfet_03v3 L=2u W=0.5u nf=1
XDNN113 VSS VSS VSS VSS nfet_03v3 L=2u W=0.5u nf=1
XDNN114 VSS VSS VSS VSS nfet_03v3 L=2u W=0.5u nf=1
XDNN115 VSS VSS VSS VSS nfet_03v3 L=2u W=0.5u nf=1
XDNN116 VSS VSS VSS VSS nfet_03v3 L=2u W=0.5u nf=1
XDNN117 VSS VSS VSS VSS nfet_03v3 L=2u W=0.5u nf=1
XDNN118 VSS VSS VSS VSS nfet_03v3 L=2u W=0.5u nf=1
XDNN119 VSS VSS VSS VSS nfet_03v3 L=2u W=0.5u nf=1
XDNN120 VSS VSS VSS VSS nfet_03v3 L=2u W=0.5u nf=1
XDNN121 VSS VSS VSS VSS nfet_03v3 L=2u W=0.5u nf=1
XDNN122 VSS VSS VSS VSS nfet_03v3 L=2u W=0.5u nf=1
XDNN123 VSS VSS VSS VSS nfet_03v3 L=2u W=0.5u nf=1
XDNN124 VSS VSS VSS VSS nfet_03v3 L=2u W=0.5u nf=1
XDNN125 VSS VSS VSS VSS nfet_03v3 L=2u W=0.5u nf=1
XDNN126 VSS VSS VSS VSS nfet_03v3 L=2u W=0.5u nf=1
XDNN127 VSS VSS VSS VSS nfet_03v3 L=2u W=0.5u nf=1
XDNN128 VSS VSS VSS VSS nfet_03v3 L=2u W=0.5u nf=1
XDNN129 VSS VSS VSS VSS nfet_03v3 L=2u W=0.5u nf=1
XDNN130 VSS VSS VSS VSS nfet_03v3 L=2u W=0.5u nf=1
XDNN131 VSS VSS VSS VSS nfet_03v3 L=2u W=0.5u nf=1
XDNN132 VSS VSS VSS VSS nfet_03v3 L=2u W=0.5u nf=1
XDNN133 VSS VSS VSS VSS nfet_03v3 L=2u W=0.5u nf=1
XDNN134 VSS VSS VSS VSS nfet_03v3 L=2u W=0.5u nf=1
XDNN135 VSS VSS VSS VSS nfet_03v3 L=2u W=0.5u nf=1
XDNN136 VSS VSS VSS VSS nfet_03v3 L=2u W=0.5u nf=1
XDNN137 VSS VSS VSS VSS nfet_03v3 L=2u W=0.5u nf=1
XDNN138 VSS VSS VSS VSS nfet_03v3 L=2u W=0.5u nf=1
XDNN139 VSS VSS VSS VSS nfet_03v3 L=2u W=0.5u nf=1
XDNN140 VSS VSS VSS VSS nfet_03v3 L=2u W=0.5u nf=1
XDNN141 VSS VSS VSS VSS nfet_03v3 L=2u W=0.5u nf=1
XDNN142 VSS VSS VSS VSS nfet_03v3 L=2u W=0.5u nf=1
XDNN143 VSS VSS VSS VSS nfet_03v3 L=2u W=0.5u nf=1
XDNN144 VSS VSS VSS VSS nfet_03v3 L=2u W=0.5u nf=1
XDNN145 VSS VSS VSS VSS nfet_03v3 L=2u W=0.5u nf=1
XDNN146 VSS VSS VSS VSS nfet_03v3 L=2u W=0.5u nf=1
XDNN147 VSS VSS VSS VSS nfet_03v3 L=2u W=0.5u nf=1
XDNN148 VSS VSS VSS VSS nfet_03v3 L=2u W=0.5u nf=1
XDNN149 VSS VSS VSS VSS nfet_03v3 L=2u W=0.5u nf=1
XDNN150 VSS VSS VSS VSS nfet_03v3 L=2u W=0.5u nf=1
XDNN151 VSS VSS VSS VSS nfet_03v3 L=2u W=0.5u nf=1
XDNN152 VSS VSS VSS VSS nfet_03v3 L=2u W=0.5u nf=1
XDNN153 VSS VSS VSS VSS nfet_03v3 L=2u W=0.5u nf=1
XDNN154 VSS VSS VSS VSS nfet_03v3 L=2u W=0.5u nf=1
XDNN155 VSS VSS VSS VSS nfet_03v3 L=2u W=0.5u nf=1
XDNN156 VSS VSS VSS VSS nfet_03v3 L=2u W=0.5u nf=1
XDNN157 VSS VSS VSS VSS nfet_03v3 L=2u W=0.5u nf=1
XDNN158 VSS VSS VSS VSS nfet_03v3 L=2u W=0.5u nf=1
XDNN159 VSS VSS VSS VSS nfet_03v3 L=2u W=0.5u nf=1
XDNN160 VSS VSS VSS VSS nfet_03v3 L=2u W=0.5u nf=1
XDNN161 VSS VSS VSS VSS nfet_03v3 L=2u W=0.5u nf=1
XDNN162 VSS VSS VSS VSS nfet_03v3 L=2u W=0.5u nf=1
XDNN163 VSS VSS VSS VSS nfet_03v3 L=2u W=0.5u nf=1
XDNN164 VSS VSS VSS VSS nfet_03v3 L=2u W=0.5u nf=1
XDNN165 VSS VSS VSS VSS nfet_03v3 L=2u W=0.5u nf=1
XDNN166 VSS VSS VSS VSS nfet_03v3 L=2u W=0.5u nf=1
XDNN167 VSS VSS VSS VSS nfet_03v3 L=2u W=0.5u nf=1
XDNN168 VSS VSS VSS VSS nfet_03v3 L=2u W=0.5u nf=1
XDNN169 VSS VSS VSS VSS nfet_03v3 L=2u W=0.5u nf=1
XDNN170 VSS VSS VSS VSS nfet_03v3 L=2u W=0.5u nf=1
XDNN171 VSS VSS VSS VSS nfet_03v3 L=2u W=0.5u nf=1
XDNN172 VSS VSS VSS VSS nfet_03v3 L=2u W=0.5u nf=1
XDNN173 VSS VSS VSS VSS nfet_03v3 L=2u W=0.5u nf=1
XDNN174 VSS VSS VSS VSS nfet_03v3 L=2u W=0.5u nf=1
XDNN175 VSS VSS VSS VSS nfet_03v3 L=2u W=0.5u nf=1
XDNN176 VSS VSS VSS VSS nfet_03v3 L=2u W=0.5u nf=1
XDNN177 VSS VSS VSS VSS nfet_03v3 L=2u W=0.5u nf=1
XDNN178 VSS VSS VSS VSS nfet_03v3 L=2u W=0.5u nf=1
XDNN179 VSS VSS VSS VSS nfet_03v3 L=2u W=0.5u nf=1
XDNN180 VSS VSS VSS VSS nfet_03v3 L=2u W=0.5u nf=1
XDNN181 VSS VSS VSS VSS nfet_03v3 L=2u W=0.5u nf=1
XDNN182 VSS VSS VSS VSS nfet_03v3 L=2u W=0.5u nf=1
XDNN183 VSS VSS VSS VSS nfet_03v3 L=2u W=0.5u nf=1
XDNN184 VSS VSS VSS VSS nfet_03v3 L=2u W=0.5u nf=1
XDNN185 VSS VSS VSS VSS nfet_03v3 L=2u W=0.5u nf=1
XDNN186 VSS VSS VSS VSS nfet_03v3 L=2u W=0.5u nf=1
XDNN187 VSS VSS VSS VSS nfet_03v3 L=2u W=0.5u nf=1
XDNN188 VSS VSS VSS VSS nfet_03v3 L=2u W=0.5u nf=1
XDNN189 VSS VSS VSS VSS nfet_03v3 L=2u W=0.5u nf=1
XDNN190 VSS VSS VSS VSS nfet_03v3 L=2u W=0.5u nf=1
XDNN191 VSS VSS VSS VSS nfet_03v3 L=2u W=0.5u nf=1
XDNN192 VSS VSS VSS VSS nfet_03v3 L=2u W=0.5u nf=1
XDNN193 VSS VSS VSS VSS nfet_03v3 L=2u W=0.5u nf=1
XDNN194 VSS VSS VSS VSS nfet_03v3 L=2u W=0.5u nf=1
XDNN195 VSS VSS VSS VSS nfet_03v3 L=2u W=0.5u nf=1
XDNN196 VSS VSS VSS VSS nfet_03v3 L=2u W=0.5u nf=1
XDNN197 VSS VSS VSS VSS nfet_03v3 L=2u W=0.5u nf=1
XDNN198 VSS VSS VSS VSS nfet_03v3 L=2u W=0.5u nf=1
XDNN199 VSS VSS VSS VSS nfet_03v3 L=2u W=0.5u nf=1
XDNN200 VSS VSS VSS VSS nfet_03v3 L=2u W=0.5u nf=1
XDNN201 VSS VSS VSS VSS nfet_03v3 L=2u W=0.5u nf=1
XDNN202 VSS VSS VSS VSS nfet_03v3 L=2u W=0.5u nf=1
XDNN203 VSS VSS VSS VSS nfet_03v3 L=2u W=0.5u nf=1
XDNN204 VSS VSS VSS VSS nfet_03v3 L=2u W=0.5u nf=1
XDNN205 VSS VSS VSS VSS nfet_03v3 L=2u W=0.5u nf=1
XDNN206 VSS VSS VSS VSS nfet_03v3 L=2u W=0.5u nf=1
XDNN207 VSS VSS VSS VSS nfet_03v3 L=2u W=0.5u nf=1
XDNN208 VSS VSS VSS VSS nfet_03v3 L=2u W=0.5u nf=1
XDNN209 VSS VSS VSS VSS nfet_03v3 L=2u W=0.5u nf=1
XDNN210 VSS VSS VSS VSS nfet_03v3 L=2u W=0.5u nf=1
XDNN211 VSS VSS VSS VSS nfet_03v3 L=2u W=0.5u nf=1
XDNN212 VSS VSS VSS VSS nfet_03v3 L=2u W=0.5u nf=1
XDNN213 VSS VSS VSS VSS nfet_03v3 L=2u W=0.5u nf=1
XDNN214 VSS VSS VSS VSS nfet_03v3 L=2u W=0.5u nf=1
XDNN215 VSS VSS VSS VSS nfet_03v3 L=2u W=0.5u nf=1
XDNN216 VSS VSS VSS VSS nfet_03v3 L=2u W=0.5u nf=1
XDNN217 VSS VSS VSS VSS nfet_03v3 L=2u W=0.5u nf=1
XDNN218 VSS VSS VSS VSS nfet_03v3 L=2u W=0.5u nf=1
XDNN219 VSS VSS VSS VSS nfet_03v3 L=2u W=0.5u nf=1
XDNN220 VSS VSS VSS VSS nfet_03v3 L=2u W=0.5u nf=1
XDNN221 VSS VSS VSS VSS nfet_03v3 L=2u W=0.5u nf=1
XDNN222 VSS VSS VSS VSS nfet_03v3 L=2u W=0.5u nf=1
XDNN223 VSS VSS VSS VSS nfet_03v3 L=2u W=0.5u nf=1
XDNN224 VSS VSS VSS VSS nfet_03v3 L=2u W=0.5u nf=1
XDNN225 VSS VSS VSS VSS nfet_03v3 L=2u W=0.5u nf=1
XDNN226 VSS VSS VSS VSS nfet_03v3 L=2u W=0.5u nf=1
XDNN227 VSS VSS VSS VSS nfet_03v3 L=2u W=0.5u nf=1
XDNN228 VSS VSS VSS VSS nfet_03v3 L=2u W=0.5u nf=1
XDNN229 VSS VSS VSS VSS nfet_03v3 L=2u W=0.5u nf=1
XDNN230 VSS VSS VSS VSS nfet_03v3 L=2u W=0.5u nf=1
XDNN231 VSS VSS VSS VSS nfet_03v3 L=2u W=0.5u nf=1
XDNN232 VSS VSS VSS VSS nfet_03v3 L=2u W=0.5u nf=1
XDNN233 VSS VSS VSS VSS nfet_03v3 L=2u W=0.5u nf=1
XDNN234 VSS VSS VSS VSS nfet_03v3 L=2u W=0.5u nf=1
XDNN235 VSS VSS VSS VSS nfet_03v3 L=2u W=0.5u nf=1
XDNN236 VSS VSS VSS VSS nfet_03v3 L=2u W=0.5u nf=1
XDNN237 VSS VSS VSS VSS nfet_03v3 L=2u W=0.5u nf=1
XDNN238 VSS VSS VSS VSS nfet_03v3 L=2u W=0.5u nf=1
XDNN239 VSS VSS VSS VSS nfet_03v3 L=2u W=0.5u nf=1
XDNN240 VSS VSS VSS VSS nfet_03v3 L=2u W=0.5u nf=1
XDNN241 VSS VSS VSS VSS nfet_03v3 L=2u W=0.5u nf=1
XDNN242 VSS VSS VSS VSS nfet_03v3 L=2u W=0.5u nf=1
XDNN243 VSS VSS VSS VSS nfet_03v3 L=2u W=0.5u nf=1
XDNN244 VSS VSS VSS VSS nfet_03v3 L=2u W=0.5u nf=1
XDNN245 VSS VSS VSS VSS nfet_03v3 L=2u W=0.5u nf=1
XDNN246 VSS VSS VSS VSS nfet_03v3 L=2u W=0.5u nf=1
XDNN247 VSS VSS VSS VSS nfet_03v3 L=2u W=0.5u nf=1
XDNN248 VSS VSS VSS VSS nfet_03v3 L=2u W=0.5u nf=1
XDNN249 VSS VSS VSS VSS nfet_03v3 L=2u W=0.5u nf=1
XDNN250 VSS VSS VSS VSS nfet_03v3 L=2u W=0.5u nf=1
XDNN251 VSS VSS VSS VSS nfet_03v3 L=2u W=0.5u nf=1
XDNN252 VSS VSS VSS VSS nfet_03v3 L=2u W=0.5u nf=1
XDNN253 VSS VSS VSS VSS nfet_03v3 L=2u W=0.5u nf=1
XDNN254 VSS VSS VSS VSS nfet_03v3 L=2u W=0.5u nf=1
XDNN255 VSS VSS VSS VSS nfet_03v3 L=2u W=0.5u nf=1
XDNN256 VSS VSS VSS VSS nfet_03v3 L=2u W=0.5u nf=1
XDNN257 VSS VSS VSS VSS nfet_03v3 L=2u W=0.5u nf=1
XDNN258 VSS VSS VSS VSS nfet_03v3 L=2u W=0.5u nf=1
XDNN259 VSS VSS VSS VSS nfet_03v3 L=2u W=0.5u nf=1
XDNN260 VSS VSS VSS VSS nfet_03v3 L=2u W=0.5u nf=1
XDNN261 VSS VSS VSS VSS nfet_03v3 L=2u W=0.5u nf=1
XDNS0 VSS VSS VSS VSS nfet_03v3 L=2u W=0.5u nf=1
XDNS1 VSS VSS VSS VSS nfet_03v3 L=2u W=0.5u nf=1
XDNS2 VSS VSS VSS VSS nfet_03v3 L=2u W=0.5u nf=1
XDNS3 VSS VSS VSS VSS nfet_03v3 L=2u W=0.5u nf=1
XDNS4 VSS VSS VSS VSS nfet_03v3 L=2u W=0.5u nf=1
XDNS5 VSS VSS VSS VSS nfet_03v3 L=2u W=0.5u nf=1
XDNS6 VSS VSS VSS VSS nfet_03v3 L=2u W=0.5u nf=1
XDNS7 VSS VSS VSS VSS nfet_03v3 L=2u W=0.5u nf=1
XDNS8 VSS VSS VSS VSS nfet_03v3 L=2u W=0.5u nf=1
XDNS9 VSS VSS VSS VSS nfet_03v3 L=2u W=0.5u nf=1
XDNS10 VSS VSS VSS VSS nfet_03v3 L=2u W=0.5u nf=1
XDNS11 VSS VSS VSS VSS nfet_03v3 L=2u W=0.5u nf=1
XDNS12 VSS VSS VSS VSS nfet_03v3 L=2u W=0.5u nf=1
XDNS13 VSS VSS VSS VSS nfet_03v3 L=2u W=0.5u nf=1
XDNS14 VSS VSS VSS VSS nfet_03v3 L=2u W=0.5u nf=1
XDNS15 VSS VSS VSS VSS nfet_03v3 L=2u W=0.5u nf=1
XDNS16 VSS VSS VSS VSS nfet_03v3 L=2u W=0.5u nf=1
XDNS17 VSS VSS VSS VSS nfet_03v3 L=2u W=0.5u nf=1
XDNS18 VSS VSS VSS VSS nfet_03v3 L=2u W=0.5u nf=1
XDNS19 VSS VSS VSS VSS nfet_03v3 L=2u W=0.5u nf=1
XDNS20 VSS VSS VSS VSS nfet_03v3 L=2u W=0.5u nf=1
XDNS21 VSS VSS VSS VSS nfet_03v3 L=2u W=0.5u nf=1
XDNS22 VSS VSS VSS VSS nfet_03v3 L=2u W=0.5u nf=1
XDNS23 VSS VSS VSS VSS nfet_03v3 L=2u W=0.5u nf=1
XDNS24 VSS VSS VSS VSS nfet_03v3 L=2u W=0.5u nf=1
XDNS25 VSS VSS VSS VSS nfet_03v3 L=2u W=0.5u nf=1
XDNS26 VSS VSS VSS VSS nfet_03v3 L=2u W=0.5u nf=1
XDNS27 VSS VSS VSS VSS nfet_03v3 L=2u W=0.5u nf=1
XDNS28 VSS VSS VSS VSS nfet_03v3 L=2u W=0.5u nf=1
XDNS29 VSS VSS VSS VSS nfet_03v3 L=2u W=0.5u nf=1
XDNS30 VSS VSS VSS VSS nfet_03v3 L=2u W=0.5u nf=1
XDNS31 VSS VSS VSS VSS nfet_03v3 L=2u W=0.5u nf=1
XDNS32 VSS VSS VSS VSS nfet_03v3 L=2u W=0.5u nf=1
XDNS33 VSS VSS VSS VSS nfet_03v3 L=2u W=0.5u nf=1
XDNS34 VSS VSS VSS VSS nfet_03v3 L=2u W=0.5u nf=1
XDNS35 VSS VSS VSS VSS nfet_03v3 L=2u W=0.5u nf=1
XDNS36 VSS VSS VSS VSS nfet_03v3 L=2u W=0.5u nf=1
XDNS37 VSS VSS VSS VSS nfet_03v3 L=2u W=0.5u nf=1
XDNS38 VSS VSS VSS VSS nfet_03v3 L=2u W=0.5u nf=1
XDNS39 VSS VSS VSS VSS nfet_03v3 L=2u W=0.5u nf=1
XDNS40 VSS VSS VSS VSS nfet_03v3 L=2u W=0.5u nf=1
XDNS41 VSS VSS VSS VSS nfet_03v3 L=2u W=0.5u nf=1
XDNS42 VSS VSS VSS VSS nfet_03v3 L=2u W=0.5u nf=1
XDNS43 VSS VSS VSS VSS nfet_03v3 L=2u W=0.5u nf=1
XDNS44 VSS VSS VSS VSS nfet_03v3 L=2u W=0.5u nf=1
XDNS45 VSS VSS VSS VSS nfet_03v3 L=2u W=0.5u nf=1
XDNS46 VSS VSS VSS VSS nfet_03v3 L=2u W=0.5u nf=1
XDNS47 VSS VSS VSS VSS nfet_03v3 L=2u W=0.5u nf=1
XDNS48 VSS VSS VSS VSS nfet_03v3 L=2u W=0.5u nf=1
XDNS49 VSS VSS VSS VSS nfet_03v3 L=2u W=0.5u nf=1
XDNS50 VSS VSS VSS VSS nfet_03v3 L=2u W=0.5u nf=1
XDNS51 VSS VSS VSS VSS nfet_03v3 L=2u W=0.5u nf=1
XDNS52 VSS VSS VSS VSS nfet_03v3 L=2u W=0.5u nf=1
XDNS53 VSS VSS VSS VSS nfet_03v3 L=2u W=0.5u nf=1
XDNS54 VSS VSS VSS VSS nfet_03v3 L=2u W=0.5u nf=1
XDNS55 VSS VSS VSS VSS nfet_03v3 L=2u W=0.5u nf=1
XDNS56 VSS VSS VSS VSS nfet_03v3 L=2u W=0.5u nf=1
XDNS57 VSS VSS VSS VSS nfet_03v3 L=2u W=0.5u nf=1
XDNS58 VSS VSS VSS VSS nfet_03v3 L=2u W=0.5u nf=1
XDNS59 VSS VSS VSS VSS nfet_03v3 L=2u W=0.5u nf=1
XDNS60 VSS VSS VSS VSS nfet_03v3 L=2u W=0.5u nf=1
XDNS61 VSS VSS VSS VSS nfet_03v3 L=2u W=0.5u nf=1
XDNS62 VSS VSS VSS VSS nfet_03v3 L=2u W=0.5u nf=1
XDNS63 VSS VSS VSS VSS nfet_03v3 L=2u W=0.5u nf=1
XDNS64 VSS VSS VSS VSS nfet_03v3 L=2u W=0.5u nf=1
XDNS65 VSS VSS VSS VSS nfet_03v3 L=2u W=0.5u nf=1
XDNS66 VSS VSS VSS VSS nfet_03v3 L=2u W=0.5u nf=1
XDNS67 VSS VSS VSS VSS nfet_03v3 L=2u W=0.5u nf=1
XDNS68 VSS VSS VSS VSS nfet_03v3 L=2u W=0.5u nf=1
XDNS69 VSS VSS VSS VSS nfet_03v3 L=2u W=0.5u nf=1
XDNS70 VSS VSS VSS VSS nfet_03v3 L=2u W=0.5u nf=1
XDNS71 VSS VSS VSS VSS nfet_03v3 L=2u W=0.5u nf=1
XDNS72 VSS VSS VSS VSS nfet_03v3 L=2u W=0.5u nf=1
XDNS73 VSS VSS VSS VSS nfet_03v3 L=2u W=0.5u nf=1
XDNS74 VSS VSS VSS VSS nfet_03v3 L=2u W=0.5u nf=1
XDNS75 VSS VSS VSS VSS nfet_03v3 L=2u W=0.5u nf=1
XDNS76 VSS VSS VSS VSS nfet_03v3 L=2u W=0.5u nf=1
XDNS77 VSS VSS VSS VSS nfet_03v3 L=2u W=0.5u nf=1
XDNS78 VSS VSS VSS VSS nfet_03v3 L=2u W=0.5u nf=1
XDNS79 VSS VSS VSS VSS nfet_03v3 L=2u W=0.5u nf=1
XDNS80 VSS VSS VSS VSS nfet_03v3 L=2u W=0.5u nf=1
XDNS81 VSS VSS VSS VSS nfet_03v3 L=2u W=0.5u nf=1
XDNS82 VSS VSS VSS VSS nfet_03v3 L=2u W=0.5u nf=1
XDNS83 VSS VSS VSS VSS nfet_03v3 L=2u W=0.5u nf=1
XDNS84 VSS VSS VSS VSS nfet_03v3 L=2u W=0.5u nf=1
XDNS85 VSS VSS VSS VSS nfet_03v3 L=2u W=0.5u nf=1
XDNS86 VSS VSS VSS VSS nfet_03v3 L=2u W=0.5u nf=1
XDNS87 VSS VSS VSS VSS nfet_03v3 L=2u W=0.5u nf=1
XDNS88 VSS VSS VSS VSS nfet_03v3 L=2u W=0.5u nf=1
XDNS89 VSS VSS VSS VSS nfet_03v3 L=2u W=0.5u nf=1
XDNS90 VSS VSS VSS VSS nfet_03v3 L=2u W=0.5u nf=1
XDNS91 VSS VSS VSS VSS nfet_03v3 L=2u W=0.5u nf=1
XDNS92 VSS VSS VSS VSS nfet_03v3 L=2u W=0.5u nf=1
XDNS93 VSS VSS VSS VSS nfet_03v3 L=2u W=0.5u nf=1
XDNS94 VSS VSS VSS VSS nfet_03v3 L=2u W=0.5u nf=1
XDNS95 VSS VSS VSS VSS nfet_03v3 L=2u W=0.5u nf=1
XDNS96 VSS VSS VSS VSS nfet_03v3 L=2u W=0.5u nf=1
XDNS97 VSS VSS VSS VSS nfet_03v3 L=2u W=0.5u nf=1
XDNS98 VSS VSS VSS VSS nfet_03v3 L=2u W=0.5u nf=1
XDNS99 VSS VSS VSS VSS nfet_03v3 L=2u W=0.5u nf=1
XDNS100 VSS VSS VSS VSS nfet_03v3 L=2u W=0.5u nf=1
XDNS101 VSS VSS VSS VSS nfet_03v3 L=2u W=0.5u nf=1
XDNS102 VSS VSS VSS VSS nfet_03v3 L=2u W=0.5u nf=1
XDNS103 VSS VSS VSS VSS nfet_03v3 L=2u W=0.5u nf=1
XDNS104 VSS VSS VSS VSS nfet_03v3 L=2u W=0.5u nf=1
XDNS105 VSS VSS VSS VSS nfet_03v3 L=2u W=0.5u nf=1
XDNS106 VSS VSS VSS VSS nfet_03v3 L=2u W=0.5u nf=1
XDNS107 VSS VSS VSS VSS nfet_03v3 L=2u W=0.5u nf=1
XDNS108 VSS VSS VSS VSS nfet_03v3 L=2u W=0.5u nf=1
XDNS109 VSS VSS VSS VSS nfet_03v3 L=2u W=0.5u nf=1
XDNS110 VSS VSS VSS VSS nfet_03v3 L=2u W=0.5u nf=1
XDNS111 VSS VSS VSS VSS nfet_03v3 L=2u W=0.5u nf=1
XDNS112 VSS VSS VSS VSS nfet_03v3 L=2u W=0.5u nf=1
XDNS113 VSS VSS VSS VSS nfet_03v3 L=2u W=0.5u nf=1
XDNS114 VSS VSS VSS VSS nfet_03v3 L=2u W=0.5u nf=1
XDNS115 VSS VSS VSS VSS nfet_03v3 L=2u W=0.5u nf=1
XDNS116 VSS VSS VSS VSS nfet_03v3 L=2u W=0.5u nf=1
XDNS117 VSS VSS VSS VSS nfet_03v3 L=2u W=0.5u nf=1
XDNS118 VSS VSS VSS VSS nfet_03v3 L=2u W=0.5u nf=1
XDNS119 VSS VSS VSS VSS nfet_03v3 L=2u W=0.5u nf=1
XDNS120 VSS VSS VSS VSS nfet_03v3 L=2u W=0.5u nf=1
XDNS121 VSS VSS VSS VSS nfet_03v3 L=2u W=0.5u nf=1
XDNS122 VSS VSS VSS VSS nfet_03v3 L=2u W=0.5u nf=1
XDNS123 VSS VSS VSS VSS nfet_03v3 L=2u W=0.5u nf=1
XDNS124 VSS VSS VSS VSS nfet_03v3 L=2u W=0.5u nf=1
XDNS125 VSS VSS VSS VSS nfet_03v3 L=2u W=0.5u nf=1
XDNS126 VSS VSS VSS VSS nfet_03v3 L=2u W=0.5u nf=1
XDNS127 VSS VSS VSS VSS nfet_03v3 L=2u W=0.5u nf=1
XDNS128 VSS VSS VSS VSS nfet_03v3 L=2u W=0.5u nf=1
XDNS129 VSS VSS VSS VSS nfet_03v3 L=2u W=0.5u nf=1
XDNS130 VSS VSS VSS VSS nfet_03v3 L=2u W=0.5u nf=1
XDNS131 VSS VSS VSS VSS nfet_03v3 L=2u W=0.5u nf=1
XDNS132 VSS VSS VSS VSS nfet_03v3 L=2u W=0.5u nf=1
XDNS133 VSS VSS VSS VSS nfet_03v3 L=2u W=0.5u nf=1
XDNS134 VSS VSS VSS VSS nfet_03v3 L=2u W=0.5u nf=1
XDNS135 VSS VSS VSS VSS nfet_03v3 L=2u W=0.5u nf=1
XDNS136 VSS VSS VSS VSS nfet_03v3 L=2u W=0.5u nf=1
XDNS137 VSS VSS VSS VSS nfet_03v3 L=2u W=0.5u nf=1
XDNS138 VSS VSS VSS VSS nfet_03v3 L=2u W=0.5u nf=1
XDNS139 VSS VSS VSS VSS nfet_03v3 L=2u W=0.5u nf=1
XDNS140 VSS VSS VSS VSS nfet_03v3 L=2u W=0.5u nf=1
XDNS141 VSS VSS VSS VSS nfet_03v3 L=2u W=0.5u nf=1
XDNS142 VSS VSS VSS VSS nfet_03v3 L=2u W=0.5u nf=1
XDNS143 VSS VSS VSS VSS nfet_03v3 L=2u W=0.5u nf=1
XDNS144 VSS VSS VSS VSS nfet_03v3 L=2u W=0.5u nf=1
XDNS145 VSS VSS VSS VSS nfet_03v3 L=2u W=0.5u nf=1
XDNS146 VSS VSS VSS VSS nfet_03v3 L=2u W=0.5u nf=1
XDNS147 VSS VSS VSS VSS nfet_03v3 L=2u W=0.5u nf=1
XDNS148 VSS VSS VSS VSS nfet_03v3 L=2u W=0.5u nf=1
XDNS149 VSS VSS VSS VSS nfet_03v3 L=2u W=0.5u nf=1
XDNS150 VSS VSS VSS VSS nfet_03v3 L=2u W=0.5u nf=1
XDNS151 VSS VSS VSS VSS nfet_03v3 L=2u W=0.5u nf=1
XDNS152 VSS VSS VSS VSS nfet_03v3 L=2u W=0.5u nf=1
XDNS153 VSS VSS VSS VSS nfet_03v3 L=2u W=0.5u nf=1
XDNS154 VSS VSS VSS VSS nfet_03v3 L=2u W=0.5u nf=1
XDNS155 VSS VSS VSS VSS nfet_03v3 L=2u W=0.5u nf=1
XDNS156 VSS VSS VSS VSS nfet_03v3 L=2u W=0.5u nf=1
XDNS157 VSS VSS VSS VSS nfet_03v3 L=2u W=0.5u nf=1
XDNS158 VSS VSS VSS VSS nfet_03v3 L=2u W=0.5u nf=1
XDNS159 VSS VSS VSS VSS nfet_03v3 L=2u W=0.5u nf=1
XDNS160 VSS VSS VSS VSS nfet_03v3 L=2u W=0.5u nf=1
XDNS161 VSS VSS VSS VSS nfet_03v3 L=2u W=0.5u nf=1
XDNS162 VSS VSS VSS VSS nfet_03v3 L=2u W=0.5u nf=1
XDNS163 VSS VSS VSS VSS nfet_03v3 L=2u W=0.5u nf=1
XDNS164 VSS VSS VSS VSS nfet_03v3 L=2u W=0.5u nf=1
XDNS165 VSS VSS VSS VSS nfet_03v3 L=2u W=0.5u nf=1
XDNS166 VSS VSS VSS VSS nfet_03v3 L=2u W=0.5u nf=1
XDNS167 VSS VSS VSS VSS nfet_03v3 L=2u W=0.5u nf=1
XDNS168 VSS VSS VSS VSS nfet_03v3 L=2u W=0.5u nf=1
XDNS169 VSS VSS VSS VSS nfet_03v3 L=2u W=0.5u nf=1
XDNS170 VSS VSS VSS VSS nfet_03v3 L=2u W=0.5u nf=1
XDNS171 VSS VSS VSS VSS nfet_03v3 L=2u W=0.5u nf=1
XDNS172 VSS VSS VSS VSS nfet_03v3 L=2u W=0.5u nf=1
XDNS173 VSS VSS VSS VSS nfet_03v3 L=2u W=0.5u nf=1
XDNS174 VSS VSS VSS VSS nfet_03v3 L=2u W=0.5u nf=1
XDNS175 VSS VSS VSS VSS nfet_03v3 L=2u W=0.5u nf=1
XDNS176 VSS VSS VSS VSS nfet_03v3 L=2u W=0.5u nf=1
XDNS177 VSS VSS VSS VSS nfet_03v3 L=2u W=0.5u nf=1
XDNS178 VSS VSS VSS VSS nfet_03v3 L=2u W=0.5u nf=1
XDNS179 VSS VSS VSS VSS nfet_03v3 L=2u W=0.5u nf=1
XDNS180 VSS VSS VSS VSS nfet_03v3 L=2u W=0.5u nf=1
XDNS181 VSS VSS VSS VSS nfet_03v3 L=2u W=0.5u nf=1
XDNS182 VSS VSS VSS VSS nfet_03v3 L=2u W=0.5u nf=1
XDNS183 VSS VSS VSS VSS nfet_03v3 L=2u W=0.5u nf=1
XDNS184 VSS VSS VSS VSS nfet_03v3 L=2u W=0.5u nf=1
XDNS185 VSS VSS VSS VSS nfet_03v3 L=2u W=0.5u nf=1
XDNS186 VSS VSS VSS VSS nfet_03v3 L=2u W=0.5u nf=1
XDNS187 VSS VSS VSS VSS nfet_03v3 L=2u W=0.5u nf=1
XDNS188 VSS VSS VSS VSS nfet_03v3 L=2u W=0.5u nf=1
XDNS189 VSS VSS VSS VSS nfet_03v3 L=2u W=0.5u nf=1
XDNS190 VSS VSS VSS VSS nfet_03v3 L=2u W=0.5u nf=1
XDNS191 VSS VSS VSS VSS nfet_03v3 L=2u W=0.5u nf=1
XDNS192 VSS VSS VSS VSS nfet_03v3 L=2u W=0.5u nf=1
XDNS193 VSS VSS VSS VSS nfet_03v3 L=2u W=0.5u nf=1
XDNS194 VSS VSS VSS VSS nfet_03v3 L=2u W=0.5u nf=1
XDNS195 VSS VSS VSS VSS nfet_03v3 L=2u W=0.5u nf=1
XDNS196 VSS VSS VSS VSS nfet_03v3 L=2u W=0.5u nf=1
XDNS197 VSS VSS VSS VSS nfet_03v3 L=2u W=0.5u nf=1
XDNS198 VSS VSS VSS VSS nfet_03v3 L=2u W=0.5u nf=1
XDNS199 VSS VSS VSS VSS nfet_03v3 L=2u W=0.5u nf=1
XDNS200 VSS VSS VSS VSS nfet_03v3 L=2u W=0.5u nf=1
XDNS201 VSS VSS VSS VSS nfet_03v3 L=2u W=0.5u nf=1
XDNS202 VSS VSS VSS VSS nfet_03v3 L=2u W=0.5u nf=1
XDNS203 VSS VSS VSS VSS nfet_03v3 L=2u W=0.5u nf=1
XDNS204 VSS VSS VSS VSS nfet_03v3 L=2u W=0.5u nf=1
XDNS205 VSS VSS VSS VSS nfet_03v3 L=2u W=0.5u nf=1
XDNS206 VSS VSS VSS VSS nfet_03v3 L=2u W=0.5u nf=1
XDNS207 VSS VSS VSS VSS nfet_03v3 L=2u W=0.5u nf=1
XDNS208 VSS VSS VSS VSS nfet_03v3 L=2u W=0.5u nf=1
XDNS209 VSS VSS VSS VSS nfet_03v3 L=2u W=0.5u nf=1
XDNS210 VSS VSS VSS VSS nfet_03v3 L=2u W=0.5u nf=1
XDNS211 VSS VSS VSS VSS nfet_03v3 L=2u W=0.5u nf=1
XDNS212 VSS VSS VSS VSS nfet_03v3 L=2u W=0.5u nf=1
XDNS213 VSS VSS VSS VSS nfet_03v3 L=2u W=0.5u nf=1
XDNS214 VSS VSS VSS VSS nfet_03v3 L=2u W=0.5u nf=1
XDNS215 VSS VSS VSS VSS nfet_03v3 L=2u W=0.5u nf=1
XDNS216 VSS VSS VSS VSS nfet_03v3 L=2u W=0.5u nf=1
XDNS217 VSS VSS VSS VSS nfet_03v3 L=2u W=0.5u nf=1
XDNS218 VSS VSS VSS VSS nfet_03v3 L=2u W=0.5u nf=1
XDNS219 VSS VSS VSS VSS nfet_03v3 L=2u W=0.5u nf=1
XDNS220 VSS VSS VSS VSS nfet_03v3 L=2u W=0.5u nf=1
XDNS221 VSS VSS VSS VSS nfet_03v3 L=2u W=0.5u nf=1
XDNS222 VSS VSS VSS VSS nfet_03v3 L=2u W=0.5u nf=1
XDNS223 VSS VSS VSS VSS nfet_03v3 L=2u W=0.5u nf=1
XDNS224 VSS VSS VSS VSS nfet_03v3 L=2u W=0.5u nf=1
XDNS225 VSS VSS VSS VSS nfet_03v3 L=2u W=0.5u nf=1
XDNS226 VSS VSS VSS VSS nfet_03v3 L=2u W=0.5u nf=1
XDNS227 VSS VSS VSS VSS nfet_03v3 L=2u W=0.5u nf=1
XDNS228 VSS VSS VSS VSS nfet_03v3 L=2u W=0.5u nf=1
XDNS229 VSS VSS VSS VSS nfet_03v3 L=2u W=0.5u nf=1
XDNS230 VSS VSS VSS VSS nfet_03v3 L=2u W=0.5u nf=1
XDNS231 VSS VSS VSS VSS nfet_03v3 L=2u W=0.5u nf=1
XDNS232 VSS VSS VSS VSS nfet_03v3 L=2u W=0.5u nf=1
XDNS233 VSS VSS VSS VSS nfet_03v3 L=2u W=0.5u nf=1
XDNS234 VSS VSS VSS VSS nfet_03v3 L=2u W=0.5u nf=1
XDNS235 VSS VSS VSS VSS nfet_03v3 L=2u W=0.5u nf=1
XDNS236 VSS VSS VSS VSS nfet_03v3 L=2u W=0.5u nf=1
XDNS237 VSS VSS VSS VSS nfet_03v3 L=2u W=0.5u nf=1
XDNS238 VSS VSS VSS VSS nfet_03v3 L=2u W=0.5u nf=1
XDNS239 VSS VSS VSS VSS nfet_03v3 L=2u W=0.5u nf=1
XDNS240 VSS VSS VSS VSS nfet_03v3 L=2u W=0.5u nf=1
XDNS241 VSS VSS VSS VSS nfet_03v3 L=2u W=0.5u nf=1
XDNS242 VSS VSS VSS VSS nfet_03v3 L=2u W=0.5u nf=1
XDNS243 VSS VSS VSS VSS nfet_03v3 L=2u W=0.5u nf=1
XDNS244 VSS VSS VSS VSS nfet_03v3 L=2u W=0.5u nf=1
XDNS245 VSS VSS VSS VSS nfet_03v3 L=2u W=0.5u nf=1
XDNS246 VSS VSS VSS VSS nfet_03v3 L=2u W=0.5u nf=1
XDNS247 VSS VSS VSS VSS nfet_03v3 L=2u W=0.5u nf=1
XDNS248 VSS VSS VSS VSS nfet_03v3 L=2u W=0.5u nf=1
XDNS249 VSS VSS VSS VSS nfet_03v3 L=2u W=0.5u nf=1
XDNS250 VSS VSS VSS VSS nfet_03v3 L=2u W=0.5u nf=1
XDNS251 VSS VSS VSS VSS nfet_03v3 L=2u W=0.5u nf=1
XDNS252 VSS VSS VSS VSS nfet_03v3 L=2u W=0.5u nf=1
XDNS253 VSS VSS VSS VSS nfet_03v3 L=2u W=0.5u nf=1
XDNS254 VSS VSS VSS VSS nfet_03v3 L=2u W=0.5u nf=1
XDNS255 VSS VSS VSS VSS nfet_03v3 L=2u W=0.5u nf=1
XDNS256 VSS VSS VSS VSS nfet_03v3 L=2u W=0.5u nf=1
XDNS257 VSS VSS VSS VSS nfet_03v3 L=2u W=0.5u nf=1
XDNS258 VSS VSS VSS VSS nfet_03v3 L=2u W=0.5u nf=1
XDNS259 VSS VSS VSS VSS nfet_03v3 L=2u W=0.5u nf=1
XDNS260 VSS VSS VSS VSS nfet_03v3 L=2u W=0.5u nf=1
XDNS261 VSS VSS VSS VSS nfet_03v3 L=2u W=0.5u nf=1
XDNW0 VSS VSS VSS VSS nfet_03v3 L=2u W=1u nf=1
XDNE0 VSS VSS VSS VSS nfet_03v3 L=2u W=1u nf=1
XDPN0 VDD VDD VDD VDD pfet_03v3 L=2u W=0.5u nf=1
XDPN1 VDD VDD VDD VDD pfet_03v3 L=2u W=0.5u nf=1
XDPN2 VDD VDD VDD VDD pfet_03v3 L=2u W=0.5u nf=1
XDPN3 VDD VDD VDD VDD pfet_03v3 L=2u W=0.5u nf=1
XDPN4 VDD VDD VDD VDD pfet_03v3 L=2u W=0.5u nf=1
XDPN5 VDD VDD VDD VDD pfet_03v3 L=2u W=0.5u nf=1
XDPN6 VDD VDD VDD VDD pfet_03v3 L=2u W=0.5u nf=1
XDPN7 VDD VDD VDD VDD pfet_03v3 L=2u W=0.5u nf=1
XDPN8 VDD VDD VDD VDD pfet_03v3 L=2u W=0.5u nf=1
XDPN9 VDD VDD VDD VDD pfet_03v3 L=2u W=0.5u nf=1
XDPN10 VDD VDD VDD VDD pfet_03v3 L=2u W=0.5u nf=1
XDPN11 VDD VDD VDD VDD pfet_03v3 L=2u W=0.5u nf=1
XDPN12 VDD VDD VDD VDD pfet_03v3 L=2u W=0.5u nf=1
XDPN13 VDD VDD VDD VDD pfet_03v3 L=2u W=0.5u nf=1
XDPN14 VDD VDD VDD VDD pfet_03v3 L=2u W=0.5u nf=1
XDPN15 VDD VDD VDD VDD pfet_03v3 L=2u W=0.5u nf=1
XDPN16 VDD VDD VDD VDD pfet_03v3 L=2u W=0.5u nf=1
XDPN17 VDD VDD VDD VDD pfet_03v3 L=2u W=0.5u nf=1
XDPN18 VDD VDD VDD VDD pfet_03v3 L=2u W=0.5u nf=1
XDPN19 VDD VDD VDD VDD pfet_03v3 L=2u W=0.5u nf=1
XDPN20 VDD VDD VDD VDD pfet_03v3 L=2u W=0.5u nf=1
XDPN21 VDD VDD VDD VDD pfet_03v3 L=2u W=0.5u nf=1
XDPN22 VDD VDD VDD VDD pfet_03v3 L=2u W=0.5u nf=1
XDPN23 VDD VDD VDD VDD pfet_03v3 L=2u W=0.5u nf=1
XDPN24 VDD VDD VDD VDD pfet_03v3 L=2u W=0.5u nf=1
XDPN25 VDD VDD VDD VDD pfet_03v3 L=2u W=0.5u nf=1
XDPN26 VDD VDD VDD VDD pfet_03v3 L=2u W=0.5u nf=1
XDPN27 VDD VDD VDD VDD pfet_03v3 L=2u W=0.5u nf=1
XDPN28 VDD VDD VDD VDD pfet_03v3 L=2u W=0.5u nf=1
XDPN29 VDD VDD VDD VDD pfet_03v3 L=2u W=0.5u nf=1
XDPN30 VDD VDD VDD VDD pfet_03v3 L=2u W=0.5u nf=1
XDPN31 VDD VDD VDD VDD pfet_03v3 L=2u W=0.5u nf=1
XDPN32 VDD VDD VDD VDD pfet_03v3 L=2u W=0.5u nf=1
XDPN33 VDD VDD VDD VDD pfet_03v3 L=2u W=0.5u nf=1
XDPN34 VDD VDD VDD VDD pfet_03v3 L=2u W=0.5u nf=1
XDPN35 VDD VDD VDD VDD pfet_03v3 L=2u W=0.5u nf=1
XDPN36 VDD VDD VDD VDD pfet_03v3 L=2u W=0.5u nf=1
XDPN37 VDD VDD VDD VDD pfet_03v3 L=2u W=0.5u nf=1
XDPN38 VDD VDD VDD VDD pfet_03v3 L=2u W=0.5u nf=1
XDPN39 VDD VDD VDD VDD pfet_03v3 L=2u W=0.5u nf=1
XDPN40 VDD VDD VDD VDD pfet_03v3 L=2u W=0.5u nf=1
XDPN41 VDD VDD VDD VDD pfet_03v3 L=2u W=0.5u nf=1
XDPN42 VDD VDD VDD VDD pfet_03v3 L=2u W=0.5u nf=1
XDPN43 VDD VDD VDD VDD pfet_03v3 L=2u W=0.5u nf=1
XDPN44 VDD VDD VDD VDD pfet_03v3 L=2u W=0.5u nf=1
XDPN45 VDD VDD VDD VDD pfet_03v3 L=2u W=0.5u nf=1
XDPN46 VDD VDD VDD VDD pfet_03v3 L=2u W=0.5u nf=1
XDPN47 VDD VDD VDD VDD pfet_03v3 L=2u W=0.5u nf=1
XDPN48 VDD VDD VDD VDD pfet_03v3 L=2u W=0.5u nf=1
XDPN49 VDD VDD VDD VDD pfet_03v3 L=2u W=0.5u nf=1
XDPN50 VDD VDD VDD VDD pfet_03v3 L=2u W=0.5u nf=1
XDPN51 VDD VDD VDD VDD pfet_03v3 L=2u W=0.5u nf=1
XDPN52 VDD VDD VDD VDD pfet_03v3 L=2u W=0.5u nf=1
XDPN53 VDD VDD VDD VDD pfet_03v3 L=2u W=0.5u nf=1
XDPN54 VDD VDD VDD VDD pfet_03v3 L=2u W=0.5u nf=1
XDPN55 VDD VDD VDD VDD pfet_03v3 L=2u W=0.5u nf=1
XDPN56 VDD VDD VDD VDD pfet_03v3 L=2u W=0.5u nf=1
XDPN57 VDD VDD VDD VDD pfet_03v3 L=2u W=0.5u nf=1
XDPN58 VDD VDD VDD VDD pfet_03v3 L=2u W=0.5u nf=1
XDPN59 VDD VDD VDD VDD pfet_03v3 L=2u W=0.5u nf=1
XDPN60 VDD VDD VDD VDD pfet_03v3 L=2u W=0.5u nf=1
XDPN61 VDD VDD VDD VDD pfet_03v3 L=2u W=0.5u nf=1
XDPN62 VDD VDD VDD VDD pfet_03v3 L=2u W=0.5u nf=1
XDPN63 VDD VDD VDD VDD pfet_03v3 L=2u W=0.5u nf=1
XDPN64 VDD VDD VDD VDD pfet_03v3 L=2u W=0.5u nf=1
XDPN65 VDD VDD VDD VDD pfet_03v3 L=2u W=0.5u nf=1
XDPN66 VDD VDD VDD VDD pfet_03v3 L=2u W=0.5u nf=1
XDPN67 VDD VDD VDD VDD pfet_03v3 L=2u W=0.5u nf=1
XDPN68 VDD VDD VDD VDD pfet_03v3 L=2u W=0.5u nf=1
XDPN69 VDD VDD VDD VDD pfet_03v3 L=2u W=0.5u nf=1
XDPN70 VDD VDD VDD VDD pfet_03v3 L=2u W=0.5u nf=1
XDPN71 VDD VDD VDD VDD pfet_03v3 L=2u W=0.5u nf=1
XDPN72 VDD VDD VDD VDD pfet_03v3 L=2u W=0.5u nf=1
XDPN73 VDD VDD VDD VDD pfet_03v3 L=2u W=0.5u nf=1
XDPN74 VDD VDD VDD VDD pfet_03v3 L=2u W=0.5u nf=1
XDPN75 VDD VDD VDD VDD pfet_03v3 L=2u W=0.5u nf=1
XDPN76 VDD VDD VDD VDD pfet_03v3 L=2u W=0.5u nf=1
XDPN77 VDD VDD VDD VDD pfet_03v3 L=2u W=0.5u nf=1
XDPN78 VDD VDD VDD VDD pfet_03v3 L=2u W=0.5u nf=1
XDPN79 VDD VDD VDD VDD pfet_03v3 L=2u W=0.5u nf=1
XDPN80 VDD VDD VDD VDD pfet_03v3 L=2u W=0.5u nf=1
XDPN81 VDD VDD VDD VDD pfet_03v3 L=2u W=0.5u nf=1
XDPN82 VDD VDD VDD VDD pfet_03v3 L=2u W=0.5u nf=1
XDPN83 VDD VDD VDD VDD pfet_03v3 L=2u W=0.5u nf=1
XDPN84 VDD VDD VDD VDD pfet_03v3 L=2u W=0.5u nf=1
XDPN85 VDD VDD VDD VDD pfet_03v3 L=2u W=0.5u nf=1
XDPN86 VDD VDD VDD VDD pfet_03v3 L=2u W=0.5u nf=1
XDPN87 VDD VDD VDD VDD pfet_03v3 L=2u W=0.5u nf=1
XDPN88 VDD VDD VDD VDD pfet_03v3 L=2u W=0.5u nf=1
XDPN89 VDD VDD VDD VDD pfet_03v3 L=2u W=0.5u nf=1
XDPN90 VDD VDD VDD VDD pfet_03v3 L=2u W=0.5u nf=1
XDPN91 VDD VDD VDD VDD pfet_03v3 L=2u W=0.5u nf=1
XDPN92 VDD VDD VDD VDD pfet_03v3 L=2u W=0.5u nf=1
XDPN93 VDD VDD VDD VDD pfet_03v3 L=2u W=0.5u nf=1
XDPN94 VDD VDD VDD VDD pfet_03v3 L=2u W=0.5u nf=1
XDPN95 VDD VDD VDD VDD pfet_03v3 L=2u W=0.5u nf=1
XDPN96 VDD VDD VDD VDD pfet_03v3 L=2u W=0.5u nf=1
XDPN97 VDD VDD VDD VDD pfet_03v3 L=2u W=0.5u nf=1
XDPN98 VDD VDD VDD VDD pfet_03v3 L=2u W=0.5u nf=1
XDPN99 VDD VDD VDD VDD pfet_03v3 L=2u W=0.5u nf=1
XDPN100 VDD VDD VDD VDD pfet_03v3 L=2u W=0.5u nf=1
XDPN101 VDD VDD VDD VDD pfet_03v3 L=2u W=0.5u nf=1
XDPN102 VDD VDD VDD VDD pfet_03v3 L=2u W=0.5u nf=1
XDPN103 VDD VDD VDD VDD pfet_03v3 L=2u W=0.5u nf=1
XDPN104 VDD VDD VDD VDD pfet_03v3 L=2u W=0.5u nf=1
XDPN105 VDD VDD VDD VDD pfet_03v3 L=2u W=0.5u nf=1
XDPN106 VDD VDD VDD VDD pfet_03v3 L=2u W=0.5u nf=1
XDPN107 VDD VDD VDD VDD pfet_03v3 L=2u W=0.5u nf=1
XDPN108 VDD VDD VDD VDD pfet_03v3 L=2u W=0.5u nf=1
XDPN109 VDD VDD VDD VDD pfet_03v3 L=2u W=0.5u nf=1
XDPN110 VDD VDD VDD VDD pfet_03v3 L=2u W=0.5u nf=1
XDPN111 VDD VDD VDD VDD pfet_03v3 L=2u W=0.5u nf=1
XDPN112 VDD VDD VDD VDD pfet_03v3 L=2u W=0.5u nf=1
XDPN113 VDD VDD VDD VDD pfet_03v3 L=2u W=0.5u nf=1
XDPN114 VDD VDD VDD VDD pfet_03v3 L=2u W=0.5u nf=1
XDPN115 VDD VDD VDD VDD pfet_03v3 L=2u W=0.5u nf=1
XDPN116 VDD VDD VDD VDD pfet_03v3 L=2u W=0.5u nf=1
XDPN117 VDD VDD VDD VDD pfet_03v3 L=2u W=0.5u nf=1
XDPN118 VDD VDD VDD VDD pfet_03v3 L=2u W=0.5u nf=1
XDPN119 VDD VDD VDD VDD pfet_03v3 L=2u W=0.5u nf=1
XDPN120 VDD VDD VDD VDD pfet_03v3 L=2u W=0.5u nf=1
XDPN121 VDD VDD VDD VDD pfet_03v3 L=2u W=0.5u nf=1
XDPN122 VDD VDD VDD VDD pfet_03v3 L=2u W=0.5u nf=1
XDPN123 VDD VDD VDD VDD pfet_03v3 L=2u W=0.5u nf=1
XDPN124 VDD VDD VDD VDD pfet_03v3 L=2u W=0.5u nf=1
XDPN125 VDD VDD VDD VDD pfet_03v3 L=2u W=0.5u nf=1
XDPN126 VDD VDD VDD VDD pfet_03v3 L=2u W=0.5u nf=1
XDPN127 VDD VDD VDD VDD pfet_03v3 L=2u W=0.5u nf=1
XDPN128 VDD VDD VDD VDD pfet_03v3 L=2u W=0.5u nf=1
XDPN129 VDD VDD VDD VDD pfet_03v3 L=2u W=0.5u nf=1
XDPN130 VDD VDD VDD VDD pfet_03v3 L=2u W=0.5u nf=1
XDPN131 VDD VDD VDD VDD pfet_03v3 L=2u W=0.5u nf=1
XDPN132 VDD VDD VDD VDD pfet_03v3 L=2u W=0.5u nf=1
XDPN133 VDD VDD VDD VDD pfet_03v3 L=2u W=0.5u nf=1
XDPN134 VDD VDD VDD VDD pfet_03v3 L=2u W=0.5u nf=1
XDPN135 VDD VDD VDD VDD pfet_03v3 L=2u W=0.5u nf=1
XDPN136 VDD VDD VDD VDD pfet_03v3 L=2u W=0.5u nf=1
XDPN137 VDD VDD VDD VDD pfet_03v3 L=2u W=0.5u nf=1
XDPN138 VDD VDD VDD VDD pfet_03v3 L=2u W=0.5u nf=1
XDPN139 VDD VDD VDD VDD pfet_03v3 L=2u W=0.5u nf=1
XDPN140 VDD VDD VDD VDD pfet_03v3 L=2u W=0.5u nf=1
XDPN141 VDD VDD VDD VDD pfet_03v3 L=2u W=0.5u nf=1
XDPN142 VDD VDD VDD VDD pfet_03v3 L=2u W=0.5u nf=1
XDPN143 VDD VDD VDD VDD pfet_03v3 L=2u W=0.5u nf=1
XDPN144 VDD VDD VDD VDD pfet_03v3 L=2u W=0.5u nf=1
XDPN145 VDD VDD VDD VDD pfet_03v3 L=2u W=0.5u nf=1
XDPN146 VDD VDD VDD VDD pfet_03v3 L=2u W=0.5u nf=1
XDPN147 VDD VDD VDD VDD pfet_03v3 L=2u W=0.5u nf=1
XDPN148 VDD VDD VDD VDD pfet_03v3 L=2u W=0.5u nf=1
XDPN149 VDD VDD VDD VDD pfet_03v3 L=2u W=0.5u nf=1
XDPN150 VDD VDD VDD VDD pfet_03v3 L=2u W=0.5u nf=1
XDPN151 VDD VDD VDD VDD pfet_03v3 L=2u W=0.5u nf=1
XDPN152 VDD VDD VDD VDD pfet_03v3 L=2u W=0.5u nf=1
XDPN153 VDD VDD VDD VDD pfet_03v3 L=2u W=0.5u nf=1
XDPN154 VDD VDD VDD VDD pfet_03v3 L=2u W=0.5u nf=1
XDPN155 VDD VDD VDD VDD pfet_03v3 L=2u W=0.5u nf=1
XDPN156 VDD VDD VDD VDD pfet_03v3 L=2u W=0.5u nf=1
XDPN157 VDD VDD VDD VDD pfet_03v3 L=2u W=0.5u nf=1
XDPN158 VDD VDD VDD VDD pfet_03v3 L=2u W=0.5u nf=1
XDPN159 VDD VDD VDD VDD pfet_03v3 L=2u W=0.5u nf=1
XDPN160 VDD VDD VDD VDD pfet_03v3 L=2u W=0.5u nf=1
XDPN161 VDD VDD VDD VDD pfet_03v3 L=2u W=0.5u nf=1
XDPN162 VDD VDD VDD VDD pfet_03v3 L=2u W=0.5u nf=1
XDPN163 VDD VDD VDD VDD pfet_03v3 L=2u W=0.5u nf=1
XDPN164 VDD VDD VDD VDD pfet_03v3 L=2u W=0.5u nf=1
XDPN165 VDD VDD VDD VDD pfet_03v3 L=2u W=0.5u nf=1
XDPN166 VDD VDD VDD VDD pfet_03v3 L=2u W=0.5u nf=1
XDPN167 VDD VDD VDD VDD pfet_03v3 L=2u W=0.5u nf=1
XDPN168 VDD VDD VDD VDD pfet_03v3 L=2u W=0.5u nf=1
XDPN169 VDD VDD VDD VDD pfet_03v3 L=2u W=0.5u nf=1
XDPN170 VDD VDD VDD VDD pfet_03v3 L=2u W=0.5u nf=1
XDPN171 VDD VDD VDD VDD pfet_03v3 L=2u W=0.5u nf=1
XDPN172 VDD VDD VDD VDD pfet_03v3 L=2u W=0.5u nf=1
XDPN173 VDD VDD VDD VDD pfet_03v3 L=2u W=0.5u nf=1
XDPN174 VDD VDD VDD VDD pfet_03v3 L=2u W=0.5u nf=1
XDPN175 VDD VDD VDD VDD pfet_03v3 L=2u W=0.5u nf=1
XDPN176 VDD VDD VDD VDD pfet_03v3 L=2u W=0.5u nf=1
XDPN177 VDD VDD VDD VDD pfet_03v3 L=2u W=0.5u nf=1
XDPN178 VDD VDD VDD VDD pfet_03v3 L=2u W=0.5u nf=1
XDPN179 VDD VDD VDD VDD pfet_03v3 L=2u W=0.5u nf=1
XDPN180 VDD VDD VDD VDD pfet_03v3 L=2u W=0.5u nf=1
XDPN181 VDD VDD VDD VDD pfet_03v3 L=2u W=0.5u nf=1
XDPN182 VDD VDD VDD VDD pfet_03v3 L=2u W=0.5u nf=1
XDPN183 VDD VDD VDD VDD pfet_03v3 L=2u W=0.5u nf=1
XDPN184 VDD VDD VDD VDD pfet_03v3 L=2u W=0.5u nf=1
XDPN185 VDD VDD VDD VDD pfet_03v3 L=2u W=0.5u nf=1
XDPN186 VDD VDD VDD VDD pfet_03v3 L=2u W=0.5u nf=1
XDPN187 VDD VDD VDD VDD pfet_03v3 L=2u W=0.5u nf=1
XDPN188 VDD VDD VDD VDD pfet_03v3 L=2u W=0.5u nf=1
XDPN189 VDD VDD VDD VDD pfet_03v3 L=2u W=0.5u nf=1
XDPN190 VDD VDD VDD VDD pfet_03v3 L=2u W=0.5u nf=1
XDPN191 VDD VDD VDD VDD pfet_03v3 L=2u W=0.5u nf=1
XDPN192 VDD VDD VDD VDD pfet_03v3 L=2u W=0.5u nf=1
XDPN193 VDD VDD VDD VDD pfet_03v3 L=2u W=0.5u nf=1
XDPN194 VDD VDD VDD VDD pfet_03v3 L=2u W=0.5u nf=1
XDPN195 VDD VDD VDD VDD pfet_03v3 L=2u W=0.5u nf=1
XDPN196 VDD VDD VDD VDD pfet_03v3 L=2u W=0.5u nf=1
XDPN197 VDD VDD VDD VDD pfet_03v3 L=2u W=0.5u nf=1
XDPN198 VDD VDD VDD VDD pfet_03v3 L=2u W=0.5u nf=1
XDPN199 VDD VDD VDD VDD pfet_03v3 L=2u W=0.5u nf=1
XDPN200 VDD VDD VDD VDD pfet_03v3 L=2u W=0.5u nf=1
XDPN201 VDD VDD VDD VDD pfet_03v3 L=2u W=0.5u nf=1
XDPN202 VDD VDD VDD VDD pfet_03v3 L=2u W=0.5u nf=1
XDPN203 VDD VDD VDD VDD pfet_03v3 L=2u W=0.5u nf=1
XDPN204 VDD VDD VDD VDD pfet_03v3 L=2u W=0.5u nf=1
XDPN205 VDD VDD VDD VDD pfet_03v3 L=2u W=0.5u nf=1
XDPN206 VDD VDD VDD VDD pfet_03v3 L=2u W=0.5u nf=1
XDPN207 VDD VDD VDD VDD pfet_03v3 L=2u W=0.5u nf=1
XDPN208 VDD VDD VDD VDD pfet_03v3 L=2u W=0.5u nf=1
XDPN209 VDD VDD VDD VDD pfet_03v3 L=2u W=0.5u nf=1
XDPN210 VDD VDD VDD VDD pfet_03v3 L=2u W=0.5u nf=1
XDPS0 VDD VDD VDD VDD pfet_03v3 L=2u W=0.5u nf=1
XDPS1 VDD VDD VDD VDD pfet_03v3 L=2u W=0.5u nf=1
XDPS2 VDD VDD VDD VDD pfet_03v3 L=2u W=0.5u nf=1
XDPS3 VDD VDD VDD VDD pfet_03v3 L=2u W=0.5u nf=1
XDPS4 VDD VDD VDD VDD pfet_03v3 L=2u W=0.5u nf=1
XDPS5 VDD VDD VDD VDD pfet_03v3 L=2u W=0.5u nf=1
XDPS6 VDD VDD VDD VDD pfet_03v3 L=2u W=0.5u nf=1
XDPS7 VDD VDD VDD VDD pfet_03v3 L=2u W=0.5u nf=1
XDPS8 VDD VDD VDD VDD pfet_03v3 L=2u W=0.5u nf=1
XDPS9 VDD VDD VDD VDD pfet_03v3 L=2u W=0.5u nf=1
XDPS10 VDD VDD VDD VDD pfet_03v3 L=2u W=0.5u nf=1
XDPS11 VDD VDD VDD VDD pfet_03v3 L=2u W=0.5u nf=1
XDPS12 VDD VDD VDD VDD pfet_03v3 L=2u W=0.5u nf=1
XDPS13 VDD VDD VDD VDD pfet_03v3 L=2u W=0.5u nf=1
XDPS14 VDD VDD VDD VDD pfet_03v3 L=2u W=0.5u nf=1
XDPS15 VDD VDD VDD VDD pfet_03v3 L=2u W=0.5u nf=1
XDPS16 VDD VDD VDD VDD pfet_03v3 L=2u W=0.5u nf=1
XDPS17 VDD VDD VDD VDD pfet_03v3 L=2u W=0.5u nf=1
XDPS18 VDD VDD VDD VDD pfet_03v3 L=2u W=0.5u nf=1
XDPS19 VDD VDD VDD VDD pfet_03v3 L=2u W=0.5u nf=1
XDPS20 VDD VDD VDD VDD pfet_03v3 L=2u W=0.5u nf=1
XDPS21 VDD VDD VDD VDD pfet_03v3 L=2u W=0.5u nf=1
XDPS22 VDD VDD VDD VDD pfet_03v3 L=2u W=0.5u nf=1
XDPS23 VDD VDD VDD VDD pfet_03v3 L=2u W=0.5u nf=1
XDPS24 VDD VDD VDD VDD pfet_03v3 L=2u W=0.5u nf=1
XDPS25 VDD VDD VDD VDD pfet_03v3 L=2u W=0.5u nf=1
XDPS26 VDD VDD VDD VDD pfet_03v3 L=2u W=0.5u nf=1
XDPS27 VDD VDD VDD VDD pfet_03v3 L=2u W=0.5u nf=1
XDPS28 VDD VDD VDD VDD pfet_03v3 L=2u W=0.5u nf=1
XDPS29 VDD VDD VDD VDD pfet_03v3 L=2u W=0.5u nf=1
XDPS30 VDD VDD VDD VDD pfet_03v3 L=2u W=0.5u nf=1
XDPS31 VDD VDD VDD VDD pfet_03v3 L=2u W=0.5u nf=1
XDPS32 VDD VDD VDD VDD pfet_03v3 L=2u W=0.5u nf=1
XDPS33 VDD VDD VDD VDD pfet_03v3 L=2u W=0.5u nf=1
XDPS34 VDD VDD VDD VDD pfet_03v3 L=2u W=0.5u nf=1
XDPS35 VDD VDD VDD VDD pfet_03v3 L=2u W=0.5u nf=1
XDPS36 VDD VDD VDD VDD pfet_03v3 L=2u W=0.5u nf=1
XDPS37 VDD VDD VDD VDD pfet_03v3 L=2u W=0.5u nf=1
XDPS38 VDD VDD VDD VDD pfet_03v3 L=2u W=0.5u nf=1
XDPS39 VDD VDD VDD VDD pfet_03v3 L=2u W=0.5u nf=1
XDPS40 VDD VDD VDD VDD pfet_03v3 L=2u W=0.5u nf=1
XDPS41 VDD VDD VDD VDD pfet_03v3 L=2u W=0.5u nf=1
XDPS42 VDD VDD VDD VDD pfet_03v3 L=2u W=0.5u nf=1
XDPS43 VDD VDD VDD VDD pfet_03v3 L=2u W=0.5u nf=1
XDPS44 VDD VDD VDD VDD pfet_03v3 L=2u W=0.5u nf=1
XDPS45 VDD VDD VDD VDD pfet_03v3 L=2u W=0.5u nf=1
XDPS46 VDD VDD VDD VDD pfet_03v3 L=2u W=0.5u nf=1
XDPS47 VDD VDD VDD VDD pfet_03v3 L=2u W=0.5u nf=1
XDPS48 VDD VDD VDD VDD pfet_03v3 L=2u W=0.5u nf=1
XDPS49 VDD VDD VDD VDD pfet_03v3 L=2u W=0.5u nf=1
XDPS50 VDD VDD VDD VDD pfet_03v3 L=2u W=0.5u nf=1
XDPS51 VDD VDD VDD VDD pfet_03v3 L=2u W=0.5u nf=1
XDPS52 VDD VDD VDD VDD pfet_03v3 L=2u W=0.5u nf=1
XDPS53 VDD VDD VDD VDD pfet_03v3 L=2u W=0.5u nf=1
XDPS54 VDD VDD VDD VDD pfet_03v3 L=2u W=0.5u nf=1
XDPS55 VDD VDD VDD VDD pfet_03v3 L=2u W=0.5u nf=1
XDPS56 VDD VDD VDD VDD pfet_03v3 L=2u W=0.5u nf=1
XDPS57 VDD VDD VDD VDD pfet_03v3 L=2u W=0.5u nf=1
XDPS58 VDD VDD VDD VDD pfet_03v3 L=2u W=0.5u nf=1
XDPS59 VDD VDD VDD VDD pfet_03v3 L=2u W=0.5u nf=1
XDPS60 VDD VDD VDD VDD pfet_03v3 L=2u W=0.5u nf=1
XDPS61 VDD VDD VDD VDD pfet_03v3 L=2u W=0.5u nf=1
XDPS62 VDD VDD VDD VDD pfet_03v3 L=2u W=0.5u nf=1
XDPS63 VDD VDD VDD VDD pfet_03v3 L=2u W=0.5u nf=1
XDPS64 VDD VDD VDD VDD pfet_03v3 L=2u W=0.5u nf=1
XDPS65 VDD VDD VDD VDD pfet_03v3 L=2u W=0.5u nf=1
XDPS66 VDD VDD VDD VDD pfet_03v3 L=2u W=0.5u nf=1
XDPS67 VDD VDD VDD VDD pfet_03v3 L=2u W=0.5u nf=1
XDPS68 VDD VDD VDD VDD pfet_03v3 L=2u W=0.5u nf=1
XDPS69 VDD VDD VDD VDD pfet_03v3 L=2u W=0.5u nf=1
XDPS70 VDD VDD VDD VDD pfet_03v3 L=2u W=0.5u nf=1
XDPS71 VDD VDD VDD VDD pfet_03v3 L=2u W=0.5u nf=1
XDPS72 VDD VDD VDD VDD pfet_03v3 L=2u W=0.5u nf=1
XDPS73 VDD VDD VDD VDD pfet_03v3 L=2u W=0.5u nf=1
XDPS74 VDD VDD VDD VDD pfet_03v3 L=2u W=0.5u nf=1
XDPS75 VDD VDD VDD VDD pfet_03v3 L=2u W=0.5u nf=1
XDPS76 VDD VDD VDD VDD pfet_03v3 L=2u W=0.5u nf=1
XDPS77 VDD VDD VDD VDD pfet_03v3 L=2u W=0.5u nf=1
XDPS78 VDD VDD VDD VDD pfet_03v3 L=2u W=0.5u nf=1
XDPS79 VDD VDD VDD VDD pfet_03v3 L=2u W=0.5u nf=1
XDPS80 VDD VDD VDD VDD pfet_03v3 L=2u W=0.5u nf=1
XDPS81 VDD VDD VDD VDD pfet_03v3 L=2u W=0.5u nf=1
XDPS82 VDD VDD VDD VDD pfet_03v3 L=2u W=0.5u nf=1
XDPS83 VDD VDD VDD VDD pfet_03v3 L=2u W=0.5u nf=1
XDPS84 VDD VDD VDD VDD pfet_03v3 L=2u W=0.5u nf=1
XDPS85 VDD VDD VDD VDD pfet_03v3 L=2u W=0.5u nf=1
XDPS86 VDD VDD VDD VDD pfet_03v3 L=2u W=0.5u nf=1
XDPS87 VDD VDD VDD VDD pfet_03v3 L=2u W=0.5u nf=1
XDPS88 VDD VDD VDD VDD pfet_03v3 L=2u W=0.5u nf=1
XDPS89 VDD VDD VDD VDD pfet_03v3 L=2u W=0.5u nf=1
XDPS90 VDD VDD VDD VDD pfet_03v3 L=2u W=0.5u nf=1
XDPS91 VDD VDD VDD VDD pfet_03v3 L=2u W=0.5u nf=1
XDPS92 VDD VDD VDD VDD pfet_03v3 L=2u W=0.5u nf=1
XDPS93 VDD VDD VDD VDD pfet_03v3 L=2u W=0.5u nf=1
XDPS94 VDD VDD VDD VDD pfet_03v3 L=2u W=0.5u nf=1
XDPS95 VDD VDD VDD VDD pfet_03v3 L=2u W=0.5u nf=1
XDPS96 VDD VDD VDD VDD pfet_03v3 L=2u W=0.5u nf=1
XDPS97 VDD VDD VDD VDD pfet_03v3 L=2u W=0.5u nf=1
XDPS98 VDD VDD VDD VDD pfet_03v3 L=2u W=0.5u nf=1
XDPS99 VDD VDD VDD VDD pfet_03v3 L=2u W=0.5u nf=1
XDPS100 VDD VDD VDD VDD pfet_03v3 L=2u W=0.5u nf=1
XDPS101 VDD VDD VDD VDD pfet_03v3 L=2u W=0.5u nf=1
XDPS102 VDD VDD VDD VDD pfet_03v3 L=2u W=0.5u nf=1
XDPS103 VDD VDD VDD VDD pfet_03v3 L=2u W=0.5u nf=1
XDPS104 VDD VDD VDD VDD pfet_03v3 L=2u W=0.5u nf=1
XDPS105 VDD VDD VDD VDD pfet_03v3 L=2u W=0.5u nf=1
XDPS106 VDD VDD VDD VDD pfet_03v3 L=2u W=0.5u nf=1
XDPS107 VDD VDD VDD VDD pfet_03v3 L=2u W=0.5u nf=1
XDPS108 VDD VDD VDD VDD pfet_03v3 L=2u W=0.5u nf=1
XDPS109 VDD VDD VDD VDD pfet_03v3 L=2u W=0.5u nf=1
XDPS110 VDD VDD VDD VDD pfet_03v3 L=2u W=0.5u nf=1
XDPS111 VDD VDD VDD VDD pfet_03v3 L=2u W=0.5u nf=1
XDPS112 VDD VDD VDD VDD pfet_03v3 L=2u W=0.5u nf=1
XDPS113 VDD VDD VDD VDD pfet_03v3 L=2u W=0.5u nf=1
XDPS114 VDD VDD VDD VDD pfet_03v3 L=2u W=0.5u nf=1
XDPS115 VDD VDD VDD VDD pfet_03v3 L=2u W=0.5u nf=1
XDPS116 VDD VDD VDD VDD pfet_03v3 L=2u W=0.5u nf=1
XDPS117 VDD VDD VDD VDD pfet_03v3 L=2u W=0.5u nf=1
XDPS118 VDD VDD VDD VDD pfet_03v3 L=2u W=0.5u nf=1
XDPS119 VDD VDD VDD VDD pfet_03v3 L=2u W=0.5u nf=1
XDPS120 VDD VDD VDD VDD pfet_03v3 L=2u W=0.5u nf=1
XDPS121 VDD VDD VDD VDD pfet_03v3 L=2u W=0.5u nf=1
XDPS122 VDD VDD VDD VDD pfet_03v3 L=2u W=0.5u nf=1
XDPS123 VDD VDD VDD VDD pfet_03v3 L=2u W=0.5u nf=1
XDPS124 VDD VDD VDD VDD pfet_03v3 L=2u W=0.5u nf=1
XDPS125 VDD VDD VDD VDD pfet_03v3 L=2u W=0.5u nf=1
XDPS126 VDD VDD VDD VDD pfet_03v3 L=2u W=0.5u nf=1
XDPS127 VDD VDD VDD VDD pfet_03v3 L=2u W=0.5u nf=1
XDPS128 VDD VDD VDD VDD pfet_03v3 L=2u W=0.5u nf=1
XDPS129 VDD VDD VDD VDD pfet_03v3 L=2u W=0.5u nf=1
XDPS130 VDD VDD VDD VDD pfet_03v3 L=2u W=0.5u nf=1
XDPS131 VDD VDD VDD VDD pfet_03v3 L=2u W=0.5u nf=1
XDPS132 VDD VDD VDD VDD pfet_03v3 L=2u W=0.5u nf=1
XDPS133 VDD VDD VDD VDD pfet_03v3 L=2u W=0.5u nf=1
XDPS134 VDD VDD VDD VDD pfet_03v3 L=2u W=0.5u nf=1
XDPS135 VDD VDD VDD VDD pfet_03v3 L=2u W=0.5u nf=1
XDPS136 VDD VDD VDD VDD pfet_03v3 L=2u W=0.5u nf=1
XDPS137 VDD VDD VDD VDD pfet_03v3 L=2u W=0.5u nf=1
XDPS138 VDD VDD VDD VDD pfet_03v3 L=2u W=0.5u nf=1
XDPS139 VDD VDD VDD VDD pfet_03v3 L=2u W=0.5u nf=1
XDPS140 VDD VDD VDD VDD pfet_03v3 L=2u W=0.5u nf=1
XDPS141 VDD VDD VDD VDD pfet_03v3 L=2u W=0.5u nf=1
XDPS142 VDD VDD VDD VDD pfet_03v3 L=2u W=0.5u nf=1
XDPS143 VDD VDD VDD VDD pfet_03v3 L=2u W=0.5u nf=1
XDPS144 VDD VDD VDD VDD pfet_03v3 L=2u W=0.5u nf=1
XDPS145 VDD VDD VDD VDD pfet_03v3 L=2u W=0.5u nf=1
XDPS146 VDD VDD VDD VDD pfet_03v3 L=2u W=0.5u nf=1
XDPS147 VDD VDD VDD VDD pfet_03v3 L=2u W=0.5u nf=1
XDPS148 VDD VDD VDD VDD pfet_03v3 L=2u W=0.5u nf=1
XDPS149 VDD VDD VDD VDD pfet_03v3 L=2u W=0.5u nf=1
XDPS150 VDD VDD VDD VDD pfet_03v3 L=2u W=0.5u nf=1
XDPS151 VDD VDD VDD VDD pfet_03v3 L=2u W=0.5u nf=1
XDPS152 VDD VDD VDD VDD pfet_03v3 L=2u W=0.5u nf=1
XDPS153 VDD VDD VDD VDD pfet_03v3 L=2u W=0.5u nf=1
XDPS154 VDD VDD VDD VDD pfet_03v3 L=2u W=0.5u nf=1
XDPS155 VDD VDD VDD VDD pfet_03v3 L=2u W=0.5u nf=1
XDPS156 VDD VDD VDD VDD pfet_03v3 L=2u W=0.5u nf=1
XDPS157 VDD VDD VDD VDD pfet_03v3 L=2u W=0.5u nf=1
XDPS158 VDD VDD VDD VDD pfet_03v3 L=2u W=0.5u nf=1
XDPS159 VDD VDD VDD VDD pfet_03v3 L=2u W=0.5u nf=1
XDPS160 VDD VDD VDD VDD pfet_03v3 L=2u W=0.5u nf=1
XDPS161 VDD VDD VDD VDD pfet_03v3 L=2u W=0.5u nf=1
XDPS162 VDD VDD VDD VDD pfet_03v3 L=2u W=0.5u nf=1
XDPS163 VDD VDD VDD VDD pfet_03v3 L=2u W=0.5u nf=1
XDPS164 VDD VDD VDD VDD pfet_03v3 L=2u W=0.5u nf=1
XDPS165 VDD VDD VDD VDD pfet_03v3 L=2u W=0.5u nf=1
XDPS166 VDD VDD VDD VDD pfet_03v3 L=2u W=0.5u nf=1
XDPS167 VDD VDD VDD VDD pfet_03v3 L=2u W=0.5u nf=1
XDPS168 VDD VDD VDD VDD pfet_03v3 L=2u W=0.5u nf=1
XDPS169 VDD VDD VDD VDD pfet_03v3 L=2u W=0.5u nf=1
XDPS170 VDD VDD VDD VDD pfet_03v3 L=2u W=0.5u nf=1
XDPS171 VDD VDD VDD VDD pfet_03v3 L=2u W=0.5u nf=1
XDPS172 VDD VDD VDD VDD pfet_03v3 L=2u W=0.5u nf=1
XDPS173 VDD VDD VDD VDD pfet_03v3 L=2u W=0.5u nf=1
XDPS174 VDD VDD VDD VDD pfet_03v3 L=2u W=0.5u nf=1
XDPS175 VDD VDD VDD VDD pfet_03v3 L=2u W=0.5u nf=1
XDPS176 VDD VDD VDD VDD pfet_03v3 L=2u W=0.5u nf=1
XDPS177 VDD VDD VDD VDD pfet_03v3 L=2u W=0.5u nf=1
XDPS178 VDD VDD VDD VDD pfet_03v3 L=2u W=0.5u nf=1
XDPS179 VDD VDD VDD VDD pfet_03v3 L=2u W=0.5u nf=1
XDPS180 VDD VDD VDD VDD pfet_03v3 L=2u W=0.5u nf=1
XDPS181 VDD VDD VDD VDD pfet_03v3 L=2u W=0.5u nf=1
XDPS182 VDD VDD VDD VDD pfet_03v3 L=2u W=0.5u nf=1
XDPS183 VDD VDD VDD VDD pfet_03v3 L=2u W=0.5u nf=1
XDPS184 VDD VDD VDD VDD pfet_03v3 L=2u W=0.5u nf=1
XDPS185 VDD VDD VDD VDD pfet_03v3 L=2u W=0.5u nf=1
XDPS186 VDD VDD VDD VDD pfet_03v3 L=2u W=0.5u nf=1
XDPS187 VDD VDD VDD VDD pfet_03v3 L=2u W=0.5u nf=1
XDPS188 VDD VDD VDD VDD pfet_03v3 L=2u W=0.5u nf=1
XDPS189 VDD VDD VDD VDD pfet_03v3 L=2u W=0.5u nf=1
XDPS190 VDD VDD VDD VDD pfet_03v3 L=2u W=0.5u nf=1
XDPS191 VDD VDD VDD VDD pfet_03v3 L=2u W=0.5u nf=1
XDPS192 VDD VDD VDD VDD pfet_03v3 L=2u W=0.5u nf=1
XDPS193 VDD VDD VDD VDD pfet_03v3 L=2u W=0.5u nf=1
XDPS194 VDD VDD VDD VDD pfet_03v3 L=2u W=0.5u nf=1
XDPS195 VDD VDD VDD VDD pfet_03v3 L=2u W=0.5u nf=1
XDPS196 VDD VDD VDD VDD pfet_03v3 L=2u W=0.5u nf=1
XDPS197 VDD VDD VDD VDD pfet_03v3 L=2u W=0.5u nf=1
XDPS198 VDD VDD VDD VDD pfet_03v3 L=2u W=0.5u nf=1
XDPS199 VDD VDD VDD VDD pfet_03v3 L=2u W=0.5u nf=1
XDPS200 VDD VDD VDD VDD pfet_03v3 L=2u W=0.5u nf=1
XDPS201 VDD VDD VDD VDD pfet_03v3 L=2u W=0.5u nf=1
XDPS202 VDD VDD VDD VDD pfet_03v3 L=2u W=0.5u nf=1
XDPS203 VDD VDD VDD VDD pfet_03v3 L=2u W=0.5u nf=1
XDPS204 VDD VDD VDD VDD pfet_03v3 L=2u W=0.5u nf=1
XDPS205 VDD VDD VDD VDD pfet_03v3 L=2u W=0.5u nf=1
XDPS206 VDD VDD VDD VDD pfet_03v3 L=2u W=0.5u nf=1
XDPS207 VDD VDD VDD VDD pfet_03v3 L=2u W=0.5u nf=1
XDPS208 VDD VDD VDD VDD pfet_03v3 L=2u W=0.5u nf=1
XDPS209 VDD VDD VDD VDD pfet_03v3 L=2u W=0.5u nf=1
XDPS210 VDD VDD VDD VDD pfet_03v3 L=2u W=0.5u nf=1
XDPW0 VDD VDD VDD VDD pfet_03v3 L=2u W=1u nf=1
XDPE0 VDD VDD VDD VDD pfet_03v3 L=2u W=1u nf=1
Cpred_Iref Iref VSS 9.062e-14
Cpred_R_j0 R_j0 VSS 1.058e-15
Cpred_R_j1 R_j1 VSS 1.083e-15
Cpred_R_j10 R_j10 VSS 1.059e-15
Cpred_R_j2 R_j2 VSS 1.105e-15
Cpred_R_j3 R_j3 VSS 1.106e-15
Cpred_R_j4 R_j4 VSS 1.106e-15
Cpred_R_j5 R_j5 VSS 1.106e-15
Cpred_R_j6 R_j6 VSS 1.106e-15
Cpred_R_j7 R_j7 VSS 1.106e-15
Cpred_R_j8 R_j8 VSS 1.106e-15
Cpred_R_j9 R_j9 VSS 1.083e-15
Cpred_Vgn Vgn VSS 2.448e-13
Cpred_Vgp Vgp VSS 3.167e-13
Cpred_Vr Vr VSS 2.21e-13
Cpred_X X VSS 3.47e-13
Cpred_net1 net1 VSS 2.171e-14
Cpred_net2 net2 VSS 2.128e-14
Cpred_net3 net3 VSS 2.023e-14
Cpred_net4 net4 VSS 2.023e-14
Cpred_net5 net5 VSS 2.023e-14
Cpred_net6 net6 VSS 2.023e-14
Cpred_net7 net7 VSS 2.023e-14
Cpred_net8 net8 VSS 2.019e-14
Cpred_s4 s4 VSS 2.023e-14
.ends
