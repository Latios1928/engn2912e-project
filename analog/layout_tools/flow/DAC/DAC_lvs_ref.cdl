* LVS reference for DAC.gds (glayout_floorplan.two_row)
* note: G3 common-centroid, 15 units: D C D B D C D A D C D B D C D (A=x1_M2 x1, B=x1_M4 x2, C=x1_M6 x4, D=x1_M8 x8)
* note: ground net GND drawn as VSS
.subckt DAC Isum_e w[3] w[2] w[1] w[0] en s Vb Isum_i VDD VSS
Mx1_Men Y en x1_X VSS nfet_03v3 L=0.64u W=0.5u nf=1
MMse Isum_e sb Y VSS nfet_03v3 L=0.64u W=0.5u nf=1
MMsi Isum_i s Y VSS nfet_03v3 L=0.64u W=0.5u nf=1
Mx1_M8_u0 x1_net1 Vb VSS VSS nfet_03v3 L=8u W=1u nf=1
Mx1_M6_u0 x1_net3 Vb VSS VSS nfet_03v3 L=8u W=1u nf=1
Mx1_M8_u1 x1_net1 Vb VSS VSS nfet_03v3 L=8u W=1u nf=1
Mx1_M4_u0 x1_net2 Vb VSS VSS nfet_03v3 L=8u W=1u nf=1
Mx1_M8_u2 x1_net1 Vb VSS VSS nfet_03v3 L=8u W=1u nf=1
Mx1_M6_u1 x1_net3 Vb VSS VSS nfet_03v3 L=8u W=1u nf=1
Mx1_M8_u3 x1_net1 Vb VSS VSS nfet_03v3 L=8u W=1u nf=1
Mx1_M2_u0 x1_net4 Vb VSS VSS nfet_03v3 L=8u W=1u nf=1
Mx1_M8_u4 x1_net1 Vb VSS VSS nfet_03v3 L=8u W=1u nf=1
Mx1_M6_u2 x1_net3 Vb VSS VSS nfet_03v3 L=8u W=1u nf=1
Mx1_M8_u5 x1_net1 Vb VSS VSS nfet_03v3 L=8u W=1u nf=1
Mx1_M4_u1 x1_net2 Vb VSS VSS nfet_03v3 L=8u W=1u nf=1
Mx1_M8_u6 x1_net1 Vb VSS VSS nfet_03v3 L=8u W=1u nf=1
Mx1_M6_u3 x1_net3 Vb VSS VSS nfet_03v3 L=8u W=1u nf=1
Mx1_M8_u7 x1_net1 Vb VSS VSS nfet_03v3 L=8u W=1u nf=1
MMni sb s VSS VSS nfet_03v3 L=0.64u W=0.5u nf=1
Mx1_M1 x1_X w[0] x1_net4 VSS nfet_03v3 L=0.64u W=0.5u nf=1
Mx1_M3_f0 x1_X w[1] x1_net2 VSS nfet_03v3 L=0.64u W=0.5u nf=1
Mx1_M3_f1 x1_X w[1] x1_net2 VSS nfet_03v3 L=0.64u W=0.5u nf=1
Mx1_M5_f0 x1_X w[2] x1_net3 VSS nfet_03v3 L=0.64u W=0.5u nf=1
Mx1_M5_f1 x1_X w[2] x1_net3 VSS nfet_03v3 L=0.64u W=0.5u nf=1
Mx1_M5_f2 x1_X w[2] x1_net3 VSS nfet_03v3 L=0.64u W=0.5u nf=1
Mx1_M5_f3 x1_X w[2] x1_net3 VSS nfet_03v3 L=0.64u W=0.5u nf=1
Mx1_M7_f0 x1_X w[3] x1_net1 VSS nfet_03v3 L=0.64u W=0.5u nf=1
Mx1_M7_f1 x1_X w[3] x1_net1 VSS nfet_03v3 L=0.64u W=0.5u nf=1
Mx1_M7_f2 x1_X w[3] x1_net1 VSS nfet_03v3 L=0.64u W=0.5u nf=1
Mx1_M7_f3 x1_X w[3] x1_net1 VSS nfet_03v3 L=0.64u W=0.5u nf=1
Mx1_M7_f4 x1_X w[3] x1_net1 VSS nfet_03v3 L=0.64u W=0.5u nf=1
Mx1_M7_f5 x1_X w[3] x1_net1 VSS nfet_03v3 L=0.64u W=0.5u nf=1
Mx1_M7_f6 x1_X w[3] x1_net1 VSS nfet_03v3 L=0.64u W=0.5u nf=1
Mx1_M7_f7 x1_X w[3] x1_net1 VSS nfet_03v3 L=0.64u W=0.5u nf=1
MMpi sb s VDD VDD pfet_03v3 L=0.32u W=0.5u nf=1
MDNN0 VSS VSS VSS VSS nfet_03v3 L=2u W=0.5u nf=1
MDNN1 VSS VSS VSS VSS nfet_03v3 L=2u W=0.5u nf=1
MDNN2 VSS VSS VSS VSS nfet_03v3 L=2u W=0.5u nf=1
MDNN3 VSS VSS VSS VSS nfet_03v3 L=2u W=0.5u nf=1
MDNN4 VSS VSS VSS VSS nfet_03v3 L=2u W=0.5u nf=1
MDNN5 VSS VSS VSS VSS nfet_03v3 L=2u W=0.5u nf=1
MDNN6 VSS VSS VSS VSS nfet_03v3 L=2u W=0.5u nf=1
MDNN7 VSS VSS VSS VSS nfet_03v3 L=2u W=0.5u nf=1
MDNN8 VSS VSS VSS VSS nfet_03v3 L=2u W=0.5u nf=1
MDNN9 VSS VSS VSS VSS nfet_03v3 L=2u W=0.5u nf=1
MDNN10 VSS VSS VSS VSS nfet_03v3 L=2u W=0.5u nf=1
MDNN11 VSS VSS VSS VSS nfet_03v3 L=2u W=0.5u nf=1
MDNN12 VSS VSS VSS VSS nfet_03v3 L=2u W=0.5u nf=1
MDNN13 VSS VSS VSS VSS nfet_03v3 L=2u W=0.5u nf=1
MDNN14 VSS VSS VSS VSS nfet_03v3 L=2u W=0.5u nf=1
MDNN15 VSS VSS VSS VSS nfet_03v3 L=2u W=0.5u nf=1
MDNN16 VSS VSS VSS VSS nfet_03v3 L=2u W=0.5u nf=1
MDNN17 VSS VSS VSS VSS nfet_03v3 L=2u W=0.5u nf=1
MDNN18 VSS VSS VSS VSS nfet_03v3 L=2u W=0.5u nf=1
MDNN19 VSS VSS VSS VSS nfet_03v3 L=2u W=0.5u nf=1
MDNN20 VSS VSS VSS VSS nfet_03v3 L=2u W=0.5u nf=1
MDNN21 VSS VSS VSS VSS nfet_03v3 L=2u W=0.5u nf=1
MDNN22 VSS VSS VSS VSS nfet_03v3 L=2u W=0.5u nf=1
MDNN23 VSS VSS VSS VSS nfet_03v3 L=2u W=0.5u nf=1
MDNN24 VSS VSS VSS VSS nfet_03v3 L=2u W=0.5u nf=1
MDNN25 VSS VSS VSS VSS nfet_03v3 L=2u W=0.5u nf=1
MDNN26 VSS VSS VSS VSS nfet_03v3 L=2u W=0.5u nf=1
MDNN27 VSS VSS VSS VSS nfet_03v3 L=2u W=0.5u nf=1
MDNN28 VSS VSS VSS VSS nfet_03v3 L=2u W=0.5u nf=1
MDNN29 VSS VSS VSS VSS nfet_03v3 L=2u W=0.5u nf=1
MDNN30 VSS VSS VSS VSS nfet_03v3 L=2u W=0.5u nf=1
MDNN31 VSS VSS VSS VSS nfet_03v3 L=2u W=0.5u nf=1
MDNN32 VSS VSS VSS VSS nfet_03v3 L=2u W=0.5u nf=1
MDNN33 VSS VSS VSS VSS nfet_03v3 L=2u W=0.5u nf=1
MDNN34 VSS VSS VSS VSS nfet_03v3 L=2u W=0.5u nf=1
MDNN35 VSS VSS VSS VSS nfet_03v3 L=2u W=0.5u nf=1
MDNN36 VSS VSS VSS VSS nfet_03v3 L=2u W=0.5u nf=1
MDNN37 VSS VSS VSS VSS nfet_03v3 L=2u W=0.5u nf=1
MDNN38 VSS VSS VSS VSS nfet_03v3 L=2u W=0.5u nf=1
MDNN39 VSS VSS VSS VSS nfet_03v3 L=2u W=0.5u nf=1
MDNN40 VSS VSS VSS VSS nfet_03v3 L=2u W=0.5u nf=1
MDNN41 VSS VSS VSS VSS nfet_03v3 L=2u W=0.5u nf=1
MDNN42 VSS VSS VSS VSS nfet_03v3 L=2u W=0.5u nf=1
MDNN43 VSS VSS VSS VSS nfet_03v3 L=2u W=0.5u nf=1
MDNN44 VSS VSS VSS VSS nfet_03v3 L=2u W=0.5u nf=1
MDNN45 VSS VSS VSS VSS nfet_03v3 L=2u W=0.5u nf=1
MDNN46 VSS VSS VSS VSS nfet_03v3 L=2u W=0.5u nf=1
MDNN47 VSS VSS VSS VSS nfet_03v3 L=2u W=0.5u nf=1
MDNN48 VSS VSS VSS VSS nfet_03v3 L=2u W=0.5u nf=1
MDNN49 VSS VSS VSS VSS nfet_03v3 L=2u W=0.5u nf=1
MDNN50 VSS VSS VSS VSS nfet_03v3 L=2u W=0.5u nf=1
MDNN51 VSS VSS VSS VSS nfet_03v3 L=2u W=0.5u nf=1
MDNN52 VSS VSS VSS VSS nfet_03v3 L=2u W=0.5u nf=1
MDNN53 VSS VSS VSS VSS nfet_03v3 L=2u W=0.5u nf=1
MDNN54 VSS VSS VSS VSS nfet_03v3 L=2u W=0.5u nf=1
MDNN55 VSS VSS VSS VSS nfet_03v3 L=2u W=0.5u nf=1
MDNN56 VSS VSS VSS VSS nfet_03v3 L=2u W=0.5u nf=1
MDNN57 VSS VSS VSS VSS nfet_03v3 L=2u W=0.5u nf=1
MDNN58 VSS VSS VSS VSS nfet_03v3 L=2u W=0.5u nf=1
MDNN59 VSS VSS VSS VSS nfet_03v3 L=2u W=0.5u nf=1
MDNN60 VSS VSS VSS VSS nfet_03v3 L=2u W=0.5u nf=1
MDNN61 VSS VSS VSS VSS nfet_03v3 L=2u W=0.5u nf=1
MDNN62 VSS VSS VSS VSS nfet_03v3 L=2u W=0.5u nf=1
MDNN63 VSS VSS VSS VSS nfet_03v3 L=2u W=0.5u nf=1
MDNN64 VSS VSS VSS VSS nfet_03v3 L=2u W=0.5u nf=1
MDNN65 VSS VSS VSS VSS nfet_03v3 L=2u W=0.5u nf=1
MDNN66 VSS VSS VSS VSS nfet_03v3 L=2u W=0.5u nf=1
MDNN67 VSS VSS VSS VSS nfet_03v3 L=2u W=0.5u nf=1
MDNN68 VSS VSS VSS VSS nfet_03v3 L=2u W=0.5u nf=1
MDNN69 VSS VSS VSS VSS nfet_03v3 L=2u W=0.5u nf=1
MDNN70 VSS VSS VSS VSS nfet_03v3 L=2u W=0.5u nf=1
MDNN71 VSS VSS VSS VSS nfet_03v3 L=2u W=0.5u nf=1
MDNN72 VSS VSS VSS VSS nfet_03v3 L=2u W=0.5u nf=1
MDNN73 VSS VSS VSS VSS nfet_03v3 L=2u W=0.5u nf=1
MDNN74 VSS VSS VSS VSS nfet_03v3 L=2u W=0.5u nf=1
MDNN75 VSS VSS VSS VSS nfet_03v3 L=2u W=0.5u nf=1
MDNN76 VSS VSS VSS VSS nfet_03v3 L=2u W=0.5u nf=1
MDNN77 VSS VSS VSS VSS nfet_03v3 L=2u W=0.5u nf=1
MDNN78 VSS VSS VSS VSS nfet_03v3 L=2u W=0.5u nf=1
MDNS0 VSS VSS VSS VSS nfet_03v3 L=2u W=0.5u nf=1
MDNS1 VSS VSS VSS VSS nfet_03v3 L=2u W=0.5u nf=1
MDNS2 VSS VSS VSS VSS nfet_03v3 L=2u W=0.5u nf=1
MDNS3 VSS VSS VSS VSS nfet_03v3 L=2u W=0.5u nf=1
MDNS4 VSS VSS VSS VSS nfet_03v3 L=2u W=0.5u nf=1
MDNS5 VSS VSS VSS VSS nfet_03v3 L=2u W=0.5u nf=1
MDNS6 VSS VSS VSS VSS nfet_03v3 L=2u W=0.5u nf=1
MDNS7 VSS VSS VSS VSS nfet_03v3 L=2u W=0.5u nf=1
MDNS8 VSS VSS VSS VSS nfet_03v3 L=2u W=0.5u nf=1
MDNS9 VSS VSS VSS VSS nfet_03v3 L=2u W=0.5u nf=1
MDNS10 VSS VSS VSS VSS nfet_03v3 L=2u W=0.5u nf=1
MDNS11 VSS VSS VSS VSS nfet_03v3 L=2u W=0.5u nf=1
MDNS12 VSS VSS VSS VSS nfet_03v3 L=2u W=0.5u nf=1
MDNS13 VSS VSS VSS VSS nfet_03v3 L=2u W=0.5u nf=1
MDNS14 VSS VSS VSS VSS nfet_03v3 L=2u W=0.5u nf=1
MDNS15 VSS VSS VSS VSS nfet_03v3 L=2u W=0.5u nf=1
MDNS16 VSS VSS VSS VSS nfet_03v3 L=2u W=0.5u nf=1
MDNS17 VSS VSS VSS VSS nfet_03v3 L=2u W=0.5u nf=1
MDNS18 VSS VSS VSS VSS nfet_03v3 L=2u W=0.5u nf=1
MDNS19 VSS VSS VSS VSS nfet_03v3 L=2u W=0.5u nf=1
MDNS20 VSS VSS VSS VSS nfet_03v3 L=2u W=0.5u nf=1
MDNS21 VSS VSS VSS VSS nfet_03v3 L=2u W=0.5u nf=1
MDNS22 VSS VSS VSS VSS nfet_03v3 L=2u W=0.5u nf=1
MDNS23 VSS VSS VSS VSS nfet_03v3 L=2u W=0.5u nf=1
MDNS24 VSS VSS VSS VSS nfet_03v3 L=2u W=0.5u nf=1
MDNS25 VSS VSS VSS VSS nfet_03v3 L=2u W=0.5u nf=1
MDNS26 VSS VSS VSS VSS nfet_03v3 L=2u W=0.5u nf=1
MDNS27 VSS VSS VSS VSS nfet_03v3 L=2u W=0.5u nf=1
MDNS28 VSS VSS VSS VSS nfet_03v3 L=2u W=0.5u nf=1
MDNS29 VSS VSS VSS VSS nfet_03v3 L=2u W=0.5u nf=1
MDNS30 VSS VSS VSS VSS nfet_03v3 L=2u W=0.5u nf=1
MDNS31 VSS VSS VSS VSS nfet_03v3 L=2u W=0.5u nf=1
MDNS32 VSS VSS VSS VSS nfet_03v3 L=2u W=0.5u nf=1
MDNS33 VSS VSS VSS VSS nfet_03v3 L=2u W=0.5u nf=1
MDNS34 VSS VSS VSS VSS nfet_03v3 L=2u W=0.5u nf=1
MDNS35 VSS VSS VSS VSS nfet_03v3 L=2u W=0.5u nf=1
MDNS36 VSS VSS VSS VSS nfet_03v3 L=2u W=0.5u nf=1
MDNS37 VSS VSS VSS VSS nfet_03v3 L=2u W=0.5u nf=1
MDNS38 VSS VSS VSS VSS nfet_03v3 L=2u W=0.5u nf=1
MDNS39 VSS VSS VSS VSS nfet_03v3 L=2u W=0.5u nf=1
MDNS40 VSS VSS VSS VSS nfet_03v3 L=2u W=0.5u nf=1
MDNS41 VSS VSS VSS VSS nfet_03v3 L=2u W=0.5u nf=1
MDNS42 VSS VSS VSS VSS nfet_03v3 L=2u W=0.5u nf=1
MDNS43 VSS VSS VSS VSS nfet_03v3 L=2u W=0.5u nf=1
MDNS44 VSS VSS VSS VSS nfet_03v3 L=2u W=0.5u nf=1
MDNS45 VSS VSS VSS VSS nfet_03v3 L=2u W=0.5u nf=1
MDNS46 VSS VSS VSS VSS nfet_03v3 L=2u W=0.5u nf=1
MDNS47 VSS VSS VSS VSS nfet_03v3 L=2u W=0.5u nf=1
MDNS48 VSS VSS VSS VSS nfet_03v3 L=2u W=0.5u nf=1
MDNS49 VSS VSS VSS VSS nfet_03v3 L=2u W=0.5u nf=1
MDNS50 VSS VSS VSS VSS nfet_03v3 L=2u W=0.5u nf=1
MDNS51 VSS VSS VSS VSS nfet_03v3 L=2u W=0.5u nf=1
MDNS52 VSS VSS VSS VSS nfet_03v3 L=2u W=0.5u nf=1
MDNS53 VSS VSS VSS VSS nfet_03v3 L=2u W=0.5u nf=1
MDNS54 VSS VSS VSS VSS nfet_03v3 L=2u W=0.5u nf=1
MDNS55 VSS VSS VSS VSS nfet_03v3 L=2u W=0.5u nf=1
MDNS56 VSS VSS VSS VSS nfet_03v3 L=2u W=0.5u nf=1
MDNS57 VSS VSS VSS VSS nfet_03v3 L=2u W=0.5u nf=1
MDNS58 VSS VSS VSS VSS nfet_03v3 L=2u W=0.5u nf=1
MDNS59 VSS VSS VSS VSS nfet_03v3 L=2u W=0.5u nf=1
MDNS60 VSS VSS VSS VSS nfet_03v3 L=2u W=0.5u nf=1
MDNS61 VSS VSS VSS VSS nfet_03v3 L=2u W=0.5u nf=1
MDNS62 VSS VSS VSS VSS nfet_03v3 L=2u W=0.5u nf=1
MDNS63 VSS VSS VSS VSS nfet_03v3 L=2u W=0.5u nf=1
MDNS64 VSS VSS VSS VSS nfet_03v3 L=2u W=0.5u nf=1
MDNS65 VSS VSS VSS VSS nfet_03v3 L=2u W=0.5u nf=1
MDNS66 VSS VSS VSS VSS nfet_03v3 L=2u W=0.5u nf=1
MDNS67 VSS VSS VSS VSS nfet_03v3 L=2u W=0.5u nf=1
MDNS68 VSS VSS VSS VSS nfet_03v3 L=2u W=0.5u nf=1
MDNS69 VSS VSS VSS VSS nfet_03v3 L=2u W=0.5u nf=1
MDNS70 VSS VSS VSS VSS nfet_03v3 L=2u W=0.5u nf=1
MDNS71 VSS VSS VSS VSS nfet_03v3 L=2u W=0.5u nf=1
MDNS72 VSS VSS VSS VSS nfet_03v3 L=2u W=0.5u nf=1
MDNS73 VSS VSS VSS VSS nfet_03v3 L=2u W=0.5u nf=1
MDNS74 VSS VSS VSS VSS nfet_03v3 L=2u W=0.5u nf=1
MDNS75 VSS VSS VSS VSS nfet_03v3 L=2u W=0.5u nf=1
MDNS76 VSS VSS VSS VSS nfet_03v3 L=2u W=0.5u nf=1
MDNS77 VSS VSS VSS VSS nfet_03v3 L=2u W=0.5u nf=1
MDNS78 VSS VSS VSS VSS nfet_03v3 L=2u W=0.5u nf=1
MDNW0 VSS VSS VSS VSS nfet_03v3 L=2u W=1u nf=1
MDNE0 VSS VSS VSS VSS nfet_03v3 L=2u W=1u nf=1
MDPN0 VDD VDD VDD VDD pfet_03v3 L=2u W=0.5u nf=1
MDPN1 VDD VDD VDD VDD pfet_03v3 L=2u W=0.5u nf=1
MDPN2 VDD VDD VDD VDD pfet_03v3 L=2u W=0.5u nf=1
MDPS0 VDD VDD VDD VDD pfet_03v3 L=2u W=0.5u nf=1
MDPS1 VDD VDD VDD VDD pfet_03v3 L=2u W=0.5u nf=1
MDPS2 VDD VDD VDD VDD pfet_03v3 L=2u W=0.5u nf=1
MDPW0 VDD VDD VDD VDD pfet_03v3 L=2u W=0.5u nf=1
MDPE0 VDD VDD VDD VDD pfet_03v3 L=2u W=0.5u nf=1
.ends
