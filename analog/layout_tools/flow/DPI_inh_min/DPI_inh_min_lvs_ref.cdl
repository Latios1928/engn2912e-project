* LVS reference for DPI_inh_min.gds (glayout_floorplan.two_row)
* note: x1_M1: 0.22/0.28 -> 0.5/0.64 (W/L kept)
* note: x1_M2: 0.22/0.28 -> 0.5/0.64 (W/L kept)
* note: x1_M3: 0.22/0.28 -> 0.5/0.64 (W/L kept)
* note: x1_M4: 0.22/0.28 -> 0.5/0.64 (W/L kept)
* note: ground net GND drawn as VSS
.subckt DPI_inh_min Vthr VT Isum VDD Iout VSS
Mx1_M1 VDD Vthr Isum Isum nfet_03v3 L=0.64u W=0.5u nf=1
Mx1_M2 x1_net1 x1_net1 Isum Isum nfet_03v3 L=0.64u W=0.5u nf=1
MMi1 Im Im VSS VSS nfet_03v3 L=8u W=2u nf=1
MMi2 Iout Im VSS VSS nfet_03v3 L=8u W=2u nf=1
Mx1_M3 x1_net1 VT VDD VDD pfet_03v3 L=0.64u W=0.5u nf=1
Mx1_M4 Im x1_net1 VDD VDD pfet_03v3 L=0.64u W=0.5u nf=1
Cx1_C2 VDD x1_net1 cap_mim_2f0fF W=22.18e-6 L=22.18e-6 m=1
MDNN0 VSS VSS VSS VSS nfet_03v3 L=2u W=0.5u nf=1
MDNN1 VSS VSS VSS VSS nfet_03v3 L=2u W=0.5u nf=1
MDNN2 VSS VSS VSS VSS nfet_03v3 L=2u W=0.5u nf=1
MDNN3 VSS VSS VSS VSS nfet_03v3 L=2u W=0.5u nf=1
MDNN4 VSS VSS VSS VSS nfet_03v3 L=2u W=0.5u nf=1
MDNN5 VSS VSS VSS VSS nfet_03v3 L=2u W=0.5u nf=1
MDNN6 VSS VSS VSS VSS nfet_03v3 L=2u W=0.5u nf=1
MDNN7 VSS VSS VSS VSS nfet_03v3 L=2u W=0.5u nf=1
MDNN8 VSS VSS VSS VSS nfet_03v3 L=2u W=0.5u nf=1
MDNN9 VSS VSS VSS VSS nfet_03v3 L=2u W=0.5u nf=1
MDNS0 VSS VSS VSS VSS nfet_03v3 L=2u W=0.5u nf=1
MDNS1 VSS VSS VSS VSS nfet_03v3 L=2u W=0.5u nf=1
MDNS2 VSS VSS VSS VSS nfet_03v3 L=2u W=0.5u nf=1
MDNS3 VSS VSS VSS VSS nfet_03v3 L=2u W=0.5u nf=1
MDNS4 VSS VSS VSS VSS nfet_03v3 L=2u W=0.5u nf=1
MDNS5 VSS VSS VSS VSS nfet_03v3 L=2u W=0.5u nf=1
MDNS6 VSS VSS VSS VSS nfet_03v3 L=2u W=0.5u nf=1
MDNS7 VSS VSS VSS VSS nfet_03v3 L=2u W=0.5u nf=1
MDNS8 VSS VSS VSS VSS nfet_03v3 L=2u W=0.5u nf=1
MDNS9 VSS VSS VSS VSS nfet_03v3 L=2u W=0.5u nf=1
MDNW0 VSS VSS VSS VSS nfet_03v3 L=2u W=2u nf=1
MDNE0 VSS VSS VSS VSS nfet_03v3 L=2u W=2u nf=1
MDNI1N0 Isum Isum Isum Isum nfet_03v3 L=2u W=0.5u nf=1
MDNI1N1 Isum Isum Isum Isum nfet_03v3 L=2u W=0.5u nf=1
MDNI1N2 Isum Isum Isum Isum nfet_03v3 L=2u W=0.5u nf=1
MDNI1N3 Isum Isum Isum Isum nfet_03v3 L=2u W=0.5u nf=1
MDNI1N4 Isum Isum Isum Isum nfet_03v3 L=2u W=0.5u nf=1
MDNI1S0 Isum Isum Isum Isum nfet_03v3 L=2u W=0.5u nf=1
MDNI1S1 Isum Isum Isum Isum nfet_03v3 L=2u W=0.5u nf=1
MDNI1S2 Isum Isum Isum Isum nfet_03v3 L=2u W=0.5u nf=1
MDNI1S3 Isum Isum Isum Isum nfet_03v3 L=2u W=0.5u nf=1
MDNI1S4 Isum Isum Isum Isum nfet_03v3 L=2u W=0.5u nf=1
MDNI1W0 Isum Isum Isum Isum nfet_03v3 L=2u W=0.5u nf=1
MDNI1E0 Isum Isum Isum Isum nfet_03v3 L=2u W=0.5u nf=1
MDPN0 VDD VDD VDD VDD pfet_03v3 L=2u W=0.5u nf=1
MDPN1 VDD VDD VDD VDD pfet_03v3 L=2u W=0.5u nf=1
MDPN2 VDD VDD VDD VDD pfet_03v3 L=2u W=0.5u nf=1
MDPN3 VDD VDD VDD VDD pfet_03v3 L=2u W=0.5u nf=1
MDPN4 VDD VDD VDD VDD pfet_03v3 L=2u W=0.5u nf=1
MDPS0 VDD VDD VDD VDD pfet_03v3 L=2u W=0.5u nf=1
MDPS1 VDD VDD VDD VDD pfet_03v3 L=2u W=0.5u nf=1
MDPS2 VDD VDD VDD VDD pfet_03v3 L=2u W=0.5u nf=1
MDPS3 VDD VDD VDD VDD pfet_03v3 L=2u W=0.5u nf=1
MDPS4 VDD VDD VDD VDD pfet_03v3 L=2u W=0.5u nf=1
MDPW0 VDD VDD VDD VDD pfet_03v3 L=2u W=0.5u nf=1
MDPE0 VDD VDD VDD VDD pfet_03v3 L=2u W=0.5u nf=1
.ends
