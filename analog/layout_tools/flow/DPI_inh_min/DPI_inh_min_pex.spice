* NGSPICE file created from DPI_inh_min_flat.ext - technology: gf180mcuD

.subckt DPI_inh_min_flat Vthr Isum Iout VT VSS VDD
X0 VSS.t32 VSS.t30 VSS.t32 VSS.t31 nfet_03v3 ad=1.2p pd=5.2u as=0 ps=0 w=2u l=2u
X1 VSS.t39 VSS.t38 VSS.t39 VSS.t4 nfet_03v3 ad=0.14p pd=1.06u as=0 ps=0 w=0.5u l=2u
X2 Isum.t8 Isum.t6 Isum.t8 Isum.t7 nfet_03v3 ad=0.14p pd=1.06u as=0 ps=0 w=0.5u l=2u
X3 VDD.t27 VDD.t26 VDD.t27 VDD.t6 pfet_03v3 ad=0.3p pd=2.2u as=0 ps=0 w=0.5u l=2u
X4 VDD.t4 Vthr Isum.t34 Isum.t33 nfet_03v3 ad=0.3p pd=2.2u as=0.3p ps=2.2u w=0.5u l=0.64u
X5 VSS.t41 VSS.t40 VSS.t41 VSS.t7 nfet_03v3 ad=0.14p pd=1.06u as=0 ps=0 w=0.5u l=2u
X6 VSS.t17 VSS.t15 VSS.t17 VSS.t16 nfet_03v3 ad=0.14p pd=1.06u as=0 ps=0 w=0.5u l=2u
X7 VDD.t16 VDD.t14 VDD.t16 VDD.t15 pfet_03v3 ad=0.14p pd=1.06u as=0 ps=0 w=0.5u l=2u
X8 VDD.t19 VDD.t17 VDD.t19 VDD.t18 pfet_03v3 ad=0.14p pd=1.06u as=0 ps=0 w=0.5u l=2u
X9 VSS.t11 VSS.t9 VSS.t11 VSS.t10 nfet_03v3 ad=0.14p pd=1.06u as=0 ps=0 w=0.5u l=2u
X10 Isum.t5 Isum.t3 Isum.t5 Isum.t4 nfet_03v3 ad=0.14p pd=1.06u as=0 ps=0 w=0.5u l=2u
X11 VDD.t3 a_4290_5135# a_190_n489# VDD.t2 pfet_03v3 ad=0.3p pd=2.2u as=0.3p ps=2.2u w=0.5u l=0.64u
X12 VDD.t25 VDD.t23 VDD.t25 VDD.t24 pfet_03v3 ad=0.3p pd=2.2u as=0 ps=0 w=0.5u l=2u
X13 VSS.t29 VSS.t27 VSS.t29 VSS.t28 nfet_03v3 ad=0.14p pd=1.06u as=0 ps=0 w=0.5u l=2u
X14 VDD.t22 VDD.t20 VDD.t22 VDD.t21 pfet_03v3 ad=0.3p pd=2.2u as=0 ps=0 w=0.5u l=2u
X15 VSS.t5 VSS.t3 VSS.t5 VSS.t4 nfet_03v3 ad=0.14p pd=1.06u as=0 ps=0 w=0.5u l=2u
X16 VSS.t37 VSS.t36 VSS.t37 VSS.t1 nfet_03v3 ad=0.3p pd=2.2u as=0 ps=0 w=0.5u l=2u
X17 Isum.t24 Isum.t23 Isum.t24 Isum.t4 nfet_03v3 ad=0.14p pd=1.06u as=0 ps=0 w=0.5u l=2u
X18 VSS.t23 VSS.t21 VSS.t23 VSS.t22 nfet_03v3 ad=0.14p pd=1.06u as=0 ps=0 w=0.5u l=2u
X19 VSS.t45 VSS.t44 VSS.t45 VSS.t13 nfet_03v3 ad=0.14p pd=1.06u as=0 ps=0 w=0.5u l=2u
X20 VSS.t51 VSS.t50 VSS.t51 VSS.t22 nfet_03v3 ad=0.14p pd=1.06u as=0 ps=0 w=0.5u l=2u
X21 a_4290_5135# a_4290_5135# Isum.t32 Isum.t31 nfet_03v3 ad=0.3p pd=2.2u as=0.3p ps=2.2u w=0.5u l=0.64u
X22 Isum.t11 Isum.t9 Isum.t11 Isum.t10 nfet_03v3 ad=0.14p pd=1.06u as=0 ps=0 w=0.5u l=2u
X23 VDD.t31 VDD.t30 VDD.t31 VDD.t12 pfet_03v3 ad=0.14p pd=1.06u as=0 ps=0 w=0.5u l=2u
X24 VSS.t2 VSS.t0 VSS.t2 VSS.t1 nfet_03v3 ad=0.3p pd=2.2u as=0 ps=0 w=0.5u l=2u
X25 VDD.t29 VDD.t28 VDD.t29 VDD.t9 pfet_03v3 ad=0.14p pd=1.06u as=0 ps=0 w=0.5u l=2u
X26 VSS.t8 VSS.t6 VSS.t8 VSS.t7 nfet_03v3 ad=0.14p pd=1.06u as=0 ps=0 w=0.5u l=2u
X27 Isum.t30 Isum.t29 Isum.t30 Isum.t13 nfet_03v3 ad=0.14p pd=1.06u as=0 ps=0 w=0.5u l=2u
X28 VDD.t7 VDD.t5 VDD.t7 VDD.t6 pfet_03v3 ad=0.3p pd=2.2u as=0 ps=0 w=0.5u l=2u
X29 Isum.t28 Isum.t27 Isum.t28 Isum.t10 nfet_03v3 ad=0.14p pd=1.06u as=0 ps=0 w=0.5u l=2u
X30 VSS.t55 VSS.t54 VSS.t55 VSS.t28 nfet_03v3 ad=0.14p pd=1.06u as=0 ps=0 w=0.5u l=2u
X31 VSS.t43 VSS.t42 VSS.t43 VSS.t10 nfet_03v3 ad=0.14p pd=1.06u as=0 ps=0 w=0.5u l=2u
X32 VDD.t35 VDD.t34 VDD.t35 VDD.t18 pfet_03v3 ad=0.14p pd=1.06u as=0 ps=0 w=0.5u l=2u
X33 Isum.t20 Isum.t18 Isum.t20 Isum.t19 nfet_03v3 ad=0.3p pd=2.2u as=0 ps=0 w=0.5u l=2u
X34 VDD.t33 VDD.t32 VDD.t33 VDD.t15 pfet_03v3 ad=0.14p pd=1.06u as=0 ps=0 w=0.5u l=2u
X35 VSS.t35 VSS.t33 VSS.t35 VSS.t34 nfet_03v3 ad=1.2p pd=5.2u as=0 ps=0 w=2u l=2u
X36 Isum.t17 Isum.t15 Isum.t17 Isum.t16 nfet_03v3 ad=0.3p pd=2.2u as=0 ps=0 w=0.5u l=2u
X37 a_190_n489# a_190_n489# VSS.t59 VSS.t58 nfet_03v3 ad=1.2p pd=5.2u as=1.2p ps=5.2u w=2u l=8u
X38 VSS.t14 VSS.t12 VSS.t14 VSS.t13 nfet_03v3 ad=0.14p pd=1.06u as=0 ps=0 w=0.5u l=2u
X39 Isum.t2 Isum.t0 Isum.t2 Isum.t1 nfet_03v3 ad=0.3p pd=2.2u as=0 ps=0 w=0.5u l=2u
X40 VDD.t13 VDD.t11 VDD.t13 VDD.t12 pfet_03v3 ad=0.14p pd=1.06u as=0 ps=0 w=0.5u l=2u
X41 VDD.t36 a_4290_5135# cap_mim_2f0_m4m5_noshield c_width=22.18u c_length=22.18u
X42 VDD.t10 VDD.t8 VDD.t10 VDD.t9 pfet_03v3 ad=0.14p pd=1.06u as=0 ps=0 w=0.5u l=2u
X43 VSS.t26 VSS.t24 VSS.t26 VSS.t25 nfet_03v3 ad=0.14p pd=1.06u as=0 ps=0 w=0.5u l=2u
X44 VSS.t47 VSS.t46 VSS.t47 VSS.t16 nfet_03v3 ad=0.14p pd=1.06u as=0 ps=0 w=0.5u l=2u
X45 Iout.t0 a_190_n489# VSS.t57 VSS.t56 nfet_03v3 ad=1.2p pd=5.2u as=1.2p ps=5.2u w=2u l=8u
X46 Isum.t14 Isum.t12 Isum.t14 Isum.t13 nfet_03v3 ad=0.14p pd=1.06u as=0 ps=0 w=0.5u l=2u
X47 VDD.t1 VT.t0 a_4290_5135# VDD.t0 pfet_03v3 ad=0.3p pd=2.2u as=0.3p ps=2.2u w=0.5u l=0.64u
X48 VSS.t49 VSS.t48 VSS.t49 VSS.t19 nfet_03v3 ad=0.14p pd=1.06u as=0 ps=0 w=0.5u l=2u
X49 Isum.t22 Isum.t21 Isum.t22 Isum.t1 nfet_03v3 ad=0.3p pd=2.2u as=0 ps=0 w=0.5u l=2u
X50 VSS.t20 VSS.t18 VSS.t20 VSS.t19 nfet_03v3 ad=0.14p pd=1.06u as=0 ps=0 w=0.5u l=2u
X51 VSS.t53 VSS.t52 VSS.t53 VSS.t25 nfet_03v3 ad=0.14p pd=1.06u as=0 ps=0 w=0.5u l=2u
X52 Isum.t26 Isum.t25 Isum.t26 Isum.t7 nfet_03v3 ad=0.14p pd=1.06u as=0 ps=0 w=0.5u l=2u
R0 Iout Iout.t0 19.3896
R1 VT VT.t0 34.6374
R2 Isum.n497 Isum.n74 29361.9
R3 Isum.n1103 Isum.n499 269.014
R4 Isum.n934 Isum.n919 269.014
R5 Isum.n1103 Isum.n500 269.014
R6 Isum.n340 Isum.n335 251.32
R7 Isum.n1106 Isum.n140 251.32
R8 Isum.n1106 Isum.n496 251.32
R9 Isum.n1138 Isum.n106 163.237
R10 Isum.n1138 Isum.n92 163.237
R11 Isum.n1087 Isum.n523 163.237
R12 Isum.n1087 Isum.n522 163.237
R13 Isum.n214 Isum.n212 145.639
R14 Isum.n1122 Isum.n123 145.639
R15 Isum.n407 Isum.n212 145.639
R16 Isum.n1122 Isum.n118 145.639
R17 Isum.n1104 Isum.n498 130.847
R18 Isum.n1105 Isum.n1104 103.909
R19 Isum.n919 Isum.n918 86.9464
R20 Isum.n507 Isum.n498 76.9691
R21 Isum.n1096 Isum.n507 76.9691
R22 Isum.n1096 Isum.n508 76.9691
R23 Isum.n1090 Isum.n508 76.9691
R24 Isum.n1090 Isum.n1089 76.9691
R25 Isum.n631 Isum.n521 76.9691
R26 Isum.n1002 Isum.n631 76.9691
R27 Isum.n1074 Isum.n542 76.9691
R28 Isum.n1074 Isum.n545 76.9691
R29 Isum.n1068 Isum.n556 76.9691
R30 Isum.n1062 Isum.n556 76.9691
R31 Isum.n1062 Isum.n566 76.9691
R32 Isum.n1056 Isum.n566 76.9691
R33 Isum.n1056 Isum.n576 76.9691
R34 Isum.n1050 Isum.n576 76.9691
R35 Isum.n1044 Isum.n601 76.9691
R36 Isum.n1044 Isum.n1035 76.9691
R37 Isum.n1194 Isum.n6 76.9691
R38 Isum.n1194 Isum.n8 76.9691
R39 Isum.n1188 Isum.n21 76.9691
R40 Isum.n1182 Isum.n21 76.9691
R41 Isum.n1176 Isum.n40 76.9691
R42 Isum.n1176 Isum.n43 76.9691
R43 Isum.n1170 Isum.n43 76.9691
R44 Isum.n1170 Isum.n53 76.9691
R45 Isum.n1164 Isum.n53 76.9691
R46 Isum.n1164 Isum.n63 76.9691
R47 Isum.n1152 Isum.n82 76.9691
R48 Isum.n1146 Isum.n96 76.9691
R49 Isum.n1140 Isum.n96 76.9691
R50 Isum.n943 Isum.n105 76.9691
R51 Isum.n943 Isum.n908 76.9691
R52 Isum.n937 Isum.n908 76.9691
R53 Isum.n937 Isum.n936 76.9691
R54 Isum.n936 Isum.n935 76.9691
R55 Isum.n497 Isum.n139 74.0746
R56 Isum.n1088 Isum.n521 61.5754
R57 Isum.n553 Isum.n545 61.5754
R58 Isum.n601 Isum.n586 61.5754
R59 Isum.n1182 Isum.n32 61.5754
R60 Isum.n1158 Isum.n71 61.5754
R61 Isum.n1140 Isum.n1139 61.5754
R62 Isum.n340 Isum.n339 59.4477
R63 Isum.n82 Isum.n74 55.8027
R64 Isum.n1080 Isum.n530 52.9164
R65 Isum.n953 Isum.n93 52.9164
R66 Isum.n346 Isum.n336 52.9106
R67 Isum.n346 Isum.n330 52.9106
R68 Isum.n354 Isum.n330 52.9106
R69 Isum.n354 Isum.n323 52.9106
R70 Isum.n398 Isum.n323 52.9106
R71 Isum.n406 Isum.n213 52.9106
R72 Isum.n406 Isum.n317 52.9106
R73 Isum.n414 Isum.n199 52.9106
R74 Isum.n422 Isum.n199 52.9106
R75 Isum.n430 Isum.n191 52.9106
R76 Isum.t7 Isum.n182 52.9106
R77 Isum.t7 Isum.n185 52.9106
R78 Isum.n451 Isum.n174 52.9106
R79 Isum.n461 Isum.n151 52.9106
R80 Isum.n477 Isum.n151 52.9106
R81 Isum.n1128 Isum.n116 52.9106
R82 Isum.n124 Isum.n116 52.9106
R83 Isum.n1120 Isum.n126 52.9106
R84 Isum.n1114 Isum.n126 52.9106
R85 Isum.n1114 Isum.n1113 52.9106
R86 Isum.n1113 Isum.n1112 52.9106
R87 Isum.n1112 Isum.n139 52.9106
R88 Isum.t31 Isum.n182 50.9264
R89 Isum.n185 Isum.t33 50.9264
R90 Isum.n1080 Isum.n533 46.1817
R91 Isum.n1034 Isum.n6 46.1817
R92 Isum.n18 Isum.n8 46.1817
R93 Isum.n953 Isum.n85 46.1817
R94 Isum.n422 Isum.t10 42.3285
R95 Isum.n461 Isum.t4 42.3285
R96 Isum.n397 Isum.n213 32.0772
R97 Isum.n1121 Isum.n124 32.0772
R98 Isum.n542 Isum.n533 30.7879
R99 Isum.n1035 Isum.n1034 30.7879
R100 Isum.n1188 Isum.n18 30.7879
R101 Isum.n1152 Isum.n85 30.7879
R102 Isum.n317 Isum.t19 27.1169
R103 Isum.n1128 Isum.t16 27.1169
R104 Isum.n469 Isum.t32 26.4763
R105 Isum.n469 Isum.t34 25.9111
R106 Isum.n1002 Isum.n530 24.0532
R107 Isum.n1146 Isum.n93 24.0532
R108 Isum.n1134 Isum.n1132 22.1099
R109 Isum.n1158 Isum.n74 21.1669
R110 Isum.n414 Isum.t13 21.1645
R111 Isum.n477 Isum.t1 21.1645
R112 Isum.n398 Isum.n397 20.8338
R113 Isum.n1121 Isum.n1120 20.8338
R114 Isum.n314 Isum.n219 15.8697
R115 Isum.n472 Isum.n158 15.8697
R116 Isum.n674 Isum.n634 15.8697
R117 Isum.n711 Isum.n710 15.8697
R118 Isum.n509 Isum.n499 15.5561
R119 Isum.n1095 Isum.n509 15.5561
R120 Isum.n1095 Isum.n510 15.5561
R121 Isum.n1091 Isum.n510 15.5561
R122 Isum.n1091 Isum.n518 15.5561
R123 Isum.n623 Isum.n518 15.5561
R124 Isum.n630 Isum.n623 15.5561
R125 Isum.n630 Isum.n534 15.5561
R126 Isum.n1079 Isum.n534 15.5561
R127 Isum.n1079 Isum.n535 15.5561
R128 Isum.n1075 Isum.n535 15.5561
R129 Isum.n1075 Isum.n541 15.5561
R130 Isum.n1067 Isum.n541 15.5561
R131 Isum.n1067 Isum.n557 15.5561
R132 Isum.n1063 Isum.n557 15.5561
R133 Isum.n1063 Isum.n563 15.5561
R134 Isum.n1055 Isum.n563 15.5561
R135 Isum.n1055 Isum.n577 15.5561
R136 Isum.n1051 Isum.n577 15.5561
R137 Isum.n1051 Isum.n583 15.5561
R138 Isum.n1043 Isum.n583 15.5561
R139 Isum.n1043 Isum.n1036 15.5561
R140 Isum.n1036 Isum.n10 15.5561
R141 Isum.n1193 Isum.n10 15.5561
R142 Isum.n1193 Isum.n11 15.5561
R143 Isum.n1189 Isum.n11 15.5561
R144 Isum.n1189 Isum.n17 15.5561
R145 Isum.n1181 Isum.n17 15.5561
R146 Isum.n1181 Isum.n33 15.5561
R147 Isum.n1177 Isum.n33 15.5561
R148 Isum.n1177 Isum.n39 15.5561
R149 Isum.n1169 Isum.n39 15.5561
R150 Isum.n1169 Isum.n54 15.5561
R151 Isum.n1165 Isum.n54 15.5561
R152 Isum.n1165 Isum.n60 15.5561
R153 Isum.n1157 Isum.n60 15.5561
R154 Isum.n1157 Isum.n75 15.5561
R155 Isum.n1153 Isum.n75 15.5561
R156 Isum.n1153 Isum.n81 15.5561
R157 Isum.n1145 Isum.n81 15.5561
R158 Isum.n1145 Isum.n97 15.5561
R159 Isum.n1141 Isum.n97 15.5561
R160 Isum.n1141 Isum.n103 15.5561
R161 Isum.n942 Isum.n103 15.5561
R162 Isum.n942 Isum.n909 15.5561
R163 Isum.n938 Isum.n909 15.5561
R164 Isum.n938 Isum.n915 15.5561
R165 Isum.n934 Isum.n915 15.5561
R166 Isum.n503 Isum.n500 15.5561
R167 Isum.n1097 Isum.n503 15.5561
R168 Isum.n1097 Isum.n506 15.5561
R169 Isum.n519 Isum.n506 15.5561
R170 Isum.n520 Isum.n519 15.5561
R171 Isum.n621 Isum.n520 15.5561
R172 Isum.n622 Isum.n621 15.5561
R173 Isum.n1003 Isum.n622 15.5561
R174 Isum.n1003 Isum.n532 15.5561
R175 Isum.n1008 Isum.n532 15.5561
R176 Isum.n1008 Isum.n544 15.5561
R177 Isum.n1011 Isum.n544 15.5561
R178 Isum.n1011 Isum.n555 15.5561
R179 Isum.n1016 Isum.n555 15.5561
R180 Isum.n1016 Isum.n565 15.5561
R181 Isum.n1019 Isum.n565 15.5561
R182 Isum.n1019 Isum.n575 15.5561
R183 Isum.n1024 Isum.n575 15.5561
R184 Isum.n1024 Isum.n585 15.5561
R185 Isum.n1027 Isum.n585 15.5561
R186 Isum.n1027 Isum.n603 15.5561
R187 Isum.n1033 Isum.n603 15.5561
R188 Isum.n1033 Isum.n4 15.5561
R189 Isum.n1195 Isum.n4 15.5561
R190 Isum.n1195 Isum.n5 15.5561
R191 Isum.n20 Isum.n5 15.5561
R192 Isum.n878 Isum.n20 15.5561
R193 Isum.n878 Isum.n31 15.5561
R194 Isum.n881 Isum.n31 15.5561
R195 Isum.n881 Isum.n42 15.5561
R196 Isum.n886 Isum.n42 15.5561
R197 Isum.n886 Isum.n52 15.5561
R198 Isum.n889 Isum.n52 15.5561
R199 Isum.n889 Isum.n62 15.5561
R200 Isum.n894 Isum.n62 15.5561
R201 Isum.n894 Isum.n73 15.5561
R202 Isum.n897 Isum.n73 15.5561
R203 Isum.n897 Isum.n84 15.5561
R204 Isum.n952 Isum.n84 15.5561
R205 Isum.n952 Isum.n95 15.5561
R206 Isum.n948 Isum.n95 15.5561
R207 Isum.n948 Isum.n104 15.5561
R208 Isum.n945 Isum.n104 15.5561
R209 Isum.n945 Isum.n944 15.5561
R210 Isum.n944 Isum.n907 15.5561
R211 Isum.n916 Isum.n907 15.5561
R212 Isum.n917 Isum.n916 15.5561
R213 Isum.n928 Isum.n917 15.5561
R214 Isum.n526 Isum.n523 15.5561
R215 Isum.n1081 Isum.n526 15.5561
R216 Isum.n1081 Isum.n529 15.5561
R217 Isum.n1073 Isum.n529 15.5561
R218 Isum.n1073 Isum.n546 15.5561
R219 Isum.n1069 Isum.n546 15.5561
R220 Isum.n1069 Isum.n552 15.5561
R221 Isum.n1061 Isum.n552 15.5561
R222 Isum.n1061 Isum.n567 15.5561
R223 Isum.n1057 Isum.n567 15.5561
R224 Isum.n1057 Isum.n573 15.5561
R225 Isum.n1049 Isum.n573 15.5561
R226 Isum.n1049 Isum.n587 15.5561
R227 Isum.n1045 Isum.n587 15.5561
R228 Isum.n1045 Isum.n600 15.5561
R229 Isum.n600 Isum.n599 15.5561
R230 Isum.n599 Isum.n9 15.5561
R231 Isum.n22 Isum.n9 15.5561
R232 Isum.n1187 Isum.n22 15.5561
R233 Isum.n1187 Isum.n23 15.5561
R234 Isum.n1183 Isum.n23 15.5561
R235 Isum.n1183 Isum.n29 15.5561
R236 Isum.n1175 Isum.n29 15.5561
R237 Isum.n1175 Isum.n44 15.5561
R238 Isum.n1171 Isum.n44 15.5561
R239 Isum.n1171 Isum.n50 15.5561
R240 Isum.n1163 Isum.n50 15.5561
R241 Isum.n1163 Isum.n64 15.5561
R242 Isum.n1159 Isum.n64 15.5561
R243 Isum.n1159 Isum.n70 15.5561
R244 Isum.n1151 Isum.n70 15.5561
R245 Isum.n1151 Isum.n86 15.5561
R246 Isum.n1147 Isum.n86 15.5561
R247 Isum.n1147 Isum.n92 15.5561
R248 Isum.n1001 Isum.n522 15.5561
R249 Isum.n1001 Isum.n531 15.5561
R250 Isum.n997 Isum.n531 15.5561
R251 Isum.n997 Isum.n543 15.5561
R252 Isum.n994 Isum.n543 15.5561
R253 Isum.n994 Isum.n554 15.5561
R254 Isum.n991 Isum.n554 15.5561
R255 Isum.n991 Isum.n564 15.5561
R256 Isum.n988 Isum.n564 15.5561
R257 Isum.n988 Isum.n574 15.5561
R258 Isum.n985 Isum.n574 15.5561
R259 Isum.n985 Isum.n584 15.5561
R260 Isum.n982 Isum.n584 15.5561
R261 Isum.n982 Isum.n602 15.5561
R262 Isum.n604 Isum.n602 15.5561
R263 Isum.n978 Isum.n604 15.5561
R264 Isum.n978 Isum.n7 15.5561
R265 Isum.n975 Isum.n7 15.5561
R266 Isum.n975 Isum.n19 15.5561
R267 Isum.n972 Isum.n19 15.5561
R268 Isum.n972 Isum.n30 15.5561
R269 Isum.n969 Isum.n30 15.5561
R270 Isum.n969 Isum.n41 15.5561
R271 Isum.n966 Isum.n41 15.5561
R272 Isum.n966 Isum.n51 15.5561
R273 Isum.n963 Isum.n51 15.5561
R274 Isum.n963 Isum.n61 15.5561
R275 Isum.n960 Isum.n61 15.5561
R276 Isum.n960 Isum.n72 15.5561
R277 Isum.n957 Isum.n72 15.5561
R278 Isum.n957 Isum.n83 15.5561
R279 Isum.n954 Isum.n83 15.5561
R280 Isum.n954 Isum.n94 15.5561
R281 Isum.n106 Isum.n94 15.5561
R282 Isum.n347 Isum.n335 15.5561
R283 Isum.n347 Isum.n331 15.5561
R284 Isum.n353 Isum.n331 15.5561
R285 Isum.n353 Isum.n322 15.5561
R286 Isum.n399 Isum.n322 15.5561
R287 Isum.n399 Isum.n318 15.5561
R288 Isum.n405 Isum.n318 15.5561
R289 Isum.n405 Isum.n206 15.5561
R290 Isum.n415 Isum.n206 15.5561
R291 Isum.n415 Isum.n202 15.5561
R292 Isum.n421 Isum.n202 15.5561
R293 Isum.n421 Isum.n190 15.5561
R294 Isum.n431 Isum.n190 15.5561
R295 Isum.n431 Isum.n186 15.5561
R296 Isum.n437 Isum.n186 15.5561
R297 Isum.n437 Isum.n171 15.5561
R298 Isum.n452 Isum.n171 15.5561
R299 Isum.n452 Isum.n166 15.5561
R300 Isum.n460 Isum.n166 15.5561
R301 Isum.n460 Isum.n167 15.5561
R302 Isum.n167 Isum.n112 15.5561
R303 Isum.n1129 Isum.n112 15.5561
R304 Isum.n1129 Isum.n113 15.5561
R305 Isum.n127 Isum.n113 15.5561
R306 Isum.n1119 Isum.n127 15.5561
R307 Isum.n1119 Isum.n128 15.5561
R308 Isum.n1115 Isum.n128 15.5561
R309 Isum.n1115 Isum.n135 15.5561
R310 Isum.n1111 Isum.n135 15.5561
R311 Isum.n1111 Isum.n140 15.5561
R312 Isum.n345 Isum.n337 15.5561
R313 Isum.n345 Isum.n329 15.5561
R314 Isum.n355 Isum.n329 15.5561
R315 Isum.n355 Isum.n324 15.5561
R316 Isum.n396 Isum.n324 15.5561
R317 Isum.n396 Isum.n325 15.5561
R318 Isum.n325 Isum.n215 15.5561
R319 Isum.n391 Isum.n215 15.5561
R320 Isum.n391 Isum.n208 15.5561
R321 Isum.n388 Isum.n208 15.5561
R322 Isum.n388 Isum.n201 15.5561
R323 Isum.n385 Isum.n201 15.5561
R324 Isum.n385 Isum.n193 15.5561
R325 Isum.n382 Isum.n193 15.5561
R326 Isum.n382 Isum.n184 15.5561
R327 Isum.n379 Isum.n184 15.5561
R328 Isum.n379 Isum.n173 15.5561
R329 Isum.n376 Isum.n173 15.5561
R330 Isum.n376 Isum.n164 15.5561
R331 Isum.n164 Isum.n150 15.5561
R332 Isum.n478 Isum.n150 15.5561
R333 Isum.n478 Isum.n115 15.5561
R334 Isum.n482 Isum.n115 15.5561
R335 Isum.n482 Isum.n481 15.5561
R336 Isum.n481 Isum.n125 15.5561
R337 Isum.n488 Isum.n125 15.5561
R338 Isum.n488 Isum.n136 15.5561
R339 Isum.n137 Isum.n136 15.5561
R340 Isum.n138 Isum.n137 15.5561
R341 Isum.n496 Isum.n138 15.5561
R342 Isum.n316 Isum.n214 15.5561
R343 Isum.n316 Isum.n207 15.5561
R344 Isum.n277 Isum.n207 15.5561
R345 Isum.n277 Isum.n200 15.5561
R346 Isum.n278 Isum.n200 15.5561
R347 Isum.n278 Isum.n192 15.5561
R348 Isum.n285 Isum.n192 15.5561
R349 Isum.n285 Isum.n183 15.5561
R350 Isum.n294 Isum.n183 15.5561
R351 Isum.n294 Isum.n172 15.5561
R352 Isum.n172 Isum.n163 15.5561
R353 Isum.n462 Isum.n163 15.5561
R354 Isum.n462 Isum.n152 15.5561
R355 Isum.n476 Isum.n152 15.5561
R356 Isum.n476 Isum.n114 15.5561
R357 Isum.n123 Isum.n114 15.5561
R358 Isum.n407 Isum.n209 15.5561
R359 Isum.n413 Isum.n209 15.5561
R360 Isum.n413 Isum.n198 15.5561
R361 Isum.n423 Isum.n198 15.5561
R362 Isum.n423 Isum.n194 15.5561
R363 Isum.n429 Isum.n194 15.5561
R364 Isum.n429 Isum.n181 15.5561
R365 Isum.n438 Isum.n181 15.5561
R366 Isum.n438 Isum.n175 15.5561
R367 Isum.n450 Isum.n175 15.5561
R368 Isum.n450 Isum.n176 15.5561
R369 Isum.n176 Isum.n165 15.5561
R370 Isum.n443 Isum.n165 15.5561
R371 Isum.n443 Isum.n117 15.5561
R372 Isum.n1127 Isum.n117 15.5561
R373 Isum.n1127 Isum.n118 15.5561
R374 Isum.n1089 Isum.n1088 15.3942
R375 Isum.n1068 Isum.n553 15.3942
R376 Isum.n1050 Isum.n586 15.3942
R377 Isum.n40 Isum.n32 15.3942
R378 Isum.n71 Isum.n63 15.3942
R379 Isum.n1139 Isum.n105 15.3942
R380 Isum.n854 Isum.n853 12.5005
R381 Isum.n746 Isum.n745 12.5005
R382 Isum.n845 Isum.n749 12.5005
R383 Isum.n847 Isum.n846 12.5005
R384 Isum.n842 Isum.n748 12.5005
R385 Isum.n841 Isum.n840 12.5005
R386 Isum.n839 Isum.n751 12.5005
R387 Isum.n829 Isum.n752 12.5005
R388 Isum.n830 Isum.n755 12.5005
R389 Isum.n833 Isum.n832 12.5005
R390 Isum.n827 Isum.n754 12.5005
R391 Isum.n826 Isum.n825 12.5005
R392 Isum.n824 Isum.n823 12.5005
R393 Isum.n822 Isum.n758 12.5005
R394 Isum.n821 Isum.n820 12.5005
R395 Isum.n819 Isum.n818 12.5005
R396 Isum.n817 Isum.n761 12.5005
R397 Isum.n816 Isum.n815 12.5005
R398 Isum.n805 Isum.n764 12.5005
R399 Isum.n807 Isum.n806 12.5005
R400 Isum.n804 Isum.n766 12.5005
R401 Isum.n803 Isum.n802 12.5005
R402 Isum.n801 Isum.n768 12.5005
R403 Isum.n791 Isum.n769 12.5005
R404 Isum.n792 Isum.n772 12.5005
R405 Isum.n795 Isum.n794 12.5005
R406 Isum.n789 Isum.n771 12.5005
R407 Isum.n709 Isum.n663 12.5005
R408 Isum.n708 Isum.n662 12.5005
R409 Isum.n707 Isum.n661 12.5005
R410 Isum.n705 Isum.n660 12.5005
R411 Isum.n704 Isum.n659 12.5005
R412 Isum.n703 Isum.n658 12.5005
R413 Isum.n702 Isum.n657 12.5005
R414 Isum.n701 Isum.n656 12.5005
R415 Isum.n700 Isum.n655 12.5005
R416 Isum.n699 Isum.n654 12.5005
R417 Isum.n697 Isum.n653 12.5005
R418 Isum.n696 Isum.n652 12.5005
R419 Isum.n695 Isum.n651 12.5005
R420 Isum.n693 Isum.n650 12.5005
R421 Isum.n692 Isum.n649 12.5005
R422 Isum.n691 Isum.n648 12.5005
R423 Isum.n689 Isum.n647 12.5005
R424 Isum.n688 Isum.n646 12.5005
R425 Isum.n687 Isum.n645 12.5005
R426 Isum.n685 Isum.n644 12.5005
R427 Isum.n684 Isum.n643 12.5005
R428 Isum.n683 Isum.n642 12.5005
R429 Isum.n682 Isum.n641 12.5005
R430 Isum.n681 Isum.n640 12.5005
R431 Isum.n680 Isum.n639 12.5005
R432 Isum.n679 Isum.n638 12.5005
R433 Isum.n677 Isum.n637 12.5005
R434 Isum.n676 Isum.n636 12.5005
R435 Isum.n675 Isum.n635 12.5005
R436 Isum.n248 Isum.n247 12.5005
R437 Isum.n246 Isum.n245 12.5005
R438 Isum.n235 Isum.n234 12.5005
R439 Isum.n258 Isum.n257 12.5005
R440 Isum.n259 Isum.n227 12.5005
R441 Isum.n261 Isum.n260 12.5005
R442 Isum.n233 Isum.n226 12.5005
R443 Isum.n232 Isum.n231 12.5005
R444 Isum.n230 Isum.n229 12.5005
R445 Isum.n474 Isum.n156 12.5005
R446 Isum.n160 Isum.n155 12.5005
R447 Isum.n464 Isum.n161 12.5005
R448 Isum.n296 Isum.n159 12.5005
R449 Isum.n298 Isum.n297 12.5005
R450 Isum.n301 Isum.n289 12.5005
R451 Isum.n302 Isum.n288 12.5005
R452 Isum.n303 Isum.n287 12.5005
R453 Isum.n306 Isum.n283 12.5005
R454 Isum.n307 Isum.n282 12.5005
R455 Isum.n308 Isum.n280 12.5005
R456 Isum.n311 Isum.n275 12.5005
R457 Isum.n312 Isum.n274 12.5005
R458 Isum.n249 Isum.n248 12.4735
R459 Isum.n229 Isum.n225 12.4729
R460 Isum.t14 Isum.n218 12.1637
R461 Isum.n468 Isum.t2 12.1268
R462 Isum.n866 Isum.n739 12.1268
R463 Isum.n713 Isum.n633 12.1268
R464 Isum.n860 Isum.n742 11.3053
R465 Isum.n783 Isum.n782 11.3053
R466 Isum.t10 Isum.n191 10.5825
R467 Isum.n174 Isum.t4 10.5825
R468 Isum.n471 Isum.n470 10.3523
R469 Isum.n287 Isum.n283 9.86111
R470 Isum.n297 Isum.n289 9.86111
R471 Isum.n681 Isum.n680 9.86111
R472 Isum.n684 Isum.n683 9.86111
R473 Isum.n701 Isum.n700 9.86111
R474 Isum.n704 Isum.n703 9.86111
R475 Isum.n791 Isum.n768 9.86111
R476 Isum.n806 Isum.n804 9.86111
R477 Isum.n829 Isum.n751 9.86111
R478 Isum.n846 Isum.n842 9.86111
R479 Isum.n260 Isum.n233 9.86111
R480 Isum.n258 Isum.n234 9.86111
R481 Isum.n785 Isum.n770 9.8285
R482 Isum.n858 Isum.n744 9.8285
R483 Isum.n270 Isum.t20 9.8285
R484 Isum.n272 Isum.t20 9.8285
R485 Isum.n267 Isum.t30 9.8285
R486 Isum.n239 Isum.t17 9.8285
R487 Isum.t17 Isum.n237 9.8285
R488 Isum.n251 Isum.t22 9.8285
R489 Isum.n470 Isum 9.4505
R490 Isum.n280 Isum.n275 8.95142
R491 Isum.n161 Isum.n160 8.95142
R492 Isum.n677 Isum.n676 8.95142
R493 Isum.n688 Isum.n687 8.95142
R494 Isum.n697 Isum.n696 8.95142
R495 Isum.n708 Isum.n707 8.95142
R496 Isum.n794 Isum.n789 8.95142
R497 Isum.n817 Isum.n816 8.95142
R498 Isum.n832 Isum.n827 8.95142
R499 Isum.n854 Isum.n745 8.95142
R500 Isum.n466 Isum.n465 8.63568
R501 Isum.n291 Isum.n284 8.63568
R502 Isum.n738 Isum.n737 8.63568
R503 Isum.n732 Isum.n731 8.63568
R504 Isum.n726 Isum.n649 8.63568
R505 Isum.n721 Isum.n720 8.63568
R506 Isum.n715 Isum.n714 8.63568
R507 Isum.n852 Isum.n851 8.63568
R508 Isum.n838 Isum.n837 8.63568
R509 Isum.n811 Isum.n758 8.63568
R510 Isum.n809 Isum.n808 8.63568
R511 Isum.n797 Isum.n796 8.63568
R512 Isum.n263 Isum.n262 8.63568
R513 Isum.n293 Isum.n292 8.59884
R514 Isum.n290 Isum.n276 8.59884
R515 Isum.n735 Isum.n734 8.59884
R516 Isum.n729 Isum.n728 8.59884
R517 Isum.n724 Isum.n723 8.59884
R518 Isum.n718 Isum.n717 8.59884
R519 Isum.n849 Isum.n848 8.59884
R520 Isum.n835 Isum.n834 8.59884
R521 Isum.n814 Isum.n813 8.59884
R522 Isum.n800 Isum.n799 8.59884
R523 Isum.n256 Isum.n255 8.59884
R524 Isum.n241 Isum.t15 8.56785
R525 Isum.n269 Isum.t18 8.56785
R526 Isum.n692 Isum.n691 7.7385
R527 Isum.n693 Isum.n692 7.7385
R528 Isum.n822 Isum.n821 7.7385
R529 Isum.n823 Isum.n822 7.7385
R530 Isum.n1105 Isum.n497 7.69736
R531 Isum.n789 Isum.n788 7.44316
R532 Isum.n856 Isum.n854 7.44316
R533 Isum.n1102 Isum.n1101 7.21377
R534 Isum.n1102 Isum.n501 7.21377
R535 Isum.n931 Isum.n930 7.12426
R536 Isum.n932 Isum.n931 7.12426
R537 Isum.n1108 Isum.n1107 7.03823
R538 Isum.n341 Isum.n333 7.03823
R539 Isum.n342 Isum.n341 7.03823
R540 Isum.n1107 Isum.n143 7.03823
R541 Isum.n275 Isum.n274 6.52558
R542 Isum.n160 Isum.n156 6.52558
R543 Isum.n676 Isum.n675 6.52558
R544 Isum.n689 Isum.n688 6.52558
R545 Isum.n696 Isum.n695 6.52558
R546 Isum.n709 Isum.n708 6.52558
R547 Isum.n818 Isum.n817 6.52558
R548 Isum.n827 Isum.n826 6.52558
R549 Isum.n857 Isum.n856 6.51288
R550 Isum.n788 Isum.n786 6.51288
R551 Isum.n265 Isum.n264 6.3005
R552 Isum.n254 Isum.n253 6.3005
R553 Isum.n1137 Isum.n1136 6.14817
R554 Isum.n1086 Isum.n1085 6.14817
R555 Isum.n1086 Isum.n524 6.14817
R556 Isum.n1137 Isum.n1135 6.13016
R557 Isum.n1124 Isum.n1123 5.97353
R558 Isum.n409 Isum.n211 5.97353
R559 Isum.n1123 Isum.n122 5.85293
R560 Isum.n221 Isum.n211 5.85293
R561 Isum.n283 Isum.n282 5.61588
R562 Isum.n288 Isum.n287 5.61588
R563 Isum.n289 Isum.n288 5.61588
R564 Isum.n297 Isum.n296 5.61588
R565 Isum.n680 Isum.n679 5.61588
R566 Isum.n682 Isum.n681 5.61588
R567 Isum.n683 Isum.n682 5.61588
R568 Isum.n685 Isum.n684 5.61588
R569 Isum.n700 Isum.n699 5.61588
R570 Isum.n702 Isum.n701 5.61588
R571 Isum.n703 Isum.n702 5.61588
R572 Isum.n705 Isum.n704 5.61588
R573 Isum.n792 Isum.n791 5.61588
R574 Isum.n803 Isum.n768 5.61588
R575 Isum.n804 Isum.n803 5.61588
R576 Isum.n806 Isum.n805 5.61588
R577 Isum.n830 Isum.n829 5.61588
R578 Isum.n841 Isum.n751 5.61588
R579 Isum.n842 Isum.n841 5.61588
R580 Isum.n846 Isum.n845 5.61588
R581 Isum.n233 Isum.n232 5.61588
R582 Isum.n260 Isum.n259 5.61588
R583 Isum.n259 Isum.n258 5.61588
R584 Isum.n245 Isum.n234 5.61588
R585 Isum.n1135 Isum.n1134 5.4941
R586 Isum.n867 Isum.n106 5.2005
R587 Isum.n106 Isum.n96 5.2005
R588 Isum.n868 Isum.n94 5.2005
R589 Isum.n1146 Isum.n94 5.2005
R590 Isum.n955 Isum.n954 5.2005
R591 Isum.n954 Isum.n953 5.2005
R592 Isum.n956 Isum.n83 5.2005
R593 Isum.n1152 Isum.n83 5.2005
R594 Isum.n958 Isum.n957 5.2005
R595 Isum.n957 Isum.n82 5.2005
R596 Isum.n959 Isum.n72 5.2005
R597 Isum.n1158 Isum.n72 5.2005
R598 Isum.n961 Isum.n960 5.2005
R599 Isum.n960 Isum.n63 5.2005
R600 Isum.n962 Isum.n61 5.2005
R601 Isum.n1164 Isum.n61 5.2005
R602 Isum.n964 Isum.n963 5.2005
R603 Isum.n963 Isum.n53 5.2005
R604 Isum.n965 Isum.n51 5.2005
R605 Isum.n1170 Isum.n51 5.2005
R606 Isum.n967 Isum.n966 5.2005
R607 Isum.n966 Isum.n43 5.2005
R608 Isum.n968 Isum.n41 5.2005
R609 Isum.n1176 Isum.n41 5.2005
R610 Isum.n970 Isum.n969 5.2005
R611 Isum.n969 Isum.n40 5.2005
R612 Isum.n971 Isum.n30 5.2005
R613 Isum.n1182 Isum.n30 5.2005
R614 Isum.n973 Isum.n972 5.2005
R615 Isum.n972 Isum.n21 5.2005
R616 Isum.n974 Isum.n19 5.2005
R617 Isum.n1188 Isum.n19 5.2005
R618 Isum.n976 Isum.n975 5.2005
R619 Isum.n975 Isum.n8 5.2005
R620 Isum.n977 Isum.n7 5.2005
R621 Isum.n1194 Isum.n7 5.2005
R622 Isum.n979 Isum.n978 5.2005
R623 Isum.n978 Isum.n6 5.2005
R624 Isum.n980 Isum.n604 5.2005
R625 Isum.n1035 Isum.n604 5.2005
R626 Isum.n981 Isum.n602 5.2005
R627 Isum.n1044 Isum.n602 5.2005
R628 Isum.n983 Isum.n982 5.2005
R629 Isum.n982 Isum.n601 5.2005
R630 Isum.n984 Isum.n584 5.2005
R631 Isum.n1050 Isum.n584 5.2005
R632 Isum.n986 Isum.n985 5.2005
R633 Isum.n985 Isum.n576 5.2005
R634 Isum.n987 Isum.n574 5.2005
R635 Isum.n1056 Isum.n574 5.2005
R636 Isum.n989 Isum.n988 5.2005
R637 Isum.n988 Isum.n566 5.2005
R638 Isum.n990 Isum.n564 5.2005
R639 Isum.n1062 Isum.n564 5.2005
R640 Isum.n992 Isum.n991 5.2005
R641 Isum.n991 Isum.n556 5.2005
R642 Isum.n993 Isum.n554 5.2005
R643 Isum.n1068 Isum.n554 5.2005
R644 Isum.n995 Isum.n994 5.2005
R645 Isum.n994 Isum.n545 5.2005
R646 Isum.n996 Isum.n543 5.2005
R647 Isum.n1074 Isum.n543 5.2005
R648 Isum.n998 Isum.n997 5.2005
R649 Isum.n997 Isum.n542 5.2005
R650 Isum.n999 Isum.n531 5.2005
R651 Isum.n1080 Isum.n531 5.2005
R652 Isum.n1001 Isum.n1000 5.2005
R653 Isum.n1002 Isum.n1001 5.2005
R654 Isum.n632 Isum.n522 5.2005
R655 Isum.n631 Isum.n522 5.2005
R656 Isum.n92 Isum.n91 5.2005
R657 Isum.n96 Isum.n92 5.2005
R658 Isum.n1148 Isum.n1147 5.2005
R659 Isum.n1147 Isum.n1146 5.2005
R660 Isum.n1149 Isum.n86 5.2005
R661 Isum.n953 Isum.n86 5.2005
R662 Isum.n1151 Isum.n1150 5.2005
R663 Isum.n1152 Isum.n1151 5.2005
R664 Isum.n70 Isum.n69 5.2005
R665 Isum.n82 Isum.n70 5.2005
R666 Isum.n1160 Isum.n1159 5.2005
R667 Isum.n1159 Isum.n1158 5.2005
R668 Isum.n1161 Isum.n64 5.2005
R669 Isum.n64 Isum.n63 5.2005
R670 Isum.n1163 Isum.n1162 5.2005
R671 Isum.n1164 Isum.n1163 5.2005
R672 Isum.n50 Isum.n49 5.2005
R673 Isum.n53 Isum.n50 5.2005
R674 Isum.n1172 Isum.n1171 5.2005
R675 Isum.n1171 Isum.n1170 5.2005
R676 Isum.n1173 Isum.n44 5.2005
R677 Isum.n44 Isum.n43 5.2005
R678 Isum.n1175 Isum.n1174 5.2005
R679 Isum.n1176 Isum.n1175 5.2005
R680 Isum.n29 Isum.n28 5.2005
R681 Isum.n40 Isum.n29 5.2005
R682 Isum.n1184 Isum.n1183 5.2005
R683 Isum.n1183 Isum.n1182 5.2005
R684 Isum.n1185 Isum.n23 5.2005
R685 Isum.n23 Isum.n21 5.2005
R686 Isum.n1187 Isum.n1186 5.2005
R687 Isum.n1188 Isum.n1187 5.2005
R688 Isum.n24 Isum.n22 5.2005
R689 Isum.n22 Isum.n8 5.2005
R690 Isum.n597 Isum.n9 5.2005
R691 Isum.n1194 Isum.n9 5.2005
R692 Isum.n599 Isum.n598 5.2005
R693 Isum.n599 Isum.n6 5.2005
R694 Isum.n600 Isum.n592 5.2005
R695 Isum.n1035 Isum.n600 5.2005
R696 Isum.n1046 Isum.n1045 5.2005
R697 Isum.n1045 Isum.n1044 5.2005
R698 Isum.n1047 Isum.n587 5.2005
R699 Isum.n601 Isum.n587 5.2005
R700 Isum.n1049 Isum.n1048 5.2005
R701 Isum.n1050 Isum.n1049 5.2005
R702 Isum.n573 Isum.n572 5.2005
R703 Isum.n576 Isum.n573 5.2005
R704 Isum.n1058 Isum.n1057 5.2005
R705 Isum.n1057 Isum.n1056 5.2005
R706 Isum.n1059 Isum.n567 5.2005
R707 Isum.n567 Isum.n566 5.2005
R708 Isum.n1061 Isum.n1060 5.2005
R709 Isum.n1062 Isum.n1061 5.2005
R710 Isum.n552 Isum.n551 5.2005
R711 Isum.n556 Isum.n552 5.2005
R712 Isum.n1070 Isum.n1069 5.2005
R713 Isum.n1069 Isum.n1068 5.2005
R714 Isum.n1071 Isum.n546 5.2005
R715 Isum.n546 Isum.n545 5.2005
R716 Isum.n1073 Isum.n1072 5.2005
R717 Isum.n1074 Isum.n1073 5.2005
R718 Isum.n529 Isum.n528 5.2005
R719 Isum.n542 Isum.n529 5.2005
R720 Isum.n1082 Isum.n1081 5.2005
R721 Isum.n1081 Isum.n1080 5.2005
R722 Isum.n1083 Isum.n526 5.2005
R723 Isum.n1002 Isum.n526 5.2005
R724 Isum.n1084 Isum.n523 5.2005
R725 Isum.n631 Isum.n523 5.2005
R726 Isum.n929 Isum.n928 5.2005
R727 Isum.n927 Isum.n917 5.2005
R728 Isum.n936 Isum.n917 5.2005
R729 Isum.n926 Isum.n916 5.2005
R730 Isum.n937 Isum.n916 5.2005
R731 Isum.n922 Isum.n907 5.2005
R732 Isum.n908 Isum.n907 5.2005
R733 Isum.n944 Isum.n906 5.2005
R734 Isum.n944 Isum.n943 5.2005
R735 Isum.n946 Isum.n945 5.2005
R736 Isum.n945 Isum.n105 5.2005
R737 Isum.n947 Isum.n104 5.2005
R738 Isum.n1140 Isum.n104 5.2005
R739 Isum.n949 Isum.n948 5.2005
R740 Isum.n948 Isum.n96 5.2005
R741 Isum.n950 Isum.n95 5.2005
R742 Isum.n1146 Isum.n95 5.2005
R743 Isum.n952 Isum.n951 5.2005
R744 Isum.n953 Isum.n952 5.2005
R745 Isum.n869 Isum.n84 5.2005
R746 Isum.n1152 Isum.n84 5.2005
R747 Isum.n898 Isum.n897 5.2005
R748 Isum.n897 Isum.n82 5.2005
R749 Isum.n896 Isum.n73 5.2005
R750 Isum.n1158 Isum.n73 5.2005
R751 Isum.n895 Isum.n894 5.2005
R752 Isum.n894 Isum.n63 5.2005
R753 Isum.n871 Isum.n62 5.2005
R754 Isum.n1164 Isum.n62 5.2005
R755 Isum.n890 Isum.n889 5.2005
R756 Isum.n889 Isum.n53 5.2005
R757 Isum.n888 Isum.n52 5.2005
R758 Isum.n1170 Isum.n52 5.2005
R759 Isum.n887 Isum.n886 5.2005
R760 Isum.n886 Isum.n43 5.2005
R761 Isum.n873 Isum.n42 5.2005
R762 Isum.n1176 Isum.n42 5.2005
R763 Isum.n882 Isum.n881 5.2005
R764 Isum.n881 Isum.n40 5.2005
R765 Isum.n880 Isum.n31 5.2005
R766 Isum.n1182 Isum.n31 5.2005
R767 Isum.n879 Isum.n878 5.2005
R768 Isum.n878 Isum.n21 5.2005
R769 Isum.n875 Isum.n20 5.2005
R770 Isum.n1188 Isum.n20 5.2005
R771 Isum.n5 Isum.n3 5.2005
R772 Isum.n8 Isum.n5 5.2005
R773 Isum.n1196 Isum.n1195 5.2005
R774 Isum.n1195 Isum.n1194 5.2005
R775 Isum.n4 Isum.n2 5.2005
R776 Isum.n6 Isum.n4 5.2005
R777 Isum.n1033 Isum.n1032 5.2005
R778 Isum.n1035 Isum.n1033 5.2005
R779 Isum.n605 Isum.n603 5.2005
R780 Isum.n1044 Isum.n603 5.2005
R781 Isum.n1028 Isum.n1027 5.2005
R782 Isum.n1027 Isum.n601 5.2005
R783 Isum.n1026 Isum.n585 5.2005
R784 Isum.n1050 Isum.n585 5.2005
R785 Isum.n1025 Isum.n1024 5.2005
R786 Isum.n1024 Isum.n576 5.2005
R787 Isum.n607 Isum.n575 5.2005
R788 Isum.n1056 Isum.n575 5.2005
R789 Isum.n1020 Isum.n1019 5.2005
R790 Isum.n1019 Isum.n566 5.2005
R791 Isum.n1018 Isum.n565 5.2005
R792 Isum.n1062 Isum.n565 5.2005
R793 Isum.n1017 Isum.n1016 5.2005
R794 Isum.n1016 Isum.n556 5.2005
R795 Isum.n609 Isum.n555 5.2005
R796 Isum.n1068 Isum.n555 5.2005
R797 Isum.n1012 Isum.n1011 5.2005
R798 Isum.n1011 Isum.n545 5.2005
R799 Isum.n1010 Isum.n544 5.2005
R800 Isum.n1074 Isum.n544 5.2005
R801 Isum.n1009 Isum.n1008 5.2005
R802 Isum.n1008 Isum.n542 5.2005
R803 Isum.n611 Isum.n532 5.2005
R804 Isum.n1080 Isum.n532 5.2005
R805 Isum.n1004 Isum.n1003 5.2005
R806 Isum.n1003 Isum.n1002 5.2005
R807 Isum.n622 Isum.n613 5.2005
R808 Isum.n631 Isum.n622 5.2005
R809 Isum.n621 Isum.n620 5.2005
R810 Isum.n621 Isum.n521 5.2005
R811 Isum.n614 Isum.n520 5.2005
R812 Isum.n1089 Isum.n520 5.2005
R813 Isum.n616 Isum.n519 5.2005
R814 Isum.n1090 Isum.n519 5.2005
R815 Isum.n506 Isum.n505 5.2005
R816 Isum.n508 Isum.n506 5.2005
R817 Isum.n1098 Isum.n1097 5.2005
R818 Isum.n1097 Isum.n1096 5.2005
R819 Isum.n1099 Isum.n503 5.2005
R820 Isum.n507 Isum.n503 5.2005
R821 Isum.n1100 Isum.n500 5.2005
R822 Isum.n500 Isum.n498 5.2005
R823 Isum.n511 Isum.n499 5.2005
R824 Isum.n499 Isum.n498 5.2005
R825 Isum.n512 Isum.n509 5.2005
R826 Isum.n509 Isum.n507 5.2005
R827 Isum.n1095 Isum.n1094 5.2005
R828 Isum.n1096 Isum.n1095 5.2005
R829 Isum.n1093 Isum.n510 5.2005
R830 Isum.n510 Isum.n508 5.2005
R831 Isum.n1092 Isum.n1091 5.2005
R832 Isum.n1091 Isum.n1090 5.2005
R833 Isum.n518 Isum.n517 5.2005
R834 Isum.n1089 Isum.n518 5.2005
R835 Isum.n624 Isum.n623 5.2005
R836 Isum.n623 Isum.n521 5.2005
R837 Isum.n630 Isum.n629 5.2005
R838 Isum.n631 Isum.n630 5.2005
R839 Isum.n536 Isum.n534 5.2005
R840 Isum.n1002 Isum.n534 5.2005
R841 Isum.n1079 Isum.n1078 5.2005
R842 Isum.n1080 Isum.n1079 5.2005
R843 Isum.n1077 Isum.n535 5.2005
R844 Isum.n542 Isum.n535 5.2005
R845 Isum.n1076 Isum.n1075 5.2005
R846 Isum.n1075 Isum.n1074 5.2005
R847 Isum.n541 Isum.n540 5.2005
R848 Isum.n545 Isum.n541 5.2005
R849 Isum.n1067 Isum.n1066 5.2005
R850 Isum.n1068 Isum.n1067 5.2005
R851 Isum.n1065 Isum.n557 5.2005
R852 Isum.n557 Isum.n556 5.2005
R853 Isum.n1064 Isum.n1063 5.2005
R854 Isum.n1063 Isum.n1062 5.2005
R855 Isum.n563 Isum.n562 5.2005
R856 Isum.n566 Isum.n563 5.2005
R857 Isum.n1055 Isum.n1054 5.2005
R858 Isum.n1056 Isum.n1055 5.2005
R859 Isum.n1053 Isum.n577 5.2005
R860 Isum.n577 Isum.n576 5.2005
R861 Isum.n1052 Isum.n1051 5.2005
R862 Isum.n1051 Isum.n1050 5.2005
R863 Isum.n583 Isum.n582 5.2005
R864 Isum.n601 Isum.n583 5.2005
R865 Isum.n1043 Isum.n1042 5.2005
R866 Isum.n1044 Isum.n1043 5.2005
R867 Isum.n1041 Isum.n1036 5.2005
R868 Isum.n1036 Isum.n1035 5.2005
R869 Isum.n12 Isum.n10 5.2005
R870 Isum.n10 Isum.n6 5.2005
R871 Isum.n1193 Isum.n1192 5.2005
R872 Isum.n1194 Isum.n1193 5.2005
R873 Isum.n1191 Isum.n11 5.2005
R874 Isum.n11 Isum.n8 5.2005
R875 Isum.n1190 Isum.n1189 5.2005
R876 Isum.n1189 Isum.n1188 5.2005
R877 Isum.n17 Isum.n16 5.2005
R878 Isum.n21 Isum.n17 5.2005
R879 Isum.n1181 Isum.n1180 5.2005
R880 Isum.n1182 Isum.n1181 5.2005
R881 Isum.n1179 Isum.n33 5.2005
R882 Isum.n40 Isum.n33 5.2005
R883 Isum.n1178 Isum.n1177 5.2005
R884 Isum.n1177 Isum.n1176 5.2005
R885 Isum.n39 Isum.n38 5.2005
R886 Isum.n43 Isum.n39 5.2005
R887 Isum.n1169 Isum.n1168 5.2005
R888 Isum.n1170 Isum.n1169 5.2005
R889 Isum.n1167 Isum.n54 5.2005
R890 Isum.n54 Isum.n53 5.2005
R891 Isum.n1166 Isum.n1165 5.2005
R892 Isum.n1165 Isum.n1164 5.2005
R893 Isum.n60 Isum.n59 5.2005
R894 Isum.n63 Isum.n60 5.2005
R895 Isum.n1157 Isum.n1156 5.2005
R896 Isum.n1158 Isum.n1157 5.2005
R897 Isum.n1155 Isum.n75 5.2005
R898 Isum.n82 Isum.n75 5.2005
R899 Isum.n1154 Isum.n1153 5.2005
R900 Isum.n1153 Isum.n1152 5.2005
R901 Isum.n81 Isum.n80 5.2005
R902 Isum.n953 Isum.n81 5.2005
R903 Isum.n1145 Isum.n1144 5.2005
R904 Isum.n1146 Isum.n1145 5.2005
R905 Isum.n1143 Isum.n97 5.2005
R906 Isum.n97 Isum.n96 5.2005
R907 Isum.n1142 Isum.n1141 5.2005
R908 Isum.n1141 Isum.n1140 5.2005
R909 Isum.n103 Isum.n102 5.2005
R910 Isum.n105 Isum.n103 5.2005
R911 Isum.n942 Isum.n941 5.2005
R912 Isum.n943 Isum.n942 5.2005
R913 Isum.n940 Isum.n909 5.2005
R914 Isum.n909 Isum.n908 5.2005
R915 Isum.n939 Isum.n938 5.2005
R916 Isum.n938 Isum.n937 5.2005
R917 Isum.n915 Isum.n914 5.2005
R918 Isum.n936 Isum.n915 5.2005
R919 Isum.n934 Isum.n933 5.2005
R920 Isum.n935 Isum.n934 5.2005
R921 Isum.n1109 Isum.n140 5.2005
R922 Isum.n140 Isum.n139 5.2005
R923 Isum.n1111 Isum.n1110 5.2005
R924 Isum.n1112 Isum.n1111 5.2005
R925 Isum.n135 Isum.n134 5.2005
R926 Isum.n1113 Isum.n135 5.2005
R927 Isum.n1116 Isum.n1115 5.2005
R928 Isum.n1115 Isum.n1114 5.2005
R929 Isum.n1117 Isum.n128 5.2005
R930 Isum.n128 Isum.n126 5.2005
R931 Isum.n1119 Isum.n1118 5.2005
R932 Isum.n1120 Isum.n1119 5.2005
R933 Isum.n129 Isum.n127 5.2005
R934 Isum.n127 Isum.n124 5.2005
R935 Isum.n113 Isum.n111 5.2005
R936 Isum.n116 Isum.n113 5.2005
R937 Isum.n1130 Isum.n1129 5.2005
R938 Isum.n1129 Isum.n1128 5.2005
R939 Isum.n112 Isum.n110 5.2005
R940 Isum.n477 Isum.n112 5.2005
R941 Isum.n458 Isum.n167 5.2005
R942 Isum.n167 Isum.n151 5.2005
R943 Isum.n460 Isum.n459 5.2005
R944 Isum.n461 Isum.n460 5.2005
R945 Isum.n168 Isum.n166 5.2005
R946 Isum.n174 Isum.n166 5.2005
R947 Isum.n453 Isum.n452 5.2005
R948 Isum.n452 Isum.n451 5.2005
R949 Isum.n171 Isum.n170 5.2005
R950 Isum.n185 Isum.n171 5.2005
R951 Isum.n437 Isum.n436 5.2005
R952 Isum.t7 Isum.n437 5.2005
R953 Isum.n187 Isum.n186 5.2005
R954 Isum.n186 Isum.n182 5.2005
R955 Isum.n432 Isum.n431 5.2005
R956 Isum.n431 Isum.n430 5.2005
R957 Isum.n190 Isum.n189 5.2005
R958 Isum.n191 Isum.n190 5.2005
R959 Isum.n421 Isum.n420 5.2005
R960 Isum.n422 Isum.n421 5.2005
R961 Isum.n203 Isum.n202 5.2005
R962 Isum.n202 Isum.n199 5.2005
R963 Isum.n416 Isum.n415 5.2005
R964 Isum.n415 Isum.n414 5.2005
R965 Isum.n206 Isum.n205 5.2005
R966 Isum.n317 Isum.n206 5.2005
R967 Isum.n405 Isum.n404 5.2005
R968 Isum.n406 Isum.n405 5.2005
R969 Isum.n319 Isum.n318 5.2005
R970 Isum.n318 Isum.n213 5.2005
R971 Isum.n400 Isum.n399 5.2005
R972 Isum.n399 Isum.n398 5.2005
R973 Isum.n322 Isum.n321 5.2005
R974 Isum.n323 Isum.n322 5.2005
R975 Isum.n353 Isum.n352 5.2005
R976 Isum.n354 Isum.n353 5.2005
R977 Isum.n332 Isum.n331 5.2005
R978 Isum.n331 Isum.n330 5.2005
R979 Isum.n348 Isum.n347 5.2005
R980 Isum.n347 Isum.n346 5.2005
R981 Isum.n335 Isum.n334 5.2005
R982 Isum.n336 Isum.n335 5.2005
R983 Isum.n496 Isum.n495 5.2005
R984 Isum.n496 Isum.n139 5.2005
R985 Isum.n494 Isum.n138 5.2005
R986 Isum.n1112 Isum.n138 5.2005
R987 Isum.n144 Isum.n137 5.2005
R988 Isum.n1113 Isum.n137 5.2005
R989 Isum.n490 Isum.n136 5.2005
R990 Isum.n1114 Isum.n136 5.2005
R991 Isum.n489 Isum.n488 5.2005
R992 Isum.n488 Isum.n126 5.2005
R993 Isum.n487 Isum.n125 5.2005
R994 Isum.n1120 Isum.n125 5.2005
R995 Isum.n481 Isum.n146 5.2005
R996 Isum.n481 Isum.n124 5.2005
R997 Isum.n483 Isum.n482 5.2005
R998 Isum.n482 Isum.n116 5.2005
R999 Isum.n480 Isum.n115 5.2005
R1000 Isum.n1128 Isum.n115 5.2005
R1001 Isum.n479 Isum.n478 5.2005
R1002 Isum.n478 Isum.n477 5.2005
R1003 Isum.n150 Isum.n148 5.2005
R1004 Isum.n151 Isum.n150 5.2005
R1005 Isum.n375 Isum.n164 5.2005
R1006 Isum.n461 Isum.n164 5.2005
R1007 Isum.n377 Isum.n376 5.2005
R1008 Isum.n376 Isum.n174 5.2005
R1009 Isum.n378 Isum.n173 5.2005
R1010 Isum.n451 Isum.n173 5.2005
R1011 Isum.n380 Isum.n379 5.2005
R1012 Isum.n379 Isum.n185 5.2005
R1013 Isum.n381 Isum.n184 5.2005
R1014 Isum.t7 Isum.n184 5.2005
R1015 Isum.n383 Isum.n382 5.2005
R1016 Isum.n382 Isum.n182 5.2005
R1017 Isum.n384 Isum.n193 5.2005
R1018 Isum.n430 Isum.n193 5.2005
R1019 Isum.n386 Isum.n385 5.2005
R1020 Isum.n385 Isum.n191 5.2005
R1021 Isum.n387 Isum.n201 5.2005
R1022 Isum.n422 Isum.n201 5.2005
R1023 Isum.n389 Isum.n388 5.2005
R1024 Isum.n388 Isum.n199 5.2005
R1025 Isum.n390 Isum.n208 5.2005
R1026 Isum.n414 Isum.n208 5.2005
R1027 Isum.n392 Isum.n391 5.2005
R1028 Isum.n391 Isum.n317 5.2005
R1029 Isum.n393 Isum.n215 5.2005
R1030 Isum.n406 Isum.n215 5.2005
R1031 Isum.n394 Isum.n325 5.2005
R1032 Isum.n325 Isum.n213 5.2005
R1033 Isum.n396 Isum.n395 5.2005
R1034 Isum.n398 Isum.n396 5.2005
R1035 Isum.n326 Isum.n324 5.2005
R1036 Isum.n324 Isum.n323 5.2005
R1037 Isum.n356 Isum.n355 5.2005
R1038 Isum.n355 Isum.n354 5.2005
R1039 Isum.n329 Isum.n328 5.2005
R1040 Isum.n330 Isum.n329 5.2005
R1041 Isum.n345 Isum.n344 5.2005
R1042 Isum.n346 Isum.n345 5.2005
R1043 Isum.n338 Isum.n337 5.2005
R1044 Isum.n467 Isum.n123 5.2005
R1045 Isum.n123 Isum.n116 5.2005
R1046 Isum.n154 Isum.n114 5.2005
R1047 Isum.n1128 Isum.n114 5.2005
R1048 Isum.n476 Isum.n475 5.2005
R1049 Isum.n477 Isum.n476 5.2005
R1050 Isum.n153 Isum.n152 5.2005
R1051 Isum.n152 Isum.n151 5.2005
R1052 Isum.n463 Isum.n462 5.2005
R1053 Isum.n462 Isum.n461 5.2005
R1054 Isum.n163 Isum.n162 5.2005
R1055 Isum.n174 Isum.n163 5.2005
R1056 Isum.n299 Isum.n172 5.2005
R1057 Isum.n451 Isum.n172 5.2005
R1058 Isum.n300 Isum.n294 5.2005
R1059 Isum.n294 Isum.n185 5.2005
R1060 Isum.n286 Isum.n183 5.2005
R1061 Isum.t7 Isum.n183 5.2005
R1062 Isum.n304 Isum.n285 5.2005
R1063 Isum.n285 Isum.n182 5.2005
R1064 Isum.n305 Isum.n192 5.2005
R1065 Isum.n430 Isum.n192 5.2005
R1066 Isum.n279 Isum.n278 5.2005
R1067 Isum.n278 Isum.n191 5.2005
R1068 Isum.n309 Isum.n200 5.2005
R1069 Isum.n422 Isum.n200 5.2005
R1070 Isum.n310 Isum.n277 5.2005
R1071 Isum.n277 Isum.n199 5.2005
R1072 Isum.n217 Isum.n207 5.2005
R1073 Isum.n414 Isum.n207 5.2005
R1074 Isum.n316 Isum.n315 5.2005
R1075 Isum.n317 Isum.n316 5.2005
R1076 Isum.n216 Isum.n214 5.2005
R1077 Isum.n406 Isum.n214 5.2005
R1078 Isum.n120 Isum.n118 5.2005
R1079 Isum.n118 Isum.n116 5.2005
R1080 Isum.n1127 Isum.n1126 5.2005
R1081 Isum.n1128 Isum.n1127 5.2005
R1082 Isum.n119 Isum.n117 5.2005
R1083 Isum.n477 Isum.n117 5.2005
R1084 Isum.n444 Isum.n443 5.2005
R1085 Isum.n443 Isum.n151 5.2005
R1086 Isum.n445 Isum.n165 5.2005
R1087 Isum.n461 Isum.n165 5.2005
R1088 Isum.n178 Isum.n176 5.2005
R1089 Isum.n176 Isum.n174 5.2005
R1090 Isum.n450 Isum.n449 5.2005
R1091 Isum.n451 Isum.n450 5.2005
R1092 Isum.n177 Isum.n175 5.2005
R1093 Isum.n185 Isum.n175 5.2005
R1094 Isum.n439 Isum.n438 5.2005
R1095 Isum.n438 Isum.t7 5.2005
R1096 Isum.n181 Isum.n180 5.2005
R1097 Isum.n182 Isum.n181 5.2005
R1098 Isum.n429 Isum.n428 5.2005
R1099 Isum.n430 Isum.n429 5.2005
R1100 Isum.n195 Isum.n194 5.2005
R1101 Isum.n194 Isum.n191 5.2005
R1102 Isum.n424 Isum.n423 5.2005
R1103 Isum.n423 Isum.n422 5.2005
R1104 Isum.n198 Isum.n197 5.2005
R1105 Isum.n199 Isum.n198 5.2005
R1106 Isum.n413 Isum.n412 5.2005
R1107 Isum.n414 Isum.n413 5.2005
R1108 Isum.n210 Isum.n209 5.2005
R1109 Isum.n317 Isum.n209 5.2005
R1110 Isum.n408 Isum.n407 5.2005
R1111 Isum.n407 Isum.n406 5.2005
R1112 Isum.n273 Isum.n272 4.85463
R1113 Isum.n268 Isum.n267 4.85463
R1114 Isum.n237 Isum.n157 4.85463
R1115 Isum.n253 Isum.n242 4.85463
R1116 Isum.n785 Isum.n784 4.69811
R1117 Isum.n859 Isum.n858 4.69811
R1118 Isum.n270 Isum.n220 4.69811
R1119 Isum.n265 Isum.n223 4.69811
R1120 Isum.n239 Isum.n238 4.69811
R1121 Isum.n251 Isum.n250 4.69811
R1122 Isum.t19 Isum.t13 4.63013
R1123 Isum.t1 Isum.t16 4.63013
R1124 Isum.n781 Isum.n780 4.5725
R1125 Isum.n862 Isum.n861 4.5725
R1126 Isum.n779 Isum.n778 4.5276
R1127 Isum.n864 Isum.n863 4.52597
R1128 Isum.n1099 Isum.n502 4.5005
R1129 Isum.n1098 Isum.n504 4.5005
R1130 Isum.n615 Isum.n505 4.5005
R1131 Isum.n617 Isum.n616 4.5005
R1132 Isum.n618 Isum.n614 4.5005
R1133 Isum.n620 Isum.n619 4.5005
R1134 Isum.n613 Isum.n612 4.5005
R1135 Isum.n1005 Isum.n1004 4.5005
R1136 Isum.n1006 Isum.n611 4.5005
R1137 Isum.n1009 Isum.n1007 4.5005
R1138 Isum.n1010 Isum.n610 4.5005
R1139 Isum.n1013 Isum.n1012 4.5005
R1140 Isum.n1014 Isum.n609 4.5005
R1141 Isum.n1017 Isum.n1015 4.5005
R1142 Isum.n1018 Isum.n608 4.5005
R1143 Isum.n1021 Isum.n1020 4.5005
R1144 Isum.n1022 Isum.n607 4.5005
R1145 Isum.n1025 Isum.n1023 4.5005
R1146 Isum.n1026 Isum.n606 4.5005
R1147 Isum.n1029 Isum.n1028 4.5005
R1148 Isum.n1030 Isum.n605 4.5005
R1149 Isum.n1032 Isum.n1031 4.5005
R1150 Isum.n2 Isum.n0 4.5005
R1151 VSS Isum.n1196 4.5005
R1152 Isum.n3 Isum.n1 4.5005
R1153 Isum.n876 Isum.n875 4.5005
R1154 Isum.n879 Isum.n877 4.5005
R1155 Isum.n880 Isum.n874 4.5005
R1156 Isum.n883 Isum.n882 4.5005
R1157 Isum.n884 Isum.n873 4.5005
R1158 Isum.n887 Isum.n885 4.5005
R1159 Isum.n888 Isum.n872 4.5005
R1160 Isum.n891 Isum.n890 4.5005
R1161 Isum.n892 Isum.n871 4.5005
R1162 Isum.n895 Isum.n893 4.5005
R1163 Isum.n896 Isum.n870 4.5005
R1164 Isum.n899 Isum.n898 4.5005
R1165 Isum.n900 Isum.n869 4.5005
R1166 Isum.n951 Isum.n901 4.5005
R1167 Isum.n950 Isum.n902 4.5005
R1168 Isum.n949 Isum.n903 4.5005
R1169 Isum.n947 Isum.n904 4.5005
R1170 Isum.n946 Isum.n905 4.5005
R1171 Isum.n923 Isum.n906 4.5005
R1172 Isum.n924 Isum.n922 4.5005
R1173 Isum.n926 Isum.n925 4.5005
R1174 Isum.n927 Isum.n921 4.5005
R1175 Isum.n930 Isum.n929 4.5005
R1176 Isum.n1101 Isum.n1100 4.5005
R1177 Isum.n511 Isum.n501 4.5005
R1178 Isum.n513 Isum.n512 4.5005
R1179 Isum.n1094 Isum.n514 4.5005
R1180 Isum.n1093 Isum.n515 4.5005
R1181 Isum.n1092 Isum.n516 4.5005
R1182 Isum.n625 Isum.n517 4.5005
R1183 Isum.n626 Isum.n624 4.5005
R1184 Isum.n629 Isum.n628 4.5005
R1185 Isum.n627 Isum.n536 4.5005
R1186 Isum.n1078 Isum.n537 4.5005
R1187 Isum.n1077 Isum.n538 4.5005
R1188 Isum.n1076 Isum.n539 4.5005
R1189 Isum.n558 Isum.n540 4.5005
R1190 Isum.n1066 Isum.n559 4.5005
R1191 Isum.n1065 Isum.n560 4.5005
R1192 Isum.n1064 Isum.n561 4.5005
R1193 Isum.n578 Isum.n562 4.5005
R1194 Isum.n1054 Isum.n579 4.5005
R1195 Isum.n1053 Isum.n580 4.5005
R1196 Isum.n1052 Isum.n581 4.5005
R1197 Isum.n1037 Isum.n582 4.5005
R1198 Isum.n1042 Isum.n1038 4.5005
R1199 Isum.n1041 Isum.n1040 4.5005
R1200 Isum.n1039 Isum.n12 4.5005
R1201 Isum.n1192 Isum.n13 4.5005
R1202 Isum.n1191 Isum.n14 4.5005
R1203 Isum.n1190 Isum.n15 4.5005
R1204 Isum.n34 Isum.n16 4.5005
R1205 Isum.n1180 Isum.n35 4.5005
R1206 Isum.n1179 Isum.n36 4.5005
R1207 Isum.n1178 Isum.n37 4.5005
R1208 Isum.n55 Isum.n38 4.5005
R1209 Isum.n1168 Isum.n56 4.5005
R1210 Isum.n1167 Isum.n57 4.5005
R1211 Isum.n1166 Isum.n58 4.5005
R1212 Isum.n76 Isum.n59 4.5005
R1213 Isum.n1156 Isum.n77 4.5005
R1214 Isum.n1155 Isum.n78 4.5005
R1215 Isum.n1154 Isum.n79 4.5005
R1216 Isum.n98 Isum.n80 4.5005
R1217 Isum.n1144 Isum.n99 4.5005
R1218 Isum.n1143 Isum.n100 4.5005
R1219 Isum.n1142 Isum.n101 4.5005
R1220 Isum.n910 Isum.n102 4.5005
R1221 Isum.n941 Isum.n911 4.5005
R1222 Isum.n940 Isum.n912 4.5005
R1223 Isum.n939 Isum.n913 4.5005
R1224 Isum.n920 Isum.n914 4.5005
R1225 Isum.n933 Isum.n932 4.5005
R1226 Isum.n1083 Isum.n525 4.5005
R1227 Isum.n1082 Isum.n527 4.5005
R1228 Isum.n547 Isum.n528 4.5005
R1229 Isum.n1072 Isum.n548 4.5005
R1230 Isum.n1071 Isum.n549 4.5005
R1231 Isum.n1070 Isum.n550 4.5005
R1232 Isum.n568 Isum.n551 4.5005
R1233 Isum.n1060 Isum.n569 4.5005
R1234 Isum.n1059 Isum.n570 4.5005
R1235 Isum.n1058 Isum.n571 4.5005
R1236 Isum.n588 Isum.n572 4.5005
R1237 Isum.n1048 Isum.n589 4.5005
R1238 Isum.n1047 Isum.n590 4.5005
R1239 Isum.n1046 Isum.n591 4.5005
R1240 Isum.n593 Isum.n592 4.5005
R1241 Isum.n598 Isum.n594 4.5005
R1242 Isum.n597 Isum.n596 4.5005
R1243 Isum.n595 Isum.n24 4.5005
R1244 Isum.n1186 Isum.n25 4.5005
R1245 Isum.n1185 Isum.n26 4.5005
R1246 Isum.n1184 Isum.n27 4.5005
R1247 Isum.n45 Isum.n28 4.5005
R1248 Isum.n1174 Isum.n46 4.5005
R1249 Isum.n1173 Isum.n47 4.5005
R1250 Isum.n1172 Isum.n48 4.5005
R1251 Isum.n65 Isum.n49 4.5005
R1252 Isum.n1162 Isum.n66 4.5005
R1253 Isum.n1161 Isum.n67 4.5005
R1254 Isum.n1160 Isum.n68 4.5005
R1255 Isum.n87 Isum.n69 4.5005
R1256 Isum.n1150 Isum.n88 4.5005
R1257 Isum.n1149 Isum.n89 4.5005
R1258 Isum.n1148 Isum.n90 4.5005
R1259 Isum.n1136 Isum.n91 4.5005
R1260 Isum.n1085 Isum.n1084 4.5005
R1261 Isum.n632 Isum.n524 4.5005
R1262 Isum.n858 Isum.n857 4.5005
R1263 Isum.n786 Isum.n785 4.5005
R1264 Isum.n1000 Isum.n633 4.5005
R1265 Isum.n999 Isum.n634 4.5005
R1266 Isum.n998 Isum.n635 4.5005
R1267 Isum.n996 Isum.n636 4.5005
R1268 Isum.n995 Isum.n637 4.5005
R1269 Isum.n993 Isum.n638 4.5005
R1270 Isum.n992 Isum.n639 4.5005
R1271 Isum.n990 Isum.n640 4.5005
R1272 Isum.n989 Isum.n641 4.5005
R1273 Isum.n987 Isum.n642 4.5005
R1274 Isum.n986 Isum.n643 4.5005
R1275 Isum.n984 Isum.n644 4.5005
R1276 Isum.n983 Isum.n645 4.5005
R1277 Isum.n981 Isum.n646 4.5005
R1278 Isum.n980 Isum.n647 4.5005
R1279 Isum.n979 Isum.n648 4.5005
R1280 Isum.n977 Isum.n649 4.5005
R1281 Isum.n976 Isum.n650 4.5005
R1282 Isum.n974 Isum.n651 4.5005
R1283 Isum.n973 Isum.n652 4.5005
R1284 Isum.n971 Isum.n653 4.5005
R1285 Isum.n970 Isum.n654 4.5005
R1286 Isum.n968 Isum.n655 4.5005
R1287 Isum.n967 Isum.n656 4.5005
R1288 Isum.n965 Isum.n657 4.5005
R1289 Isum.n964 Isum.n658 4.5005
R1290 Isum.n962 Isum.n659 4.5005
R1291 Isum.n961 Isum.n660 4.5005
R1292 Isum.n959 Isum.n661 4.5005
R1293 Isum.n958 Isum.n662 4.5005
R1294 Isum.n956 Isum.n663 4.5005
R1295 Isum.n955 Isum.n711 4.5005
R1296 Isum.n868 Isum.n866 4.5005
R1297 Isum.n867 Isum.n107 4.5005
R1298 Isum.n1134 Isum.n1133 4.5005
R1299 Isum.n349 Isum.n348 4.5005
R1300 Isum.n350 Isum.n332 4.5005
R1301 Isum.n352 Isum.n351 4.5005
R1302 Isum.n321 Isum.n320 4.5005
R1303 Isum.n401 Isum.n400 4.5005
R1304 Isum.n402 Isum.n319 4.5005
R1305 Isum.n404 Isum.n403 4.5005
R1306 Isum.n205 Isum.n204 4.5005
R1307 Isum.n417 Isum.n416 4.5005
R1308 Isum.n418 Isum.n203 4.5005
R1309 Isum.n420 Isum.n419 4.5005
R1310 Isum.n189 Isum.n188 4.5005
R1311 Isum.n433 Isum.n432 4.5005
R1312 Isum.n434 Isum.n187 4.5005
R1313 Isum.n436 Isum.n435 4.5005
R1314 Isum.n170 Isum.n169 4.5005
R1315 Isum.n454 Isum.n453 4.5005
R1316 Isum.n455 Isum.n168 4.5005
R1317 Isum.n459 Isum.n456 4.5005
R1318 Isum.n458 Isum.n457 4.5005
R1319 Isum.n110 Isum.n108 4.5005
R1320 Isum.n1131 Isum.n1130 4.5005
R1321 Isum.n111 Isum.n109 4.5005
R1322 Isum.n130 Isum.n129 4.5005
R1323 Isum.n1118 Isum.n131 4.5005
R1324 Isum.n1117 Isum.n132 4.5005
R1325 Isum.n1116 Isum.n133 4.5005
R1326 Isum.n141 Isum.n134 4.5005
R1327 Isum.n1110 Isum.n142 4.5005
R1328 Isum.n1109 Isum.n1108 4.5005
R1329 Isum.n334 Isum.n333 4.5005
R1330 Isum.n344 Isum.n343 4.5005
R1331 Isum.n328 Isum.n327 4.5005
R1332 Isum.n357 Isum.n356 4.5005
R1333 Isum.n358 Isum.n326 4.5005
R1334 Isum.n395 Isum.n359 4.5005
R1335 Isum.n394 Isum.n360 4.5005
R1336 Isum.n393 Isum.n361 4.5005
R1337 Isum.n392 Isum.n362 4.5005
R1338 Isum.n390 Isum.n363 4.5005
R1339 Isum.n389 Isum.n364 4.5005
R1340 Isum.n387 Isum.n365 4.5005
R1341 Isum.n386 Isum.n366 4.5005
R1342 Isum.n384 Isum.n367 4.5005
R1343 Isum.n383 Isum.n368 4.5005
R1344 Isum.n381 Isum.n369 4.5005
R1345 Isum.n380 Isum.n370 4.5005
R1346 Isum.n378 Isum.n371 4.5005
R1347 Isum.n377 Isum.n372 4.5005
R1348 Isum.n375 Isum.n374 4.5005
R1349 Isum.n373 Isum.n148 4.5005
R1350 Isum.n479 Isum.n149 4.5005
R1351 Isum.n480 Isum.n147 4.5005
R1352 Isum.n484 Isum.n483 4.5005
R1353 Isum.n485 Isum.n146 4.5005
R1354 Isum.n487 Isum.n486 4.5005
R1355 Isum.n489 Isum.n145 4.5005
R1356 Isum.n491 Isum.n490 4.5005
R1357 Isum.n492 Isum.n144 4.5005
R1358 Isum.n494 Isum.n493 4.5005
R1359 Isum.n495 Isum.n143 4.5005
R1360 Isum.n342 Isum.n338 4.5005
R1361 Isum.n410 Isum.n210 4.5005
R1362 Isum.n412 Isum.n411 4.5005
R1363 Isum.n197 Isum.n196 4.5005
R1364 Isum.n425 Isum.n424 4.5005
R1365 Isum.n426 Isum.n195 4.5005
R1366 Isum.n428 Isum.n427 4.5005
R1367 Isum.n180 Isum.n179 4.5005
R1368 Isum.n440 Isum.n439 4.5005
R1369 Isum.n441 Isum.n177 4.5005
R1370 Isum.n449 Isum.n448 4.5005
R1371 Isum.n447 Isum.n178 4.5005
R1372 Isum.n446 Isum.n445 4.5005
R1373 Isum.n444 Isum.n442 4.5005
R1374 Isum.n121 Isum.n119 4.5005
R1375 Isum.n1126 Isum.n1125 4.5005
R1376 Isum.n1124 Isum.n120 4.5005
R1377 Isum.n409 Isum.n408 4.5005
R1378 Isum.n253 Isum.n252 4.5005
R1379 Isum.n252 Isum.n251 4.5005
R1380 Isum.n240 Isum.n237 4.5005
R1381 Isum.n240 Isum.n239 4.5005
R1382 Isum.n267 Isum.n266 4.5005
R1383 Isum.n266 Isum.n265 4.5005
R1384 Isum.n272 Isum.n271 4.5005
R1385 Isum.n271 Isum.n270 4.5005
R1386 Isum.n315 Isum.n314 4.5005
R1387 Isum.n312 Isum.n217 4.5005
R1388 Isum.n311 Isum.n310 4.5005
R1389 Isum.n309 Isum.n308 4.5005
R1390 Isum.n307 Isum.n279 4.5005
R1391 Isum.n306 Isum.n305 4.5005
R1392 Isum.n304 Isum.n303 4.5005
R1393 Isum.n302 Isum.n286 4.5005
R1394 Isum.n301 Isum.n300 4.5005
R1395 Isum.n299 Isum.n298 4.5005
R1396 Isum.n162 Isum.n159 4.5005
R1397 Isum.n464 Isum.n463 4.5005
R1398 Isum.n155 Isum.n153 4.5005
R1399 Isum.n475 Isum.n474 4.5005
R1400 Isum.n472 Isum.n154 4.5005
R1401 Isum.n468 Isum.n467 4.5005
R1402 Isum.n218 Isum.n216 4.5005
R1403 Isum.n281 Isum.n280 4.49281
R1404 Isum.n295 Isum.n161 4.49281
R1405 Isum.n678 Isum.n677 4.49281
R1406 Isum.n687 Isum.n686 4.49281
R1407 Isum.n698 Isum.n697 4.49281
R1408 Isum.n707 Isum.n706 4.49281
R1409 Isum.n794 Isum.n793 4.49281
R1410 Isum.n816 Isum.n763 4.49281
R1411 Isum.n832 Isum.n831 4.49281
R1412 Isum.n844 Isum.n745 4.49281
R1413 Isum.n229 Isum.n228 4.49281
R1414 Isum.n248 Isum.n244 4.49281
R1415 Isum.n225 Isum.t29 3.9035
R1416 Isum.n249 Isum.t21 3.90299
R1417 Isum.n339 Isum.n337 3.89052
R1418 Isum.n466 Isum.t5 3.5285
R1419 Isum.t2 Isum.n466 3.5285
R1420 Isum.n292 Isum.t8 3.5285
R1421 Isum.n292 Isum.t5 3.5285
R1422 Isum.n291 Isum.t11 3.5285
R1423 Isum.t8 Isum.n291 3.5285
R1424 Isum.n290 Isum.t14 3.5285
R1425 Isum.t11 Isum.n290 3.5285
R1426 Isum.n738 Isum.n736 3.5285
R1427 Isum.n739 Isum.n738 3.5285
R1428 Isum.n735 Isum.n733 3.5285
R1429 Isum.n736 Isum.n735 3.5285
R1430 Isum.n732 Isum.n730 3.5285
R1431 Isum.n733 Isum.n732 3.5285
R1432 Isum.n729 Isum.n727 3.5285
R1433 Isum.n730 Isum.n729 3.5285
R1434 Isum.n726 Isum.n725 3.5285
R1435 Isum.n727 Isum.n726 3.5285
R1436 Isum.n724 Isum.n722 3.5285
R1437 Isum.n725 Isum.n724 3.5285
R1438 Isum.n721 Isum.n719 3.5285
R1439 Isum.n722 Isum.n721 3.5285
R1440 Isum.n718 Isum.n716 3.5285
R1441 Isum.n719 Isum.n718 3.5285
R1442 Isum.n715 Isum.n713 3.5285
R1443 Isum.n716 Isum.n715 3.5285
R1444 Isum.n851 Isum.n850 3.5285
R1445 Isum.n851 Isum.n744 3.5285
R1446 Isum.n849 Isum.n747 3.5285
R1447 Isum.n850 Isum.n849 3.5285
R1448 Isum.n837 Isum.n836 3.5285
R1449 Isum.n837 Isum.n747 3.5285
R1450 Isum.n835 Isum.n753 3.5285
R1451 Isum.n836 Isum.n835 3.5285
R1452 Isum.n812 Isum.n811 3.5285
R1453 Isum.n811 Isum.n753 3.5285
R1454 Isum.n813 Isum.n810 3.5285
R1455 Isum.n813 Isum.n812 3.5285
R1456 Isum.n809 Isum.n765 3.5285
R1457 Isum.n810 Isum.n809 3.5285
R1458 Isum.n799 Isum.n798 3.5285
R1459 Isum.n799 Isum.n765 3.5285
R1460 Isum.n797 Isum.n770 3.5285
R1461 Isum.n798 Isum.n797 3.5285
R1462 Isum.n264 Isum.t30 3.5285
R1463 Isum.n264 Isum.t28 3.5285
R1464 Isum.n255 Isum.t26 3.5285
R1465 Isum.n255 Isum.t24 3.5285
R1466 Isum.t28 Isum.n263 3.5285
R1467 Isum.n263 Isum.t26 3.5285
R1468 Isum.t24 Isum.n254 3.5285
R1469 Isum.n254 Isum.t22 3.5285
R1470 Isum.n236 Isum.n122 3.49121
R1471 Isum.n222 Isum.n221 3.49121
R1472 Isum.n928 Isum.n918 3.45362
R1473 Isum.n691 Isum.n690 3.36973
R1474 Isum.n694 Isum.n693 3.36973
R1475 Isum.n821 Isum.n760 3.36973
R1476 Isum.n823 Isum.n757 3.36973
R1477 Isum.n252 Isum.n249 3.09098
R1478 Isum.n266 Isum.n225 3.09091
R1479 Isum.n780 Isum.n779 2.9825
R1480 Isum.n863 Isum.n862 2.9825
R1481 Isum.n862 Isum.n741 2.40683
R1482 Isum.n780 Isum.n776 2.3767
R1483 Isum.n274 Isum.n219 2.24665
R1484 Isum.n158 Isum.n156 2.24665
R1485 Isum.n675 Isum.n674 2.24665
R1486 Isum.n690 Isum.n689 2.24665
R1487 Isum.n695 Isum.n694 2.24665
R1488 Isum.n710 Isum.n709 2.24665
R1489 Isum.n818 Isum.n760 2.24665
R1490 Isum.n826 Isum.n757 2.24665
R1491 Isum.n788 Isum.n787 2.07778
R1492 Isum.n856 Isum.n855 2.07778
R1493 Isum.n430 Isum.t31 1.98463
R1494 Isum.n451 Isum.t33 1.98463
R1495 Isum.n935 Isum.n918 1.68164
R1496 Isum.n339 Isum.n336 1.231
R1497 Isum.n282 Isum.n281 1.12358
R1498 Isum.n296 Isum.n295 1.12358
R1499 Isum.n679 Isum.n678 1.12358
R1500 Isum.n686 Isum.n685 1.12358
R1501 Isum.n699 Isum.n698 1.12358
R1502 Isum.n706 Isum.n705 1.12358
R1503 Isum.n793 Isum.n792 1.12358
R1504 Isum.n805 Isum.n763 1.12358
R1505 Isum.n831 Isum.n830 1.12358
R1506 Isum.n845 Isum.n844 1.12358
R1507 Isum.n232 Isum.n228 1.12358
R1508 Isum.n245 Isum.n244 1.12358
R1509 Isum.n288 Isum.t6 0.913
R1510 Isum.n219 Isum.t12 0.913
R1511 Isum.n281 Isum.t9 0.913
R1512 Isum.n295 Isum.t3 0.913
R1513 Isum.n158 Isum.t0 0.913
R1514 Isum.n702 Isum.n666 0.913
R1515 Isum.n682 Isum.n671 0.913
R1516 Isum.n674 Isum.n673 0.913
R1517 Isum.n678 Isum.n672 0.913
R1518 Isum.n686 Isum.n670 0.913
R1519 Isum.n690 Isum.n669 0.913
R1520 Isum.n694 Isum.n668 0.913
R1521 Isum.n698 Isum.n667 0.913
R1522 Isum.n706 Isum.n665 0.913
R1523 Isum.n710 Isum.n664 0.913
R1524 Isum.n841 Isum.n750 0.913
R1525 Isum.n803 Isum.n767 0.913
R1526 Isum.n793 Isum.n790 0.913
R1527 Isum.n763 Isum.n762 0.913
R1528 Isum.n760 Isum.n759 0.913
R1529 Isum.n757 Isum.n756 0.913
R1530 Isum.n831 Isum.n828 0.913
R1531 Isum.n844 Isum.n843 0.913
R1532 Isum.n259 Isum.t25 0.913
R1533 Isum.n228 Isum.t27 0.913
R1534 Isum.n244 Isum.t23 0.913
R1535 Isum.n470 Isum.n469 0.7511
R1536 Isum.n865 Isum.n864 0.249527
R1537 Isum.n778 Isum.n777 0.226446
R1538 Isum.n1123 Isum.n1122 0.217167
R1539 Isum.n1122 Isum.n1121 0.217167
R1540 Isum.n212 Isum.n211 0.217167
R1541 Isum.n397 Isum.n212 0.217167
R1542 Isum.n1087 Isum.n1086 0.193093
R1543 Isum.n1088 Isum.n1087 0.193093
R1544 Isum.n1138 Isum.n1137 0.193093
R1545 Isum.n1139 Isum.n1138 0.193093
R1546 Isum.n408 Isum.n210 0.1445
R1547 Isum.n412 Isum.n210 0.1445
R1548 Isum.n412 Isum.n197 0.1445
R1549 Isum.n424 Isum.n197 0.1445
R1550 Isum.n424 Isum.n195 0.1445
R1551 Isum.n428 Isum.n195 0.1445
R1552 Isum.n428 Isum.n180 0.1445
R1553 Isum.n439 Isum.n180 0.1445
R1554 Isum.n439 Isum.n177 0.1445
R1555 Isum.n449 Isum.n177 0.1445
R1556 Isum.n449 Isum.n178 0.1445
R1557 Isum.n445 Isum.n178 0.1445
R1558 Isum.n445 Isum.n444 0.1445
R1559 Isum.n444 Isum.n119 0.1445
R1560 Isum.n1126 Isum.n119 0.1445
R1561 Isum.n1126 Isum.n120 0.1445
R1562 Isum.n344 Isum.n338 0.1445
R1563 Isum.n344 Isum.n328 0.1445
R1564 Isum.n356 Isum.n328 0.1445
R1565 Isum.n356 Isum.n326 0.1445
R1566 Isum.n395 Isum.n326 0.1445
R1567 Isum.n395 Isum.n394 0.1445
R1568 Isum.n394 Isum.n393 0.1445
R1569 Isum.n393 Isum.n392 0.1445
R1570 Isum.n392 Isum.n390 0.1445
R1571 Isum.n390 Isum.n389 0.1445
R1572 Isum.n389 Isum.n387 0.1445
R1573 Isum.n387 Isum.n386 0.1445
R1574 Isum.n386 Isum.n384 0.1445
R1575 Isum.n384 Isum.n383 0.1445
R1576 Isum.n383 Isum.n381 0.1445
R1577 Isum.n381 Isum.n380 0.1445
R1578 Isum.n380 Isum.n378 0.1445
R1579 Isum.n378 Isum.n377 0.1445
R1580 Isum.n377 Isum.n375 0.1445
R1581 Isum.n375 Isum.n148 0.1445
R1582 Isum.n479 Isum.n148 0.1445
R1583 Isum.n480 Isum.n479 0.1445
R1584 Isum.n483 Isum.n480 0.1445
R1585 Isum.n483 Isum.n146 0.1445
R1586 Isum.n487 Isum.n146 0.1445
R1587 Isum.n489 Isum.n487 0.1445
R1588 Isum.n490 Isum.n489 0.1445
R1589 Isum.n490 Isum.n144 0.1445
R1590 Isum.n494 Isum.n144 0.1445
R1591 Isum.n495 Isum.n494 0.1445
R1592 Isum.n348 Isum.n334 0.1445
R1593 Isum.n348 Isum.n332 0.1445
R1594 Isum.n352 Isum.n332 0.1445
R1595 Isum.n352 Isum.n321 0.1445
R1596 Isum.n400 Isum.n321 0.1445
R1597 Isum.n400 Isum.n319 0.1445
R1598 Isum.n404 Isum.n319 0.1445
R1599 Isum.n404 Isum.n205 0.1445
R1600 Isum.n416 Isum.n205 0.1445
R1601 Isum.n416 Isum.n203 0.1445
R1602 Isum.n420 Isum.n203 0.1445
R1603 Isum.n420 Isum.n189 0.1445
R1604 Isum.n432 Isum.n189 0.1445
R1605 Isum.n432 Isum.n187 0.1445
R1606 Isum.n436 Isum.n187 0.1445
R1607 Isum.n436 Isum.n170 0.1445
R1608 Isum.n453 Isum.n170 0.1445
R1609 Isum.n453 Isum.n168 0.1445
R1610 Isum.n459 Isum.n168 0.1445
R1611 Isum.n459 Isum.n458 0.1445
R1612 Isum.n458 Isum.n110 0.1445
R1613 Isum.n1130 Isum.n110 0.1445
R1614 Isum.n1130 Isum.n111 0.1445
R1615 Isum.n129 Isum.n111 0.1445
R1616 Isum.n1118 Isum.n129 0.1445
R1617 Isum.n1118 Isum.n1117 0.1445
R1618 Isum.n1117 Isum.n1116 0.1445
R1619 Isum.n1116 Isum.n134 0.1445
R1620 Isum.n1110 Isum.n134 0.1445
R1621 Isum.n1110 Isum.n1109 0.1445
R1622 Isum.n512 Isum.n511 0.1445
R1623 Isum.n1094 Isum.n512 0.1445
R1624 Isum.n1094 Isum.n1093 0.1445
R1625 Isum.n1093 Isum.n1092 0.1445
R1626 Isum.n1092 Isum.n517 0.1445
R1627 Isum.n624 Isum.n517 0.1445
R1628 Isum.n629 Isum.n624 0.1445
R1629 Isum.n629 Isum.n536 0.1445
R1630 Isum.n1078 Isum.n536 0.1445
R1631 Isum.n1078 Isum.n1077 0.1445
R1632 Isum.n1077 Isum.n1076 0.1445
R1633 Isum.n1076 Isum.n540 0.1445
R1634 Isum.n1066 Isum.n540 0.1445
R1635 Isum.n1066 Isum.n1065 0.1445
R1636 Isum.n1065 Isum.n1064 0.1445
R1637 Isum.n1064 Isum.n562 0.1445
R1638 Isum.n1054 Isum.n562 0.1445
R1639 Isum.n1054 Isum.n1053 0.1445
R1640 Isum.n1053 Isum.n1052 0.1445
R1641 Isum.n1052 Isum.n582 0.1445
R1642 Isum.n1042 Isum.n582 0.1445
R1643 Isum.n1042 Isum.n1041 0.1445
R1644 Isum.n1041 Isum.n12 0.1445
R1645 Isum.n1192 Isum.n12 0.1445
R1646 Isum.n1192 Isum.n1191 0.1445
R1647 Isum.n1191 Isum.n1190 0.1445
R1648 Isum.n1190 Isum.n16 0.1445
R1649 Isum.n1180 Isum.n16 0.1445
R1650 Isum.n1180 Isum.n1179 0.1445
R1651 Isum.n1179 Isum.n1178 0.1445
R1652 Isum.n1178 Isum.n38 0.1445
R1653 Isum.n1168 Isum.n38 0.1445
R1654 Isum.n1168 Isum.n1167 0.1445
R1655 Isum.n1167 Isum.n1166 0.1445
R1656 Isum.n1166 Isum.n59 0.1445
R1657 Isum.n1156 Isum.n59 0.1445
R1658 Isum.n1156 Isum.n1155 0.1445
R1659 Isum.n1155 Isum.n1154 0.1445
R1660 Isum.n1154 Isum.n80 0.1445
R1661 Isum.n1144 Isum.n80 0.1445
R1662 Isum.n1144 Isum.n1143 0.1445
R1663 Isum.n1143 Isum.n1142 0.1445
R1664 Isum.n1142 Isum.n102 0.1445
R1665 Isum.n941 Isum.n102 0.1445
R1666 Isum.n941 Isum.n940 0.1445
R1667 Isum.n940 Isum.n939 0.1445
R1668 Isum.n939 Isum.n914 0.1445
R1669 Isum.n933 Isum.n914 0.1445
R1670 Isum.n1100 Isum.n1099 0.1445
R1671 Isum.n1099 Isum.n1098 0.1445
R1672 Isum.n1098 Isum.n505 0.1445
R1673 Isum.n616 Isum.n505 0.1445
R1674 Isum.n616 Isum.n614 0.1445
R1675 Isum.n620 Isum.n614 0.1445
R1676 Isum.n620 Isum.n613 0.1445
R1677 Isum.n1004 Isum.n613 0.1445
R1678 Isum.n1004 Isum.n611 0.1445
R1679 Isum.n1009 Isum.n611 0.1445
R1680 Isum.n1010 Isum.n1009 0.1445
R1681 Isum.n1012 Isum.n1010 0.1445
R1682 Isum.n1012 Isum.n609 0.1445
R1683 Isum.n1017 Isum.n609 0.1445
R1684 Isum.n1018 Isum.n1017 0.1445
R1685 Isum.n1020 Isum.n1018 0.1445
R1686 Isum.n1020 Isum.n607 0.1445
R1687 Isum.n1025 Isum.n607 0.1445
R1688 Isum.n1026 Isum.n1025 0.1445
R1689 Isum.n1028 Isum.n1026 0.1445
R1690 Isum.n1028 Isum.n605 0.1445
R1691 Isum.n1032 Isum.n605 0.1445
R1692 Isum.n1032 Isum.n2 0.1445
R1693 Isum.n1196 Isum.n2 0.1445
R1694 Isum.n1196 Isum.n3 0.1445
R1695 Isum.n875 Isum.n3 0.1445
R1696 Isum.n879 Isum.n875 0.1445
R1697 Isum.n880 Isum.n879 0.1445
R1698 Isum.n882 Isum.n880 0.1445
R1699 Isum.n882 Isum.n873 0.1445
R1700 Isum.n887 Isum.n873 0.1445
R1701 Isum.n888 Isum.n887 0.1445
R1702 Isum.n890 Isum.n888 0.1445
R1703 Isum.n890 Isum.n871 0.1445
R1704 Isum.n895 Isum.n871 0.1445
R1705 Isum.n896 Isum.n895 0.1445
R1706 Isum.n898 Isum.n896 0.1445
R1707 Isum.n898 Isum.n869 0.1445
R1708 Isum.n951 Isum.n869 0.1445
R1709 Isum.n951 Isum.n950 0.1445
R1710 Isum.n950 Isum.n949 0.1445
R1711 Isum.n949 Isum.n947 0.1445
R1712 Isum.n947 Isum.n946 0.1445
R1713 Isum.n946 Isum.n906 0.1445
R1714 Isum.n922 Isum.n906 0.1445
R1715 Isum.n926 Isum.n922 0.1445
R1716 Isum.n927 Isum.n926 0.1445
R1717 Isum.n929 Isum.n927 0.1445
R1718 Isum.n1101 Isum.n502 0.1445
R1719 Isum.n504 Isum.n502 0.1445
R1720 Isum.n615 Isum.n504 0.1445
R1721 Isum.n617 Isum.n615 0.1445
R1722 Isum.n618 Isum.n617 0.1445
R1723 Isum.n619 Isum.n618 0.1445
R1724 Isum.n619 Isum.n612 0.1445
R1725 Isum.n1005 Isum.n612 0.1445
R1726 Isum.n1006 Isum.n1005 0.1445
R1727 Isum.n1007 Isum.n1006 0.1445
R1728 Isum.n1007 Isum.n610 0.1445
R1729 Isum.n1013 Isum.n610 0.1445
R1730 Isum.n1014 Isum.n1013 0.1445
R1731 Isum.n1015 Isum.n1014 0.1445
R1732 Isum.n1015 Isum.n608 0.1445
R1733 Isum.n1021 Isum.n608 0.1445
R1734 Isum.n1022 Isum.n1021 0.1445
R1735 Isum.n1023 Isum.n1022 0.1445
R1736 Isum.n1023 Isum.n606 0.1445
R1737 Isum.n1029 Isum.n606 0.1445
R1738 Isum.n1030 Isum.n1029 0.1445
R1739 Isum.n1031 Isum.n1030 0.1445
R1740 Isum.n1031 Isum.n0 0.1445
R1741 VSS Isum.n0 0.1445
R1742 VSS Isum.n1 0.1445
R1743 Isum.n876 Isum.n1 0.1445
R1744 Isum.n877 Isum.n876 0.1445
R1745 Isum.n877 Isum.n874 0.1445
R1746 Isum.n883 Isum.n874 0.1445
R1747 Isum.n884 Isum.n883 0.1445
R1748 Isum.n885 Isum.n884 0.1445
R1749 Isum.n885 Isum.n872 0.1445
R1750 Isum.n891 Isum.n872 0.1445
R1751 Isum.n892 Isum.n891 0.1445
R1752 Isum.n893 Isum.n892 0.1445
R1753 Isum.n893 Isum.n870 0.1445
R1754 Isum.n899 Isum.n870 0.1445
R1755 Isum.n900 Isum.n899 0.1445
R1756 Isum.n901 Isum.n900 0.1445
R1757 Isum.n902 Isum.n901 0.1445
R1758 Isum.n903 Isum.n902 0.1445
R1759 Isum.n904 Isum.n903 0.1445
R1760 Isum.n905 Isum.n904 0.1445
R1761 Isum.n923 Isum.n905 0.1445
R1762 Isum.n924 Isum.n923 0.1445
R1763 Isum.n925 Isum.n924 0.1445
R1764 Isum.n925 Isum.n921 0.1445
R1765 Isum.n930 Isum.n921 0.1445
R1766 Isum.n513 Isum.n501 0.1445
R1767 Isum.n514 Isum.n513 0.1445
R1768 Isum.n515 Isum.n514 0.1445
R1769 Isum.n516 Isum.n515 0.1445
R1770 Isum.n625 Isum.n516 0.1445
R1771 Isum.n626 Isum.n625 0.1445
R1772 Isum.n628 Isum.n626 0.1445
R1773 Isum.n628 Isum.n627 0.1445
R1774 Isum.n627 Isum.n537 0.1445
R1775 Isum.n538 Isum.n537 0.1445
R1776 Isum.n539 Isum.n538 0.1445
R1777 Isum.n558 Isum.n539 0.1445
R1778 Isum.n559 Isum.n558 0.1445
R1779 Isum.n560 Isum.n559 0.1445
R1780 Isum.n561 Isum.n560 0.1445
R1781 Isum.n578 Isum.n561 0.1445
R1782 Isum.n579 Isum.n578 0.1445
R1783 Isum.n580 Isum.n579 0.1445
R1784 Isum.n581 Isum.n580 0.1445
R1785 Isum.n1037 Isum.n581 0.1445
R1786 Isum.n1038 Isum.n1037 0.1445
R1787 Isum.n1040 Isum.n1038 0.1445
R1788 Isum.n1040 Isum.n1039 0.1445
R1789 Isum.n1039 Isum.n13 0.1445
R1790 Isum.n14 Isum.n13 0.1445
R1791 Isum.n15 Isum.n14 0.1445
R1792 Isum.n34 Isum.n15 0.1445
R1793 Isum.n35 Isum.n34 0.1445
R1794 Isum.n36 Isum.n35 0.1445
R1795 Isum.n37 Isum.n36 0.1445
R1796 Isum.n55 Isum.n37 0.1445
R1797 Isum.n56 Isum.n55 0.1445
R1798 Isum.n57 Isum.n56 0.1445
R1799 Isum.n58 Isum.n57 0.1445
R1800 Isum.n76 Isum.n58 0.1445
R1801 Isum.n77 Isum.n76 0.1445
R1802 Isum.n78 Isum.n77 0.1445
R1803 Isum.n79 Isum.n78 0.1445
R1804 Isum.n98 Isum.n79 0.1445
R1805 Isum.n99 Isum.n98 0.1445
R1806 Isum.n100 Isum.n99 0.1445
R1807 Isum.n910 Isum.n101 0.1445
R1808 Isum.n911 Isum.n910 0.1445
R1809 Isum.n912 Isum.n911 0.1445
R1810 Isum.n913 Isum.n912 0.1445
R1811 Isum.n920 Isum.n913 0.1445
R1812 Isum.n932 Isum.n920 0.1445
R1813 Isum.n1000 Isum.n632 0.1445
R1814 Isum.n1000 Isum.n999 0.1445
R1815 Isum.n999 Isum.n998 0.1445
R1816 Isum.n998 Isum.n996 0.1445
R1817 Isum.n996 Isum.n995 0.1445
R1818 Isum.n995 Isum.n993 0.1445
R1819 Isum.n993 Isum.n992 0.1445
R1820 Isum.n992 Isum.n990 0.1445
R1821 Isum.n990 Isum.n989 0.1445
R1822 Isum.n989 Isum.n987 0.1445
R1823 Isum.n987 Isum.n986 0.1445
R1824 Isum.n986 Isum.n984 0.1445
R1825 Isum.n984 Isum.n983 0.1445
R1826 Isum.n983 Isum.n981 0.1445
R1827 Isum.n981 Isum.n980 0.1445
R1828 Isum.n980 Isum.n979 0.1445
R1829 Isum.n979 Isum.n977 0.1445
R1830 Isum.n977 Isum.n976 0.1445
R1831 Isum.n976 Isum.n974 0.1445
R1832 Isum.n974 Isum.n973 0.1445
R1833 Isum.n973 Isum.n971 0.1445
R1834 Isum.n971 Isum.n970 0.1445
R1835 Isum.n970 Isum.n968 0.1445
R1836 Isum.n968 Isum.n967 0.1445
R1837 Isum.n967 Isum.n965 0.1445
R1838 Isum.n965 Isum.n964 0.1445
R1839 Isum.n964 Isum.n962 0.1445
R1840 Isum.n962 Isum.n961 0.1445
R1841 Isum.n961 Isum.n959 0.1445
R1842 Isum.n959 Isum.n958 0.1445
R1843 Isum.n958 Isum.n956 0.1445
R1844 Isum.n956 Isum.n955 0.1445
R1845 Isum.n955 Isum.n868 0.1445
R1846 Isum.n868 Isum.n867 0.1445
R1847 Isum.n1084 Isum.n1083 0.1445
R1848 Isum.n1083 Isum.n1082 0.1445
R1849 Isum.n1082 Isum.n528 0.1445
R1850 Isum.n1072 Isum.n528 0.1445
R1851 Isum.n1072 Isum.n1071 0.1445
R1852 Isum.n1071 Isum.n1070 0.1445
R1853 Isum.n1070 Isum.n551 0.1445
R1854 Isum.n1060 Isum.n551 0.1445
R1855 Isum.n1060 Isum.n1059 0.1445
R1856 Isum.n1059 Isum.n1058 0.1445
R1857 Isum.n1058 Isum.n572 0.1445
R1858 Isum.n1048 Isum.n572 0.1445
R1859 Isum.n1048 Isum.n1047 0.1445
R1860 Isum.n1047 Isum.n1046 0.1445
R1861 Isum.n1046 Isum.n592 0.1445
R1862 Isum.n598 Isum.n592 0.1445
R1863 Isum.n598 Isum.n597 0.1445
R1864 Isum.n597 Isum.n24 0.1445
R1865 Isum.n1186 Isum.n24 0.1445
R1866 Isum.n1186 Isum.n1185 0.1445
R1867 Isum.n1185 Isum.n1184 0.1445
R1868 Isum.n1184 Isum.n28 0.1445
R1869 Isum.n1174 Isum.n28 0.1445
R1870 Isum.n1174 Isum.n1173 0.1445
R1871 Isum.n1173 Isum.n1172 0.1445
R1872 Isum.n1172 Isum.n49 0.1445
R1873 Isum.n1162 Isum.n49 0.1445
R1874 Isum.n1162 Isum.n1161 0.1445
R1875 Isum.n1161 Isum.n1160 0.1445
R1876 Isum.n1160 Isum.n69 0.1445
R1877 Isum.n1150 Isum.n69 0.1445
R1878 Isum.n1150 Isum.n1149 0.1445
R1879 Isum.n1149 Isum.n1148 0.1445
R1880 Isum.n1148 Isum.n91 0.1445
R1881 Isum.n1085 Isum.n525 0.1445
R1882 Isum.n527 Isum.n525 0.1445
R1883 Isum.n547 Isum.n527 0.1445
R1884 Isum.n548 Isum.n547 0.1445
R1885 Isum.n549 Isum.n548 0.1445
R1886 Isum.n550 Isum.n549 0.1445
R1887 Isum.n568 Isum.n550 0.1445
R1888 Isum.n569 Isum.n568 0.1445
R1889 Isum.n570 Isum.n569 0.1445
R1890 Isum.n571 Isum.n570 0.1445
R1891 Isum.n588 Isum.n571 0.1445
R1892 Isum.n589 Isum.n588 0.1445
R1893 Isum.n590 Isum.n589 0.1445
R1894 Isum.n591 Isum.n590 0.1445
R1895 Isum.n593 Isum.n591 0.1445
R1896 Isum.n594 Isum.n593 0.1445
R1897 Isum.n596 Isum.n594 0.1445
R1898 Isum.n596 Isum.n595 0.1445
R1899 Isum.n595 Isum.n25 0.1445
R1900 Isum.n26 Isum.n25 0.1445
R1901 Isum.n27 Isum.n26 0.1445
R1902 Isum.n45 Isum.n27 0.1445
R1903 Isum.n46 Isum.n45 0.1445
R1904 Isum.n47 Isum.n46 0.1445
R1905 Isum.n48 Isum.n47 0.1445
R1906 Isum.n65 Isum.n48 0.1445
R1907 Isum.n66 Isum.n65 0.1445
R1908 Isum.n67 Isum.n66 0.1445
R1909 Isum.n68 Isum.n67 0.1445
R1910 Isum.n87 Isum.n68 0.1445
R1911 Isum.n88 Isum.n87 0.1445
R1912 Isum.n89 Isum.n88 0.1445
R1913 Isum.n90 Isum.n89 0.1445
R1914 Isum.n1136 Isum.n90 0.1445
R1915 Isum.n349 Isum.n333 0.1445
R1916 Isum.n350 Isum.n349 0.1445
R1917 Isum.n351 Isum.n350 0.1445
R1918 Isum.n351 Isum.n320 0.1445
R1919 Isum.n401 Isum.n320 0.1445
R1920 Isum.n402 Isum.n401 0.1445
R1921 Isum.n403 Isum.n402 0.1445
R1922 Isum.n403 Isum.n204 0.1445
R1923 Isum.n417 Isum.n204 0.1445
R1924 Isum.n418 Isum.n417 0.1445
R1925 Isum.n419 Isum.n418 0.1445
R1926 Isum.n419 Isum.n188 0.1445
R1927 Isum.n433 Isum.n188 0.1445
R1928 Isum.n434 Isum.n433 0.1445
R1929 Isum.n435 Isum.n434 0.1445
R1930 Isum.n435 Isum.n169 0.1445
R1931 Isum.n454 Isum.n169 0.1445
R1932 Isum.n455 Isum.n454 0.1445
R1933 Isum.n456 Isum.n455 0.1445
R1934 Isum.n457 Isum.n456 0.1445
R1935 Isum.n457 Isum.n108 0.1445
R1936 Isum.n1131 Isum.n109 0.1445
R1937 Isum.n130 Isum.n109 0.1445
R1938 Isum.n131 Isum.n130 0.1445
R1939 Isum.n132 Isum.n131 0.1445
R1940 Isum.n133 Isum.n132 0.1445
R1941 Isum.n141 Isum.n133 0.1445
R1942 Isum.n142 Isum.n141 0.1445
R1943 Isum.n1108 Isum.n142 0.1445
R1944 Isum.n343 Isum.n342 0.1445
R1945 Isum.n343 Isum.n327 0.1445
R1946 Isum.n357 Isum.n327 0.1445
R1947 Isum.n358 Isum.n357 0.1445
R1948 Isum.n359 Isum.n358 0.1445
R1949 Isum.n360 Isum.n359 0.1445
R1950 Isum.n361 Isum.n360 0.1445
R1951 Isum.n362 Isum.n361 0.1445
R1952 Isum.n363 Isum.n362 0.1445
R1953 Isum.n364 Isum.n363 0.1445
R1954 Isum.n365 Isum.n364 0.1445
R1955 Isum.n366 Isum.n365 0.1445
R1956 Isum.n367 Isum.n366 0.1445
R1957 Isum.n368 Isum.n367 0.1445
R1958 Isum.n369 Isum.n368 0.1445
R1959 Isum.n370 Isum.n369 0.1445
R1960 Isum.n371 Isum.n370 0.1445
R1961 Isum.n372 Isum.n371 0.1445
R1962 Isum.n374 Isum.n372 0.1445
R1963 Isum.n374 Isum.n373 0.1445
R1964 Isum.n373 Isum.n149 0.1445
R1965 Isum.n149 Isum.n147 0.1445
R1966 Isum.n484 Isum.n147 0.1445
R1967 Isum.n485 Isum.n484 0.1445
R1968 Isum.n486 Isum.n485 0.1445
R1969 Isum.n486 Isum.n145 0.1445
R1970 Isum.n491 Isum.n145 0.1445
R1971 Isum.n492 Isum.n491 0.1445
R1972 Isum.n493 Isum.n492 0.1445
R1973 Isum.n493 Isum.n143 0.1445
R1974 Isum.n315 Isum.n216 0.1445
R1975 Isum.n315 Isum.n217 0.1445
R1976 Isum.n310 Isum.n217 0.1445
R1977 Isum.n310 Isum.n309 0.1445
R1978 Isum.n309 Isum.n279 0.1445
R1979 Isum.n305 Isum.n279 0.1445
R1980 Isum.n305 Isum.n304 0.1445
R1981 Isum.n304 Isum.n286 0.1445
R1982 Isum.n300 Isum.n286 0.1445
R1983 Isum.n300 Isum.n299 0.1445
R1984 Isum.n299 Isum.n162 0.1445
R1985 Isum.n463 Isum.n162 0.1445
R1986 Isum.n463 Isum.n153 0.1445
R1987 Isum.n475 Isum.n153 0.1445
R1988 Isum.n475 Isum.n154 0.1445
R1989 Isum.n467 Isum.n154 0.1445
R1990 Isum.n410 Isum.n409 0.1445
R1991 Isum.n411 Isum.n410 0.1445
R1992 Isum.n411 Isum.n196 0.1445
R1993 Isum.n425 Isum.n196 0.1445
R1994 Isum.n426 Isum.n425 0.1445
R1995 Isum.n427 Isum.n426 0.1445
R1996 Isum.n427 Isum.n179 0.1445
R1997 Isum.n440 Isum.n179 0.1445
R1998 Isum.n441 Isum.n440 0.1445
R1999 Isum.n448 Isum.n441 0.1445
R2000 Isum.n448 Isum.n447 0.1445
R2001 Isum.n447 Isum.n446 0.1445
R2002 Isum.n446 Isum.n442 0.1445
R2003 Isum.n442 Isum.n121 0.1445
R2004 Isum.n1125 Isum.n121 0.1445
R2005 Isum.n1125 Isum.n1124 0.1445
R2006 Isum.n1132 Isum.n108 0.1337
R2007 Isum.n1133 Isum.n101 0.1265
R2008 Isum.n1107 Isum.n1106 0.111138
R2009 Isum.n1106 Isum.n1105 0.111138
R2010 Isum.n341 Isum.n340 0.111138
R2011 Isum.n1103 Isum.n1102 0.102461
R2012 Isum.n1104 Isum.n1103 0.102461
R2013 Isum.n931 Isum.n919 0.102461
R2014 Isum.n778 Isum.n774 0.0737173
R2015 Isum.n776 Isum.n775 0.0727085
R2016 Isum.n860 Isum.n859 0.0613362
R2017 Isum.n784 Isum.n783 0.0613362
R2018 Isum.n741 Isum.n712 0.0609263
R2019 Isum.n864 Isum.n740 0.0537268
R2020 Isum.n861 Isum.n860 0.0440889
R2021 Isum.n783 Isum.n781 0.0440889
R2022 Isum.n741 Isum.n740 0.0413911
R2023 Isum.n776 Isum.n774 0.0299032
R2024 Isum.n242 Isum.n241 0.0272885
R2025 Isum.n269 Isum.n268 0.0272885
R2026 Isum.n241 Isum.n240 0.0249386
R2027 Isum.n271 Isum.n269 0.0249386
R2028 Isum.n777 Isum.n524 0.0239
R2029 Isum.n865 Isum.n107 0.0239
R2030 Isum.n238 Isum.n236 0.0215313
R2031 Isum.n222 Isum.n220 0.0215313
R2032 Isum.n859 Isum.n743 0.0207265
R2033 Isum.n784 Isum.n773 0.0207265
R2034 Isum.n795 Isum.n772 0.0203347
R2035 Isum.n772 Isum.n769 0.0203347
R2036 Isum.n802 Isum.n801 0.0203347
R2037 Isum.n802 Isum.n766 0.0203347
R2038 Isum.n807 Isum.n764 0.0203347
R2039 Isum.n815 Isum.n764 0.0203347
R2040 Isum.n819 Isum.n761 0.0203347
R2041 Isum.n820 Isum.n819 0.0203347
R2042 Isum.n820 Isum.n758 0.0203347
R2043 Isum.n824 Isum.n758 0.0203347
R2044 Isum.n825 Isum.n824 0.0203347
R2045 Isum.n825 Isum.n754 0.0203347
R2046 Isum.n833 Isum.n755 0.0203347
R2047 Isum.n755 Isum.n752 0.0203347
R2048 Isum.n840 Isum.n839 0.0203347
R2049 Isum.n840 Isum.n748 0.0203347
R2050 Isum.n847 Isum.n749 0.0203347
R2051 Isum.n749 Isum.n746 0.0203347
R2052 Isum.n231 Isum.n230 0.0203347
R2053 Isum.n231 Isum.n226 0.0203347
R2054 Isum.n261 Isum.n227 0.0203347
R2055 Isum.n257 Isum.n227 0.0203347
R2056 Isum.n246 Isum.n235 0.0203347
R2057 Isum.n247 Isum.n246 0.0203347
R2058 Isum.n238 Isum.n157 0.019299
R2059 Isum.n250 Isum.n242 0.019299
R2060 Isum.n273 Isum.n220 0.019299
R2061 Isum.n268 Isum.n223 0.019299
R2062 Isum.n473 Isum.n157 0.018594
R2063 Isum.n313 Isum.n273 0.018594
R2064 Isum.n1133 Isum.n100 0.0185
R2065 Isum.n1135 Isum.n107 0.0185
R2066 Isum.n861 Isum.n740 0.0179042
R2067 Isum.n781 Isum.n774 0.0179042
R2068 Isum.n635 Isum.n634 0.0167896
R2069 Isum.n636 Isum.n635 0.0167896
R2070 Isum.n638 Isum.n637 0.0167896
R2071 Isum.n639 Isum.n638 0.0167896
R2072 Isum.n641 Isum.n640 0.0167896
R2073 Isum.n642 Isum.n641 0.0167896
R2074 Isum.n644 Isum.n643 0.0167896
R2075 Isum.n645 Isum.n644 0.0167896
R2076 Isum.n647 Isum.n646 0.0167896
R2077 Isum.n648 Isum.n647 0.0167896
R2078 Isum.n649 Isum.n648 0.0167896
R2079 Isum.n650 Isum.n649 0.0167896
R2080 Isum.n651 Isum.n650 0.0167896
R2081 Isum.n652 Isum.n651 0.0167896
R2082 Isum.n654 Isum.n653 0.0167896
R2083 Isum.n655 Isum.n654 0.0167896
R2084 Isum.n657 Isum.n656 0.0167896
R2085 Isum.n658 Isum.n657 0.0167896
R2086 Isum.n660 Isum.n659 0.0167896
R2087 Isum.n661 Isum.n660 0.0167896
R2088 Isum.n663 Isum.n662 0.0167896
R2089 Isum.n711 Isum.n663 0.0167896
R2090 Isum.n314 Isum.n218 0.0167896
R2091 Isum.n312 Isum.n311 0.0167896
R2092 Isum.n308 Isum.n307 0.0167896
R2093 Isum.n307 Isum.n306 0.0167896
R2094 Isum.n303 Isum.n302 0.0167896
R2095 Isum.n302 Isum.n301 0.0167896
R2096 Isum.n298 Isum.n159 0.0167896
R2097 Isum.n464 Isum.n159 0.0167896
R2098 Isum.n474 Isum.n155 0.0167896
R2099 Isum.n796 Isum.n795 0.0163678
R2100 Isum.n815 Isum.n814 0.0163678
R2101 Isum.n834 Isum.n833 0.0163678
R2102 Isum.n852 Isum.n746 0.0163678
R2103 Isum.n775 Isum.n633 0.0160769
R2104 Isum.n866 Isum.n712 0.0160769
R2105 Isum.n250 Isum.n243 0.0156567
R2106 Isum.n224 Isum.n223 0.0156567
R2107 Isum.n472 Isum.n471 0.0155679
R2108 Isum.n777 Isum.n633 0.0141425
R2109 Isum.n866 Isum.n865 0.0141425
R2110 Isum.n221 Isum.n218 0.0141425
R2111 Isum.n468 Isum.n122 0.0141425
R2112 Isum.n714 Isum.n637 0.0135317
R2113 Isum.n723 Isum.n645 0.0135317
R2114 Isum.n728 Isum.n653 0.0135317
R2115 Isum.n737 Isum.n661 0.0135317
R2116 Isum.n308 Isum.n276 0.0135317
R2117 Isum.n465 Isum.n464 0.0135317
R2118 Isum.n857 Isum.n743 0.0132003
R2119 Isum.n786 Isum.n773 0.0132003
R2120 Isum.n801 Isum.n800 0.0124008
R2121 Isum.n808 Isum.n766 0.0124008
R2122 Isum.n839 Isum.n838 0.0124008
R2123 Isum.n848 Isum.n748 0.0124008
R2124 Isum.n262 Isum.n261 0.0124008
R2125 Isum.n257 Isum.n256 0.0124008
R2126 Isum.n1132 Isum.n1131 0.0113
R2127 Isum.n717 Isum.n640 0.0102738
R2128 Isum.n720 Isum.n642 0.0102738
R2129 Isum.n731 Isum.n656 0.0102738
R2130 Isum.n734 Isum.n658 0.0102738
R2131 Isum.n303 Isum.n284 0.0102738
R2132 Isum.n301 Isum.n293 0.0102738
R2133 Isum.n252 Isum.n243 0.010017
R2134 Isum.n266 Isum.n224 0.010017
R2135 Isum.n314 Isum.n313 0.00956109
R2136 Isum.n473 Isum.n472 0.00956109
R2137 Isum.n800 Isum.n769 0.00843388
R2138 Isum.n808 Isum.n807 0.00843388
R2139 Isum.n838 Isum.n752 0.00843388
R2140 Isum.n848 Isum.n847 0.00843388
R2141 Isum.n262 Isum.n226 0.00843388
R2142 Isum.n256 Isum.n235 0.00843388
R2143 Isum.n313 Isum.n312 0.00772851
R2144 Isum.n474 Isum.n473 0.00772851
R2145 Isum.n717 Isum.n639 0.00701584
R2146 Isum.n720 Isum.n643 0.00701584
R2147 Isum.n731 Isum.n655 0.00701584
R2148 Isum.n734 Isum.n659 0.00701584
R2149 Isum.n306 Isum.n284 0.00701584
R2150 Isum.n298 Isum.n293 0.00701584
R2151 Isum.n773 Isum.n771 0.00545868
R2152 Isum.n853 Isum.n743 0.00545868
R2153 Isum.n796 Isum.n771 0.00446694
R2154 Isum.n814 Isum.n761 0.00446694
R2155 Isum.n834 Isum.n754 0.00446694
R2156 Isum.n853 Isum.n852 0.00446694
R2157 Isum.n240 Isum.n236 0.0041423
R2158 Isum.n271 Isum.n222 0.0041423
R2159 Isum.n714 Isum.n636 0.00375792
R2160 Isum.n723 Isum.n646 0.00375792
R2161 Isum.n728 Isum.n652 0.00375792
R2162 Isum.n737 Isum.n662 0.00375792
R2163 Isum.n311 Isum.n276 0.00375792
R2164 Isum.n465 Isum.n155 0.00375792
R2165 Isum.n471 Isum.n468 0.00172172
R2166 Isum.n230 Isum.n224 0.00149173
R2167 Isum.n247 Isum.n243 0.00149173
R2168 Isum.n775 Isum.n634 0.00121267
R2169 Isum.n712 Isum.n711 0.00121267
R2170 VDD.n405 VDD.n403 159.163
R2171 VDD.n486 VDD.n366 159.163
R2172 VDD.n411 VDD.n403 159.163
R2173 VDD.n486 VDD.n485 159.163
R2174 VDD.n238 VDD.n237 150.326
R2175 VDD.n279 VDD.n278 150.326
R2176 VDD.n239 VDD.n238 150.326
R2177 VDD.n278 VDD.n277 150.326
R2178 VDD.n94 VDD.n82 130.988
R2179 VDD.n551 VDD.n19 130.988
R2180 VDD.n96 VDD.n81 59.836
R2181 VDD.n97 VDD.n75 59.836
R2182 VDD.n105 VDD.n75 59.836
R2183 VDD.n108 VDD.n107 59.836
R2184 VDD.n127 VDD.t12 59.836
R2185 VDD.t12 VDD.n126 59.836
R2186 VDD.n124 VDD.n123 59.836
R2187 VDD.n122 VDD.n26 59.836
R2188 VDD.n182 VDD.n26 59.836
R2189 VDD.n550 VDD.n20 59.836
R2190 VDD.n127 VDD.t2 57.5921
R2191 VDD.n126 VDD.t0 57.5921
R2192 VDD.n549 VDD.n19 53.9033
R2193 VDD.n83 VDD.n82 53.9033
R2194 VDD.t15 VDD.n105 47.8689
R2195 VDD.t9 VDD.n122 47.8689
R2196 VDD.t24 VDD.n96 30.6662
R2197 VDD.t21 VDD.n20 30.6662
R2198 VDD.n308 VDD.t4 26.6436
R2199 VDD.n544 VDD.t1 24.2905
R2200 VDD.n309 VDD.t3 24.2905
R2201 VDD.n97 VDD.t18 23.9347
R2202 VDD.n182 VDD.t6 23.9347
R2203 VDD.n47 VDD.n46 15.8697
R2204 VDD.n29 VDD.n15 15.8697
R2205 VDD.n95 VDD.n94 14.0005
R2206 VDD.n95 VDD.n51 14.0005
R2207 VDD.n52 VDD.n51 14.0005
R2208 VDD.n53 VDD.n52 14.0005
R2209 VDD.n106 VDD.n53 14.0005
R2210 VDD.n106 VDD.n62 14.0005
R2211 VDD.n128 VDD.n62 14.0005
R2212 VDD.n128 VDD.n63 14.0005
R2213 VDD.n125 VDD.n63 14.0005
R2214 VDD.n125 VDD.n8 14.0005
R2215 VDD.n9 VDD.n8 14.0005
R2216 VDD.n10 VDD.n9 14.0005
R2217 VDD.n27 VDD.n10 14.0005
R2218 VDD.n181 VDD.n27 14.0005
R2219 VDD.n181 VDD.n18 14.0005
R2220 VDD.n551 VDD.n18 14.0005
R2221 VDD.n84 VDD.n80 14.0005
R2222 VDD.n98 VDD.n80 14.0005
R2223 VDD.n98 VDD.n76 14.0005
R2224 VDD.n104 VDD.n76 14.0005
R2225 VDD.n104 VDD.n74 14.0005
R2226 VDD.n109 VDD.n74 14.0005
R2227 VDD.n109 VDD.n64 14.0005
R2228 VDD.n65 VDD.n64 14.0005
R2229 VDD.n66 VDD.n65 14.0005
R2230 VDD.n67 VDD.n66 14.0005
R2231 VDD.n68 VDD.n67 14.0005
R2232 VDD.n121 VDD.n68 14.0005
R2233 VDD.n121 VDD.n25 14.0005
R2234 VDD.n183 VDD.n25 14.0005
R2235 VDD.n183 VDD.n21 14.0005
R2236 VDD.n548 VDD.n21 14.0005
R2237 VDD.n405 VDD.n404 14.0005
R2238 VDD.n404 VDD.n313 14.0005
R2239 VDD.n314 VDD.n313 14.0005
R2240 VDD.n315 VDD.n314 14.0005
R2241 VDD.n318 VDD.n315 14.0005
R2242 VDD.n319 VDD.n318 14.0005
R2243 VDD.n320 VDD.n319 14.0005
R2244 VDD.n321 VDD.n320 14.0005
R2245 VDD.n324 VDD.n321 14.0005
R2246 VDD.n325 VDD.n324 14.0005
R2247 VDD.n326 VDD.n325 14.0005
R2248 VDD.n327 VDD.n326 14.0005
R2249 VDD.n330 VDD.n327 14.0005
R2250 VDD.n331 VDD.n330 14.0005
R2251 VDD.n332 VDD.n331 14.0005
R2252 VDD.n333 VDD.n332 14.0005
R2253 VDD.n336 VDD.n333 14.0005
R2254 VDD.n337 VDD.n336 14.0005
R2255 VDD.n338 VDD.n337 14.0005
R2256 VDD.n339 VDD.n338 14.0005
R2257 VDD.n342 VDD.n339 14.0005
R2258 VDD.n343 VDD.n342 14.0005
R2259 VDD.n344 VDD.n343 14.0005
R2260 VDD.n345 VDD.n344 14.0005
R2261 VDD.n348 VDD.n345 14.0005
R2262 VDD.n349 VDD.n348 14.0005
R2263 VDD.n350 VDD.n349 14.0005
R2264 VDD.n351 VDD.n350 14.0005
R2265 VDD.n354 VDD.n351 14.0005
R2266 VDD.n355 VDD.n354 14.0005
R2267 VDD.n356 VDD.n355 14.0005
R2268 VDD.n357 VDD.n356 14.0005
R2269 VDD.n360 VDD.n357 14.0005
R2270 VDD.n361 VDD.n360 14.0005
R2271 VDD.n362 VDD.n361 14.0005
R2272 VDD.n363 VDD.n362 14.0005
R2273 VDD.n366 VDD.n363 14.0005
R2274 VDD.n412 VDD.n411 14.0005
R2275 VDD.n413 VDD.n412 14.0005
R2276 VDD.n413 VDD.n399 14.0005
R2277 VDD.n419 VDD.n399 14.0005
R2278 VDD.n420 VDD.n419 14.0005
R2279 VDD.n421 VDD.n420 14.0005
R2280 VDD.n421 VDD.n395 14.0005
R2281 VDD.n427 VDD.n395 14.0005
R2282 VDD.n428 VDD.n427 14.0005
R2283 VDD.n429 VDD.n428 14.0005
R2284 VDD.n429 VDD.n391 14.0005
R2285 VDD.n435 VDD.n391 14.0005
R2286 VDD.n436 VDD.n435 14.0005
R2287 VDD.n437 VDD.n436 14.0005
R2288 VDD.n437 VDD.n387 14.0005
R2289 VDD.n443 VDD.n387 14.0005
R2290 VDD.n444 VDD.n443 14.0005
R2291 VDD.n445 VDD.n444 14.0005
R2292 VDD.n445 VDD.n383 14.0005
R2293 VDD.n451 VDD.n383 14.0005
R2294 VDD.n452 VDD.n451 14.0005
R2295 VDD.n453 VDD.n452 14.0005
R2296 VDD.n453 VDD.n379 14.0005
R2297 VDD.n459 VDD.n379 14.0005
R2298 VDD.n460 VDD.n459 14.0005
R2299 VDD.n461 VDD.n460 14.0005
R2300 VDD.n461 VDD.n375 14.0005
R2301 VDD.n467 VDD.n375 14.0005
R2302 VDD.n468 VDD.n467 14.0005
R2303 VDD.n469 VDD.n468 14.0005
R2304 VDD.n469 VDD.n371 14.0005
R2305 VDD.n475 VDD.n371 14.0005
R2306 VDD.n476 VDD.n475 14.0005
R2307 VDD.n478 VDD.n476 14.0005
R2308 VDD.n478 VDD.n477 14.0005
R2309 VDD.n477 VDD.n367 14.0005
R2310 VDD.n485 VDD.n367 14.0005
R2311 VDD.n237 VDD.n234 14.0005
R2312 VDD.n234 VDD.n191 14.0005
R2313 VDD.n192 VDD.n191 14.0005
R2314 VDD.n193 VDD.n192 14.0005
R2315 VDD.n196 VDD.n193 14.0005
R2316 VDD.n197 VDD.n196 14.0005
R2317 VDD.n198 VDD.n197 14.0005
R2318 VDD.n199 VDD.n198 14.0005
R2319 VDD.n202 VDD.n199 14.0005
R2320 VDD.n203 VDD.n202 14.0005
R2321 VDD.n204 VDD.n203 14.0005
R2322 VDD.n205 VDD.n204 14.0005
R2323 VDD.n208 VDD.n205 14.0005
R2324 VDD.n209 VDD.n208 14.0005
R2325 VDD.n210 VDD.n209 14.0005
R2326 VDD.n211 VDD.n210 14.0005
R2327 VDD.n214 VDD.n211 14.0005
R2328 VDD.n279 VDD.n214 14.0005
R2329 VDD.n239 VDD.n231 14.0005
R2330 VDD.n245 VDD.n231 14.0005
R2331 VDD.n246 VDD.n245 14.0005
R2332 VDD.n247 VDD.n246 14.0005
R2333 VDD.n247 VDD.n227 14.0005
R2334 VDD.n253 VDD.n227 14.0005
R2335 VDD.n254 VDD.n253 14.0005
R2336 VDD.n255 VDD.n254 14.0005
R2337 VDD.n255 VDD.n223 14.0005
R2338 VDD.n261 VDD.n223 14.0005
R2339 VDD.n262 VDD.n261 14.0005
R2340 VDD.n263 VDD.n262 14.0005
R2341 VDD.n263 VDD.n219 14.0005
R2342 VDD.n269 VDD.n219 14.0005
R2343 VDD.n270 VDD.n269 14.0005
R2344 VDD.n271 VDD.n270 14.0005
R2345 VDD.n271 VDD.n215 14.0005
R2346 VDD.n277 VDD.n215 14.0005
R2347 VDD.n167 VDD.n166 12.5005
R2348 VDD.n165 VDD.n164 12.5005
R2349 VDD.n163 VDD.n37 12.5005
R2350 VDD.n162 VDD.n161 12.5005
R2351 VDD.n39 VDD.n38 12.5005
R2352 VDD.n156 VDD.n155 12.5005
R2353 VDD.n154 VDD.n40 12.5005
R2354 VDD.n153 VDD.n152 12.5005
R2355 VDD.n151 VDD.n150 12.5005
R2356 VDD.n179 VDD.n30 12.5005
R2357 VDD.n28 VDD.n14 12.5005
R2358 VDD.n556 VDD.n13 12.5005
R2359 VDD.n6 VDD.n4 12.5005
R2360 VDD.n561 VDD.n560 12.5005
R2361 VDD.n562 VDD.n2 12.5005
R2362 VDD VDD.n563 12.5005
R2363 VDD.n3 VDD.n0 12.5005
R2364 VDD.n131 VDD.n60 12.5005
R2365 VDD.n132 VDD.n59 12.5005
R2366 VDD.n133 VDD.n57 12.5005
R2367 VDD.n56 VDD.n49 12.5005
R2368 VDD.n137 VDD.n48 12.5005
R2369 VDD.n168 VDD.n167 12.4735
R2370 VDD.n150 VDD.n149 12.4729
R2371 VDD.n107 VDD.t15 11.9676
R2372 VDD.n123 VDD.t9 11.9676
R2373 VDD.n92 VDD.t19 11.4557
R2374 VDD.t7 VDD.n553 11.4188
R2375 VDD.n307 VDD.n306 10.9013
R2376 VDD.n543 VDD.n542 10.7663
R2377 VDD.n545 VDD.n544 10.1327
R2378 VDD.n307 VDD.t36 9.89435
R2379 VDD.n60 VDD.n3 9.86111
R2380 VDD.n562 VDD.n561 9.86111
R2381 VDD.n155 VDD.n154 9.86111
R2382 VDD.n163 VDD.n162 9.86111
R2383 VDD.n141 VDD.t25 9.1205
R2384 VDD.t25 VDD.n45 9.1205
R2385 VDD.t35 VDD.n43 9.1205
R2386 VDD.n174 VDD.t22 9.1205
R2387 VDD.n176 VDD.t22 9.1205
R2388 VDD.n169 VDD.t27 9.1205
R2389 VDD.n57 VDD.n56 8.95142
R2390 VDD.n28 VDD.n13 8.95142
R2391 VDD.n173 VDD.t20 8.56785
R2392 VDD.n143 VDD.t23 8.56785
R2393 VDD.n555 VDD.n554 7.53568
R2394 VDD.n90 VDD.n61 7.53568
R2395 VDD.n158 VDD.n157 7.53568
R2396 VDD.n89 VDD.n5 7.49884
R2397 VDD.n91 VDD.n55 7.49884
R2398 VDD.n160 VDD.n159 7.49884
R2399 VDD.n56 VDD.n48 6.52558
R2400 VDD.n30 VDD.n28 6.52558
R2401 VDD.n94 VDD.n93 6.3005
R2402 VDD.n94 VDD.n81 6.3005
R2403 VDD.n95 VDD.n50 6.3005
R2404 VDD.n96 VDD.n95 6.3005
R2405 VDD.n136 VDD.n51 6.3005
R2406 VDD.n97 VDD.n51 6.3005
R2407 VDD.n135 VDD.n52 6.3005
R2408 VDD.n75 VDD.n52 6.3005
R2409 VDD.n134 VDD.n53 6.3005
R2410 VDD.n105 VDD.n53 6.3005
R2411 VDD.n106 VDD.n54 6.3005
R2412 VDD.n107 VDD.n106 6.3005
R2413 VDD.n130 VDD.n62 6.3005
R2414 VDD.n108 VDD.n62 6.3005
R2415 VDD.n129 VDD.n128 6.3005
R2416 VDD.n128 VDD.n127 6.3005
R2417 VDD.n63 VDD.n1 6.3005
R2418 VDD.t12 VDD.n63 6.3005
R2419 VDD.n125 VDD.n7 6.3005
R2420 VDD.n126 VDD.n125 6.3005
R2421 VDD.n559 VDD.n8 6.3005
R2422 VDD.n124 VDD.n8 6.3005
R2423 VDD.n558 VDD.n9 6.3005
R2424 VDD.n123 VDD.n9 6.3005
R2425 VDD.n557 VDD.n10 6.3005
R2426 VDD.n122 VDD.n10 6.3005
R2427 VDD.n27 VDD.n11 6.3005
R2428 VDD.n27 VDD.n26 6.3005
R2429 VDD.n181 VDD.n180 6.3005
R2430 VDD.n182 VDD.n181 6.3005
R2431 VDD.n18 VDD.n17 6.3005
R2432 VDD.n20 VDD.n18 6.3005
R2433 VDD.n552 VDD.n551 6.3005
R2434 VDD.n551 VDD.n550 6.3005
R2435 VDD.n548 VDD.n547 6.3005
R2436 VDD.n22 VDD.n21 6.3005
R2437 VDD.n21 VDD.n20 6.3005
R2438 VDD.n184 VDD.n183 6.3005
R2439 VDD.n183 VDD.n182 6.3005
R2440 VDD.n25 VDD.n24 6.3005
R2441 VDD.n26 VDD.n25 6.3005
R2442 VDD.n121 VDD.n120 6.3005
R2443 VDD.n122 VDD.n121 6.3005
R2444 VDD.n69 VDD.n68 6.3005
R2445 VDD.n123 VDD.n68 6.3005
R2446 VDD.n116 VDD.n67 6.3005
R2447 VDD.n124 VDD.n67 6.3005
R2448 VDD.n115 VDD.n66 6.3005
R2449 VDD.n126 VDD.n66 6.3005
R2450 VDD.n114 VDD.n65 6.3005
R2451 VDD.t12 VDD.n65 6.3005
R2452 VDD.n71 VDD.n64 6.3005
R2453 VDD.n127 VDD.n64 6.3005
R2454 VDD.n110 VDD.n109 6.3005
R2455 VDD.n109 VDD.n108 6.3005
R2456 VDD.n74 VDD.n73 6.3005
R2457 VDD.n107 VDD.n74 6.3005
R2458 VDD.n104 VDD.n103 6.3005
R2459 VDD.n105 VDD.n104 6.3005
R2460 VDD.n77 VDD.n76 6.3005
R2461 VDD.n76 VDD.n75 6.3005
R2462 VDD.n99 VDD.n98 6.3005
R2463 VDD.n98 VDD.n97 6.3005
R2464 VDD.n80 VDD.n79 6.3005
R2465 VDD.n96 VDD.n80 6.3005
R2466 VDD.n85 VDD.n84 6.3005
R2467 VDD.n366 VDD.n364 6.3005
R2468 VDD.n490 VDD.n363 6.3005
R2469 VDD.n491 VDD.n362 6.3005
R2470 VDD.n492 VDD.n361 6.3005
R2471 VDD.n360 VDD.n358 6.3005
R2472 VDD.n496 VDD.n357 6.3005
R2473 VDD.n497 VDD.n356 6.3005
R2474 VDD.n498 VDD.n355 6.3005
R2475 VDD.n354 VDD.n352 6.3005
R2476 VDD.n502 VDD.n351 6.3005
R2477 VDD.n503 VDD.n350 6.3005
R2478 VDD.n504 VDD.n349 6.3005
R2479 VDD.n348 VDD.n346 6.3005
R2480 VDD.n508 VDD.n345 6.3005
R2481 VDD.n509 VDD.n344 6.3005
R2482 VDD.n510 VDD.n343 6.3005
R2483 VDD.n342 VDD.n340 6.3005
R2484 VDD.n514 VDD.n339 6.3005
R2485 VDD.n515 VDD.n338 6.3005
R2486 VDD.n516 VDD.n337 6.3005
R2487 VDD.n336 VDD.n334 6.3005
R2488 VDD.n520 VDD.n333 6.3005
R2489 VDD.n521 VDD.n332 6.3005
R2490 VDD.n522 VDD.n331 6.3005
R2491 VDD.n330 VDD.n328 6.3005
R2492 VDD.n526 VDD.n327 6.3005
R2493 VDD.n527 VDD.n326 6.3005
R2494 VDD.n528 VDD.n325 6.3005
R2495 VDD.n324 VDD.n322 6.3005
R2496 VDD.n532 VDD.n321 6.3005
R2497 VDD.n533 VDD.n320 6.3005
R2498 VDD.n534 VDD.n319 6.3005
R2499 VDD.n318 VDD.n316 6.3005
R2500 VDD.n538 VDD.n315 6.3005
R2501 VDD.n539 VDD.n314 6.3005
R2502 VDD.n540 VDD.n313 6.3005
R2503 VDD.n404 VDD.n312 6.3005
R2504 VDD.n406 VDD.n405 6.3005
R2505 VDD.n485 VDD.n484 6.3005
R2506 VDD.n483 VDD.n367 6.3005
R2507 VDD.n477 VDD.n368 6.3005
R2508 VDD.n479 VDD.n478 6.3005
R2509 VDD.n476 VDD.n370 6.3005
R2510 VDD.n475 VDD.n474 6.3005
R2511 VDD.n372 VDD.n371 6.3005
R2512 VDD.n470 VDD.n469 6.3005
R2513 VDD.n468 VDD.n374 6.3005
R2514 VDD.n467 VDD.n466 6.3005
R2515 VDD.n376 VDD.n375 6.3005
R2516 VDD.n462 VDD.n461 6.3005
R2517 VDD.n460 VDD.n378 6.3005
R2518 VDD.n459 VDD.n458 6.3005
R2519 VDD.n380 VDD.n379 6.3005
R2520 VDD.n454 VDD.n453 6.3005
R2521 VDD.n452 VDD.n382 6.3005
R2522 VDD.n451 VDD.n450 6.3005
R2523 VDD.n384 VDD.n383 6.3005
R2524 VDD.n446 VDD.n445 6.3005
R2525 VDD.n444 VDD.n386 6.3005
R2526 VDD.n443 VDD.n442 6.3005
R2527 VDD.n388 VDD.n387 6.3005
R2528 VDD.n438 VDD.n437 6.3005
R2529 VDD.n436 VDD.n390 6.3005
R2530 VDD.n435 VDD.n434 6.3005
R2531 VDD.n392 VDD.n391 6.3005
R2532 VDD.n430 VDD.n429 6.3005
R2533 VDD.n428 VDD.n394 6.3005
R2534 VDD.n427 VDD.n426 6.3005
R2535 VDD.n396 VDD.n395 6.3005
R2536 VDD.n422 VDD.n421 6.3005
R2537 VDD.n420 VDD.n398 6.3005
R2538 VDD.n419 VDD.n418 6.3005
R2539 VDD.n400 VDD.n399 6.3005
R2540 VDD.n414 VDD.n413 6.3005
R2541 VDD.n412 VDD.n402 6.3005
R2542 VDD.n411 VDD.n410 6.3005
R2543 VDD.n280 VDD.n279 6.3005
R2544 VDD.n214 VDD.n212 6.3005
R2545 VDD.n284 VDD.n211 6.3005
R2546 VDD.n285 VDD.n210 6.3005
R2547 VDD.n286 VDD.n209 6.3005
R2548 VDD.n208 VDD.n206 6.3005
R2549 VDD.n290 VDD.n205 6.3005
R2550 VDD.n291 VDD.n204 6.3005
R2551 VDD.n292 VDD.n203 6.3005
R2552 VDD.n202 VDD.n200 6.3005
R2553 VDD.n296 VDD.n199 6.3005
R2554 VDD.n297 VDD.n198 6.3005
R2555 VDD.n298 VDD.n197 6.3005
R2556 VDD.n196 VDD.n194 6.3005
R2557 VDD.n302 VDD.n193 6.3005
R2558 VDD.n303 VDD.n192 6.3005
R2559 VDD.n304 VDD.n191 6.3005
R2560 VDD.n234 VDD.n190 6.3005
R2561 VDD.n237 VDD.n236 6.3005
R2562 VDD.n277 VDD.n276 6.3005
R2563 VDD.n216 VDD.n215 6.3005
R2564 VDD.n272 VDD.n271 6.3005
R2565 VDD.n270 VDD.n218 6.3005
R2566 VDD.n269 VDD.n268 6.3005
R2567 VDD.n220 VDD.n219 6.3005
R2568 VDD.n264 VDD.n263 6.3005
R2569 VDD.n262 VDD.n222 6.3005
R2570 VDD.n261 VDD.n260 6.3005
R2571 VDD.n224 VDD.n223 6.3005
R2572 VDD.n256 VDD.n255 6.3005
R2573 VDD.n254 VDD.n226 6.3005
R2574 VDD.n253 VDD.n252 6.3005
R2575 VDD.n228 VDD.n227 6.3005
R2576 VDD.n248 VDD.n247 6.3005
R2577 VDD.n246 VDD.n230 6.3005
R2578 VDD.n245 VDD.n244 6.3005
R2579 VDD.n232 VDD.n231 6.3005
R2580 VDD.n240 VDD.n239 6.3005
R2581 VDD.n488 VDD.n487 6.28904
R2582 VDD.n487 VDD.n365 6.28904
R2583 VDD.n409 VDD.n408 6.28904
R2584 VDD.n408 VDD.n407 6.28904
R2585 VDD.n281 VDD.n213 6.1864
R2586 VDD.n275 VDD.n213 6.1864
R2587 VDD.n241 VDD.n233 6.1864
R2588 VDD.n235 VDD.n233 6.1864
R2589 VDD.n87 VDD.n86 5.97263
R2590 VDD.n88 VDD.n87 5.85203
R2591 VDD.n187 VDD.n16 5.75561
R2592 VDD.n545 VDD.n187 5.72861
R2593 VDD.n60 VDD.n59 5.61588
R2594 VDD.n563 VDD.n3 5.61588
R2595 VDD.n563 VDD.n562 5.61588
R2596 VDD.n561 VDD.n4 5.61588
R2597 VDD.n154 VDD.n153 5.61588
R2598 VDD.n155 VDD.n38 5.61588
R2599 VDD.n162 VDD.n38 5.61588
R2600 VDD.n164 VDD.n163 5.61588
R2601 VDD.t18 VDD.t24 5.2361
R2602 VDD.t6 VDD.t21 5.2361
R2603 VDD.n147 VDD.n146 5.2005
R2604 VDD.n171 VDD.n34 5.2005
R2605 VDD.n139 VDD.n45 4.85463
R2606 VDD.n144 VDD.n43 4.85463
R2607 VDD.n177 VDD.n176 4.85463
R2608 VDD.n172 VDD.n171 4.85463
R2609 VDD.n141 VDD.n140 4.69811
R2610 VDD.n147 VDD.n145 4.69811
R2611 VDD.n174 VDD.n31 4.69811
R2612 VDD.n169 VDD.n33 4.69811
R2613 VDD.n402 VDD.n401 4.5005
R2614 VDD.n415 VDD.n414 4.5005
R2615 VDD.n416 VDD.n400 4.5005
R2616 VDD.n418 VDD.n417 4.5005
R2617 VDD.n398 VDD.n397 4.5005
R2618 VDD.n423 VDD.n422 4.5005
R2619 VDD.n424 VDD.n396 4.5005
R2620 VDD.n426 VDD.n425 4.5005
R2621 VDD.n394 VDD.n393 4.5005
R2622 VDD.n431 VDD.n430 4.5005
R2623 VDD.n432 VDD.n392 4.5005
R2624 VDD.n434 VDD.n433 4.5005
R2625 VDD.n390 VDD.n389 4.5005
R2626 VDD.n439 VDD.n438 4.5005
R2627 VDD.n440 VDD.n388 4.5005
R2628 VDD.n442 VDD.n441 4.5005
R2629 VDD.n386 VDD.n385 4.5005
R2630 VDD.n447 VDD.n446 4.5005
R2631 VDD.n448 VDD.n384 4.5005
R2632 VDD.n450 VDD.n449 4.5005
R2633 VDD.n382 VDD.n381 4.5005
R2634 VDD.n455 VDD.n454 4.5005
R2635 VDD.n456 VDD.n380 4.5005
R2636 VDD.n458 VDD.n457 4.5005
R2637 VDD.n378 VDD.n377 4.5005
R2638 VDD.n463 VDD.n462 4.5005
R2639 VDD.n464 VDD.n376 4.5005
R2640 VDD.n466 VDD.n465 4.5005
R2641 VDD.n374 VDD.n373 4.5005
R2642 VDD.n471 VDD.n470 4.5005
R2643 VDD.n472 VDD.n372 4.5005
R2644 VDD.n474 VDD.n473 4.5005
R2645 VDD.n370 VDD.n369 4.5005
R2646 VDD.n480 VDD.n479 4.5005
R2647 VDD.n481 VDD.n368 4.5005
R2648 VDD.n483 VDD.n482 4.5005
R2649 VDD.n484 VDD.n365 4.5005
R2650 VDD.n410 VDD.n409 4.5005
R2651 VDD.n312 VDD.n310 4.5005
R2652 VDD.n541 VDD.n540 4.5005
R2653 VDD.n539 VDD.n311 4.5005
R2654 VDD.n538 VDD.n537 4.5005
R2655 VDD.n536 VDD.n316 4.5005
R2656 VDD.n535 VDD.n534 4.5005
R2657 VDD.n533 VDD.n317 4.5005
R2658 VDD.n532 VDD.n531 4.5005
R2659 VDD.n530 VDD.n322 4.5005
R2660 VDD.n529 VDD.n528 4.5005
R2661 VDD.n527 VDD.n323 4.5005
R2662 VDD.n526 VDD.n525 4.5005
R2663 VDD.n524 VDD.n328 4.5005
R2664 VDD.n523 VDD.n522 4.5005
R2665 VDD.n521 VDD.n329 4.5005
R2666 VDD.n520 VDD.n519 4.5005
R2667 VDD.n518 VDD.n334 4.5005
R2668 VDD.n517 VDD.n516 4.5005
R2669 VDD.n515 VDD.n335 4.5005
R2670 VDD.n514 VDD.n513 4.5005
R2671 VDD.n512 VDD.n340 4.5005
R2672 VDD.n511 VDD.n510 4.5005
R2673 VDD.n509 VDD.n341 4.5005
R2674 VDD.n508 VDD.n507 4.5005
R2675 VDD.n506 VDD.n346 4.5005
R2676 VDD.n505 VDD.n504 4.5005
R2677 VDD.n503 VDD.n347 4.5005
R2678 VDD.n502 VDD.n501 4.5005
R2679 VDD.n500 VDD.n352 4.5005
R2680 VDD.n499 VDD.n498 4.5005
R2681 VDD.n497 VDD.n353 4.5005
R2682 VDD.n496 VDD.n495 4.5005
R2683 VDD.n494 VDD.n358 4.5005
R2684 VDD.n493 VDD.n492 4.5005
R2685 VDD.n491 VDD.n359 4.5005
R2686 VDD.n490 VDD.n489 4.5005
R2687 VDD.n488 VDD.n364 4.5005
R2688 VDD.n407 VDD.n406 4.5005
R2689 VDD.n242 VDD.n232 4.5005
R2690 VDD.n244 VDD.n243 4.5005
R2691 VDD.n230 VDD.n229 4.5005
R2692 VDD.n249 VDD.n248 4.5005
R2693 VDD.n250 VDD.n228 4.5005
R2694 VDD.n252 VDD.n251 4.5005
R2695 VDD.n226 VDD.n225 4.5005
R2696 VDD.n257 VDD.n256 4.5005
R2697 VDD.n258 VDD.n224 4.5005
R2698 VDD.n260 VDD.n259 4.5005
R2699 VDD.n222 VDD.n221 4.5005
R2700 VDD.n265 VDD.n264 4.5005
R2701 VDD.n266 VDD.n220 4.5005
R2702 VDD.n268 VDD.n267 4.5005
R2703 VDD.n218 VDD.n217 4.5005
R2704 VDD.n273 VDD.n272 4.5005
R2705 VDD.n274 VDD.n216 4.5005
R2706 VDD.n276 VDD.n275 4.5005
R2707 VDD.n241 VDD.n240 4.5005
R2708 VDD.n190 VDD.n188 4.5005
R2709 VDD.n305 VDD.n304 4.5005
R2710 VDD.n303 VDD.n189 4.5005
R2711 VDD.n302 VDD.n301 4.5005
R2712 VDD.n300 VDD.n194 4.5005
R2713 VDD.n299 VDD.n298 4.5005
R2714 VDD.n297 VDD.n195 4.5005
R2715 VDD.n296 VDD.n295 4.5005
R2716 VDD.n294 VDD.n200 4.5005
R2717 VDD.n293 VDD.n292 4.5005
R2718 VDD.n291 VDD.n201 4.5005
R2719 VDD.n290 VDD.n289 4.5005
R2720 VDD.n288 VDD.n206 4.5005
R2721 VDD.n287 VDD.n286 4.5005
R2722 VDD.n285 VDD.n207 4.5005
R2723 VDD.n284 VDD.n283 4.5005
R2724 VDD.n282 VDD.n212 4.5005
R2725 VDD.n281 VDD.n280 4.5005
R2726 VDD.n236 VDD.n235 4.5005
R2727 VDD.n79 VDD.n78 4.5005
R2728 VDD.n100 VDD.n99 4.5005
R2729 VDD.n101 VDD.n77 4.5005
R2730 VDD.n103 VDD.n102 4.5005
R2731 VDD.n73 VDD.n72 4.5005
R2732 VDD.n111 VDD.n110 4.5005
R2733 VDD.n112 VDD.n71 4.5005
R2734 VDD.n114 VDD.n113 4.5005
R2735 VDD.n115 VDD.n70 4.5005
R2736 VDD.n117 VDD.n116 4.5005
R2737 VDD.n118 VDD.n69 4.5005
R2738 VDD.n120 VDD.n119 4.5005
R2739 VDD.n24 VDD.n23 4.5005
R2740 VDD.n185 VDD.n184 4.5005
R2741 VDD.n186 VDD.n22 4.5005
R2742 VDD.n547 VDD.n546 4.5005
R2743 VDD.n86 VDD.n85 4.5005
R2744 VDD.n171 VDD.n170 4.5005
R2745 VDD.n170 VDD.n169 4.5005
R2746 VDD.n176 VDD.n175 4.5005
R2747 VDD.n175 VDD.n174 4.5005
R2748 VDD.n148 VDD.n43 4.5005
R2749 VDD.n148 VDD.n147 4.5005
R2750 VDD.n142 VDD.n45 4.5005
R2751 VDD.n142 VDD.n141 4.5005
R2752 VDD.n93 VDD.n92 4.5005
R2753 VDD.n50 VDD.n46 4.5005
R2754 VDD.n137 VDD.n136 4.5005
R2755 VDD.n135 VDD.n49 4.5005
R2756 VDD.n134 VDD.n133 4.5005
R2757 VDD.n132 VDD.n54 4.5005
R2758 VDD.n131 VDD.n130 4.5005
R2759 VDD.n129 VDD.n0 4.5005
R2760 VDD VDD.n1 4.5005
R2761 VDD.n7 VDD.n2 4.5005
R2762 VDD.n560 VDD.n559 4.5005
R2763 VDD.n558 VDD.n6 4.5005
R2764 VDD.n557 VDD.n556 4.5005
R2765 VDD.n14 VDD.n11 4.5005
R2766 VDD.n180 VDD.n179 4.5005
R2767 VDD.n17 VDD.n15 4.5005
R2768 VDD.n553 VDD.n552 4.5005
R2769 VDD.n58 VDD.n57 4.49281
R2770 VDD.n13 VDD.n12 4.49281
R2771 VDD.n150 VDD.n41 4.49281
R2772 VDD.n167 VDD.n36 4.49281
R2773 VDD.n554 VDD.t10 3.9205
R2774 VDD.n554 VDD.t7 3.9205
R2775 VDD.t13 VDD.n89 3.9205
R2776 VDD.n89 VDD.t10 3.9205
R2777 VDD.t16 VDD.n90 3.9205
R2778 VDD.n90 VDD.t13 3.9205
R2779 VDD.t19 VDD.n91 3.9205
R2780 VDD.n91 VDD.t16 3.9205
R2781 VDD.n146 VDD.t35 3.9205
R2782 VDD.n146 VDD.t33 3.9205
R2783 VDD.n159 VDD.t31 3.9205
R2784 VDD.n159 VDD.t29 3.9205
R2785 VDD.n158 VDD.t33 3.9205
R2786 VDD.t31 VDD.n158 3.9205
R2787 VDD.t29 VDD.n34 3.9205
R2788 VDD.t27 VDD.n34 3.9205
R2789 VDD.n149 VDD.t34 3.9035
R2790 VDD.n168 VDD.t26 3.90299
R2791 VDD.n549 VDD.n548 3.53837
R2792 VDD.n84 VDD.n83 3.53837
R2793 VDD.n32 VDD.n16 3.49121
R2794 VDD.n88 VDD.n44 3.49121
R2795 VDD.n309 VDD.n308 3.4493
R2796 VDD.n170 VDD.n168 3.09098
R2797 VDD.n149 VDD.n148 3.09091
R2798 VDD.n83 VDD.n81 2.5935
R2799 VDD.n550 VDD.n549 2.5935
R2800 VDD.n48 VDD.n47 2.24665
R2801 VDD.n30 VDD.n29 2.24665
R2802 VDD.n108 VDD.t2 2.24433
R2803 VDD.t0 VDD.n124 2.24433
R2804 VDD.n308 VDD.n307 1.3163
R2805 VDD.n59 VDD.n58 1.12358
R2806 VDD.n12 VDD.n4 1.12358
R2807 VDD.n153 VDD.n41 1.12358
R2808 VDD.n164 VDD.n36 1.12358
R2809 VDD.n563 VDD.t11 0.913
R2810 VDD.n47 VDD.t17 0.913
R2811 VDD.n58 VDD.t14 0.913
R2812 VDD.n12 VDD.t8 0.913
R2813 VDD.n29 VDD.t5 0.913
R2814 VDD.n38 VDD.t30 0.913
R2815 VDD.n41 VDD.t32 0.913
R2816 VDD.n36 VDD.t28 0.913
R2817 VDD.n544 VDD.n543 0.3839
R2818 VDD.n187 VDD.n19 0.263
R2819 VDD.n87 VDD.n82 0.263
R2820 VDD.n278 VDD.n213 0.2255
R2821 VDD.n238 VDD.n233 0.2255
R2822 VDD.n487 VDD.n486 0.203726
R2823 VDD.n408 VDD.n403 0.203726
R2824 VDD.n543 VDD.n309 0.1823
R2825 VDD.n546 VDD.n545 0.1481
R2826 VDD.n85 VDD.n79 0.1445
R2827 VDD.n99 VDD.n79 0.1445
R2828 VDD.n99 VDD.n77 0.1445
R2829 VDD.n103 VDD.n77 0.1445
R2830 VDD.n103 VDD.n73 0.1445
R2831 VDD.n110 VDD.n73 0.1445
R2832 VDD.n110 VDD.n71 0.1445
R2833 VDD.n114 VDD.n71 0.1445
R2834 VDD.n115 VDD.n114 0.1445
R2835 VDD.n116 VDD.n115 0.1445
R2836 VDD.n116 VDD.n69 0.1445
R2837 VDD.n120 VDD.n69 0.1445
R2838 VDD.n120 VDD.n24 0.1445
R2839 VDD.n184 VDD.n24 0.1445
R2840 VDD.n184 VDD.n22 0.1445
R2841 VDD.n547 VDD.n22 0.1445
R2842 VDD.n93 VDD.n50 0.1445
R2843 VDD.n136 VDD.n50 0.1445
R2844 VDD.n136 VDD.n135 0.1445
R2845 VDD.n135 VDD.n134 0.1445
R2846 VDD.n134 VDD.n54 0.1445
R2847 VDD.n130 VDD.n54 0.1445
R2848 VDD.n130 VDD.n129 0.1445
R2849 VDD.n129 VDD.n1 0.1445
R2850 VDD.n7 VDD.n1 0.1445
R2851 VDD.n559 VDD.n7 0.1445
R2852 VDD.n559 VDD.n558 0.1445
R2853 VDD.n558 VDD.n557 0.1445
R2854 VDD.n557 VDD.n11 0.1445
R2855 VDD.n180 VDD.n11 0.1445
R2856 VDD.n180 VDD.n17 0.1445
R2857 VDD.n552 VDD.n17 0.1445
R2858 VDD.n410 VDD.n402 0.1445
R2859 VDD.n414 VDD.n402 0.1445
R2860 VDD.n414 VDD.n400 0.1445
R2861 VDD.n418 VDD.n400 0.1445
R2862 VDD.n418 VDD.n398 0.1445
R2863 VDD.n422 VDD.n398 0.1445
R2864 VDD.n422 VDD.n396 0.1445
R2865 VDD.n426 VDD.n396 0.1445
R2866 VDD.n426 VDD.n394 0.1445
R2867 VDD.n430 VDD.n394 0.1445
R2868 VDD.n430 VDD.n392 0.1445
R2869 VDD.n434 VDD.n392 0.1445
R2870 VDD.n434 VDD.n390 0.1445
R2871 VDD.n438 VDD.n390 0.1445
R2872 VDD.n438 VDD.n388 0.1445
R2873 VDD.n442 VDD.n388 0.1445
R2874 VDD.n442 VDD.n386 0.1445
R2875 VDD.n446 VDD.n386 0.1445
R2876 VDD.n446 VDD.n384 0.1445
R2877 VDD.n450 VDD.n384 0.1445
R2878 VDD.n450 VDD.n382 0.1445
R2879 VDD.n454 VDD.n382 0.1445
R2880 VDD.n454 VDD.n380 0.1445
R2881 VDD.n458 VDD.n380 0.1445
R2882 VDD.n458 VDD.n378 0.1445
R2883 VDD.n462 VDD.n378 0.1445
R2884 VDD.n462 VDD.n376 0.1445
R2885 VDD.n466 VDD.n376 0.1445
R2886 VDD.n466 VDD.n374 0.1445
R2887 VDD.n470 VDD.n374 0.1445
R2888 VDD.n470 VDD.n372 0.1445
R2889 VDD.n474 VDD.n372 0.1445
R2890 VDD.n474 VDD.n370 0.1445
R2891 VDD.n479 VDD.n370 0.1445
R2892 VDD.n479 VDD.n368 0.1445
R2893 VDD.n483 VDD.n368 0.1445
R2894 VDD.n484 VDD.n483 0.1445
R2895 VDD.n406 VDD.n312 0.1445
R2896 VDD.n540 VDD.n312 0.1445
R2897 VDD.n540 VDD.n539 0.1445
R2898 VDD.n539 VDD.n538 0.1445
R2899 VDD.n538 VDD.n316 0.1445
R2900 VDD.n534 VDD.n316 0.1445
R2901 VDD.n534 VDD.n533 0.1445
R2902 VDD.n533 VDD.n532 0.1445
R2903 VDD.n532 VDD.n322 0.1445
R2904 VDD.n528 VDD.n322 0.1445
R2905 VDD.n528 VDD.n527 0.1445
R2906 VDD.n527 VDD.n526 0.1445
R2907 VDD.n526 VDD.n328 0.1445
R2908 VDD.n522 VDD.n328 0.1445
R2909 VDD.n522 VDD.n521 0.1445
R2910 VDD.n521 VDD.n520 0.1445
R2911 VDD.n520 VDD.n334 0.1445
R2912 VDD.n516 VDD.n334 0.1445
R2913 VDD.n516 VDD.n515 0.1445
R2914 VDD.n515 VDD.n514 0.1445
R2915 VDD.n514 VDD.n340 0.1445
R2916 VDD.n510 VDD.n340 0.1445
R2917 VDD.n510 VDD.n509 0.1445
R2918 VDD.n509 VDD.n508 0.1445
R2919 VDD.n508 VDD.n346 0.1445
R2920 VDD.n504 VDD.n346 0.1445
R2921 VDD.n504 VDD.n503 0.1445
R2922 VDD.n503 VDD.n502 0.1445
R2923 VDD.n502 VDD.n352 0.1445
R2924 VDD.n498 VDD.n352 0.1445
R2925 VDD.n498 VDD.n497 0.1445
R2926 VDD.n497 VDD.n496 0.1445
R2927 VDD.n496 VDD.n358 0.1445
R2928 VDD.n492 VDD.n358 0.1445
R2929 VDD.n492 VDD.n491 0.1445
R2930 VDD.n491 VDD.n490 0.1445
R2931 VDD.n490 VDD.n364 0.1445
R2932 VDD.n409 VDD.n401 0.1445
R2933 VDD.n415 VDD.n401 0.1445
R2934 VDD.n416 VDD.n415 0.1445
R2935 VDD.n417 VDD.n416 0.1445
R2936 VDD.n417 VDD.n397 0.1445
R2937 VDD.n423 VDD.n397 0.1445
R2938 VDD.n424 VDD.n423 0.1445
R2939 VDD.n425 VDD.n424 0.1445
R2940 VDD.n425 VDD.n393 0.1445
R2941 VDD.n431 VDD.n393 0.1445
R2942 VDD.n432 VDD.n431 0.1445
R2943 VDD.n433 VDD.n432 0.1445
R2944 VDD.n433 VDD.n389 0.1445
R2945 VDD.n439 VDD.n389 0.1445
R2946 VDD.n440 VDD.n439 0.1445
R2947 VDD.n441 VDD.n440 0.1445
R2948 VDD.n441 VDD.n385 0.1445
R2949 VDD.n447 VDD.n385 0.1445
R2950 VDD.n448 VDD.n447 0.1445
R2951 VDD.n449 VDD.n448 0.1445
R2952 VDD.n449 VDD.n381 0.1445
R2953 VDD.n455 VDD.n381 0.1445
R2954 VDD.n456 VDD.n455 0.1445
R2955 VDD.n457 VDD.n456 0.1445
R2956 VDD.n457 VDD.n377 0.1445
R2957 VDD.n463 VDD.n377 0.1445
R2958 VDD.n464 VDD.n463 0.1445
R2959 VDD.n465 VDD.n464 0.1445
R2960 VDD.n465 VDD.n373 0.1445
R2961 VDD.n471 VDD.n373 0.1445
R2962 VDD.n472 VDD.n471 0.1445
R2963 VDD.n473 VDD.n472 0.1445
R2964 VDD.n473 VDD.n369 0.1445
R2965 VDD.n480 VDD.n369 0.1445
R2966 VDD.n481 VDD.n480 0.1445
R2967 VDD.n482 VDD.n481 0.1445
R2968 VDD.n482 VDD.n365 0.1445
R2969 VDD.n407 VDD.n310 0.1445
R2970 VDD.n541 VDD.n311 0.1445
R2971 VDD.n537 VDD.n311 0.1445
R2972 VDD.n537 VDD.n536 0.1445
R2973 VDD.n536 VDD.n535 0.1445
R2974 VDD.n535 VDD.n317 0.1445
R2975 VDD.n531 VDD.n317 0.1445
R2976 VDD.n531 VDD.n530 0.1445
R2977 VDD.n530 VDD.n529 0.1445
R2978 VDD.n529 VDD.n323 0.1445
R2979 VDD.n525 VDD.n323 0.1445
R2980 VDD.n525 VDD.n524 0.1445
R2981 VDD.n524 VDD.n523 0.1445
R2982 VDD.n523 VDD.n329 0.1445
R2983 VDD.n519 VDD.n329 0.1445
R2984 VDD.n519 VDD.n518 0.1445
R2985 VDD.n518 VDD.n517 0.1445
R2986 VDD.n517 VDD.n335 0.1445
R2987 VDD.n513 VDD.n335 0.1445
R2988 VDD.n513 VDD.n512 0.1445
R2989 VDD.n512 VDD.n511 0.1445
R2990 VDD.n511 VDD.n341 0.1445
R2991 VDD.n507 VDD.n341 0.1445
R2992 VDD.n507 VDD.n506 0.1445
R2993 VDD.n506 VDD.n505 0.1445
R2994 VDD.n505 VDD.n347 0.1445
R2995 VDD.n501 VDD.n347 0.1445
R2996 VDD.n501 VDD.n500 0.1445
R2997 VDD.n500 VDD.n499 0.1445
R2998 VDD.n499 VDD.n353 0.1445
R2999 VDD.n495 VDD.n353 0.1445
R3000 VDD.n495 VDD.n494 0.1445
R3001 VDD.n494 VDD.n493 0.1445
R3002 VDD.n493 VDD.n359 0.1445
R3003 VDD.n489 VDD.n359 0.1445
R3004 VDD.n489 VDD.n488 0.1445
R3005 VDD.n240 VDD.n232 0.1445
R3006 VDD.n244 VDD.n232 0.1445
R3007 VDD.n244 VDD.n230 0.1445
R3008 VDD.n248 VDD.n230 0.1445
R3009 VDD.n248 VDD.n228 0.1445
R3010 VDD.n252 VDD.n228 0.1445
R3011 VDD.n252 VDD.n226 0.1445
R3012 VDD.n256 VDD.n226 0.1445
R3013 VDD.n256 VDD.n224 0.1445
R3014 VDD.n260 VDD.n224 0.1445
R3015 VDD.n260 VDD.n222 0.1445
R3016 VDD.n264 VDD.n222 0.1445
R3017 VDD.n264 VDD.n220 0.1445
R3018 VDD.n268 VDD.n220 0.1445
R3019 VDD.n268 VDD.n218 0.1445
R3020 VDD.n272 VDD.n218 0.1445
R3021 VDD.n272 VDD.n216 0.1445
R3022 VDD.n276 VDD.n216 0.1445
R3023 VDD.n236 VDD.n190 0.1445
R3024 VDD.n304 VDD.n190 0.1445
R3025 VDD.n304 VDD.n303 0.1445
R3026 VDD.n303 VDD.n302 0.1445
R3027 VDD.n302 VDD.n194 0.1445
R3028 VDD.n298 VDD.n194 0.1445
R3029 VDD.n298 VDD.n297 0.1445
R3030 VDD.n297 VDD.n296 0.1445
R3031 VDD.n296 VDD.n200 0.1445
R3032 VDD.n292 VDD.n200 0.1445
R3033 VDD.n292 VDD.n291 0.1445
R3034 VDD.n291 VDD.n290 0.1445
R3035 VDD.n290 VDD.n206 0.1445
R3036 VDD.n286 VDD.n206 0.1445
R3037 VDD.n286 VDD.n285 0.1445
R3038 VDD.n285 VDD.n284 0.1445
R3039 VDD.n284 VDD.n212 0.1445
R3040 VDD.n280 VDD.n212 0.1445
R3041 VDD.n242 VDD.n241 0.1445
R3042 VDD.n243 VDD.n242 0.1445
R3043 VDD.n243 VDD.n229 0.1445
R3044 VDD.n249 VDD.n229 0.1445
R3045 VDD.n250 VDD.n249 0.1445
R3046 VDD.n251 VDD.n250 0.1445
R3047 VDD.n251 VDD.n225 0.1445
R3048 VDD.n257 VDD.n225 0.1445
R3049 VDD.n258 VDD.n257 0.1445
R3050 VDD.n259 VDD.n258 0.1445
R3051 VDD.n259 VDD.n221 0.1445
R3052 VDD.n265 VDD.n221 0.1445
R3053 VDD.n266 VDD.n265 0.1445
R3054 VDD.n267 VDD.n266 0.1445
R3055 VDD.n267 VDD.n217 0.1445
R3056 VDD.n273 VDD.n217 0.1445
R3057 VDD.n274 VDD.n273 0.1445
R3058 VDD.n275 VDD.n274 0.1445
R3059 VDD.n235 VDD.n188 0.1445
R3060 VDD.n305 VDD.n189 0.1445
R3061 VDD.n301 VDD.n189 0.1445
R3062 VDD.n301 VDD.n300 0.1445
R3063 VDD.n300 VDD.n299 0.1445
R3064 VDD.n299 VDD.n195 0.1445
R3065 VDD.n295 VDD.n195 0.1445
R3066 VDD.n295 VDD.n294 0.1445
R3067 VDD.n294 VDD.n293 0.1445
R3068 VDD.n293 VDD.n201 0.1445
R3069 VDD.n289 VDD.n201 0.1445
R3070 VDD.n289 VDD.n288 0.1445
R3071 VDD.n288 VDD.n287 0.1445
R3072 VDD.n287 VDD.n207 0.1445
R3073 VDD.n283 VDD.n207 0.1445
R3074 VDD.n283 VDD.n282 0.1445
R3075 VDD.n282 VDD.n281 0.1445
R3076 VDD.n86 VDD.n78 0.1445
R3077 VDD.n100 VDD.n78 0.1445
R3078 VDD.n101 VDD.n100 0.1445
R3079 VDD.n102 VDD.n101 0.1445
R3080 VDD.n102 VDD.n72 0.1445
R3081 VDD.n111 VDD.n72 0.1445
R3082 VDD.n112 VDD.n111 0.1445
R3083 VDD.n113 VDD.n112 0.1445
R3084 VDD.n113 VDD.n70 0.1445
R3085 VDD.n117 VDD.n70 0.1445
R3086 VDD.n118 VDD.n117 0.1445
R3087 VDD.n119 VDD.n118 0.1445
R3088 VDD.n119 VDD.n23 0.1445
R3089 VDD.n185 VDD.n23 0.1445
R3090 VDD.n186 VDD.n185 0.1445
R3091 VDD.n546 VDD.n186 0.1445
R3092 VDD.n306 VDD.n305 0.1337
R3093 VDD.n542 VDD.n541 0.0905
R3094 VDD.n542 VDD.n310 0.0545
R3095 VDD.n173 VDD.n172 0.0272885
R3096 VDD.n144 VDD.n143 0.0272885
R3097 VDD.n175 VDD.n173 0.0249386
R3098 VDD.n143 VDD.n142 0.0249386
R3099 VDD.n32 VDD.n31 0.0215313
R3100 VDD.n140 VDD.n44 0.0215313
R3101 VDD.n152 VDD.n151 0.0203347
R3102 VDD.n152 VDD.n40 0.0203347
R3103 VDD.n156 VDD.n39 0.0203347
R3104 VDD.n161 VDD.n39 0.0203347
R3105 VDD.n165 VDD.n37 0.0203347
R3106 VDD.n166 VDD.n165 0.0203347
R3107 VDD.n177 VDD.n31 0.019299
R3108 VDD.n172 VDD.n33 0.019299
R3109 VDD.n140 VDD.n139 0.019299
R3110 VDD.n145 VDD.n144 0.019299
R3111 VDD.n178 VDD.n177 0.018594
R3112 VDD.n139 VDD.n138 0.018594
R3113 VDD.n92 VDD.n46 0.0167896
R3114 VDD.n137 VDD.n49 0.0167896
R3115 VDD.n133 VDD.n132 0.0167896
R3116 VDD.n132 VDD.n131 0.0167896
R3117 VDD VDD.n0 0.0167896
R3118 VDD VDD.n2 0.0167896
R3119 VDD.n560 VDD.n6 0.0167896
R3120 VDD.n556 VDD.n6 0.0167896
R3121 VDD.n179 VDD.n14 0.0167896
R3122 VDD.n553 VDD.n15 0.0167896
R3123 VDD.n35 VDD.n33 0.0156567
R3124 VDD.n145 VDD.n42 0.0156567
R3125 VDD.n92 VDD.n88 0.0141425
R3126 VDD.n553 VDD.n16 0.0141425
R3127 VDD.n133 VDD.n55 0.0135317
R3128 VDD.n556 VDD.n555 0.0135317
R3129 VDD.n157 VDD.n156 0.0124008
R3130 VDD.n161 VDD.n160 0.0124008
R3131 VDD.n306 VDD.n188 0.0113
R3132 VDD.n61 VDD.n0 0.0102738
R3133 VDD.n5 VDD.n2 0.0102738
R3134 VDD.n170 VDD.n35 0.010017
R3135 VDD.n148 VDD.n42 0.010017
R3136 VDD.n138 VDD.n46 0.00956109
R3137 VDD.n178 VDD.n15 0.00956109
R3138 VDD.n157 VDD.n40 0.00843388
R3139 VDD.n160 VDD.n37 0.00843388
R3140 VDD.n138 VDD.n137 0.00772851
R3141 VDD.n179 VDD.n178 0.00772851
R3142 VDD.n131 VDD.n61 0.00701584
R3143 VDD.n560 VDD.n5 0.00701584
R3144 VDD.n175 VDD.n32 0.0041423
R3145 VDD.n142 VDD.n44 0.0041423
R3146 VDD.n55 VDD.n49 0.00375792
R3147 VDD.n555 VDD.n14 0.00375792
R3148 VDD.n151 VDD.n42 0.00149173
R3149 VDD.n166 VDD.n35 0.00149173
R3150 VSS.n1151 VSS.n1150 29361.9
R3151 VSS.n614 VSS.n609 269.014
R3152 VSS.n1121 VSS.n460 269.014
R3153 VSS.n614 VSS.n611 269.014
R3154 VSS.n326 VSS.n29 251.32
R3155 VSS.n326 VSS.n31 251.32
R3156 VSS.n281 VSS.n276 251.32
R3157 VSS.n1135 VSS.n446 163.237
R3158 VSS.n1135 VSS.n447 163.237
R3159 VSS.n973 VSS.n586 163.237
R3160 VSS.n588 VSS.n586 163.237
R3161 VSS.n1168 VSS.n5 145.639
R3162 VSS.n9 VSS.n5 145.639
R3163 VSS.n376 VSS.n111 145.639
R3164 VSS.n113 VSS.n111 145.639
R3165 VSS.n613 VSS.n610 130.847
R3166 VSS.n613 VSS.n32 103.909
R3167 VSS.n1121 VSS.n1120 86.9464
R3168 VSS.n620 VSS.n610 76.9691
R3169 VSS.n620 VSS.n604 76.9691
R3170 VSS.n628 VSS.n604 76.9691
R3171 VSS.n628 VSS.n596 76.9691
R3172 VSS.n964 VSS.n596 76.9691
R3173 VSS.n972 VSS.n587 76.9691
R3174 VSS.n972 VSS.n590 76.9691
R3175 VSS.n988 VSS.n572 76.9691
R3176 VSS.n988 VSS.n575 76.9691
R3177 VSS.n996 VSS.n557 76.9691
R3178 VSS.n1004 VSS.n557 76.9691
R3179 VSS.n1004 VSS.t22 76.9691
R3180 VSS.n1012 VSS.t22 76.9691
R3181 VSS.n1020 VSS.n542 76.9691
R3182 VSS.n1028 VSS.n533 76.9691
R3183 VSS.n1028 VSS.n536 76.9691
R3184 VSS.n1036 VSS.n518 76.9691
R3185 VSS.n1044 VSS.n518 76.9691
R3186 VSS.n1052 VSS.n509 76.9691
R3187 VSS.n1052 VSS.n512 76.9691
R3188 VSS.n1060 VSS.n503 76.9691
R3189 VSS.n1068 VSS.t7 76.9691
R3190 VSS.n1079 VSS.t7 76.9691
R3191 VSS.n1079 VSS.n479 76.9691
R3192 VSS.n1087 VSS.n479 76.9691
R3193 VSS.n1149 VSS.n36 76.9691
R3194 VSS.n1101 VSS.n1100 76.9691
R3195 VSS.n1101 VSS.n448 76.9691
R3196 VSS.n1133 VSS.n450 76.9691
R3197 VSS.n1110 VSS.n450 76.9691
R3198 VSS.n1110 VSS.n462 76.9691
R3199 VSS.n1118 VSS.n462 76.9691
R3200 VSS.n1119 VSS.n1118 76.9691
R3201 VSS.n1152 VSS.n1151 74.0746
R3202 VSS.n963 VSS.n587 61.5754
R3203 VSS.n575 VSS.t25 61.5754
R3204 VSS.t19 VSS.n533 61.5754
R3205 VSS.n512 VSS.t10 61.5754
R3206 VSS.t4 VSS.n33 61.5754
R3207 VSS.n1134 VSS.n448 61.5754
R3208 VSS.n281 VSS.n280 59.4477
R3209 VSS.n1150 VSS.n1149 55.8027
R3210 VSS.n980 VSS.t34 52.9164
R3211 VSS.n907 VSS.t31 52.9164
R3212 VSS.n287 VSS.n277 52.9106
R3213 VSS.n287 VSS.n271 52.9106
R3214 VSS.n295 VSS.n271 52.9106
R3215 VSS.n295 VSS.n264 52.9106
R3216 VSS.n367 VSS.n264 52.9106
R3217 VSS.n375 VSS.n112 52.9106
R3218 VSS.n375 VSS.n258 52.9106
R3219 VSS.n383 VSS.n96 52.9106
R3220 VSS.n391 VSS.n96 52.9106
R3221 VSS.n399 VSS.n88 52.9106
R3222 VSS.n399 VSS.n80 52.9106
R3223 VSS.n407 VSS.n80 52.9106
R3224 VSS.n407 VSS.n71 52.9106
R3225 VSS.n415 VSS.n71 52.9106
R3226 VSS.n415 VSS.n74 52.9106
R3227 VSS.n423 VSS.n52 52.9106
R3228 VSS.n436 VSS.n52 52.9106
R3229 VSS.n1167 VSS.n6 52.9106
R3230 VSS.n1167 VSS.n8 52.9106
R3231 VSS.n1161 VSS.n1160 52.9106
R3232 VSS.n1160 VSS.n1159 52.9106
R3233 VSS.n1159 VSS.n22 52.9106
R3234 VSS.n1153 VSS.n22 52.9106
R3235 VSS.n1153 VSS.n1152 52.9106
R3236 VSS.n980 VSS.t28 46.1817
R3237 VSS.n1036 VSS.t16 46.1817
R3238 VSS.n1044 VSS.t13 46.1817
R3239 VSS.n907 VSS.t1 46.1817
R3240 VSS.t56 VSS.n542 43.2953
R3241 VSS.n503 VSS.t58 43.2953
R3242 VSS.n391 VSS.n99 42.3285
R3243 VSS.n423 VSS.n63 42.3285
R3244 VSS.n1012 VSS.t56 33.6743
R3245 VSS.n1068 VSS.t58 33.6743
R3246 VSS.n366 VSS.n112 32.0772
R3247 VSS.n18 VSS.n8 32.0772
R3248 VSS.t28 VSS.n572 30.7879
R3249 VSS.n536 VSS.t16 30.7879
R3250 VSS.t13 VSS.n509 30.7879
R3251 VSS.t1 VSS.n36 30.7879
R3252 VSS.n258 VSS.n257 27.1169
R3253 VSS.n55 VSS.n6 27.1169
R3254 VSS.n590 VSS.t34 24.0532
R3255 VSS.n1100 VSS.t31 24.0532
R3256 VSS.n1150 VSS.n33 21.1669
R3257 VSS.n383 VSS.n105 21.1645
R3258 VSS.n436 VSS.n56 21.1645
R3259 VSS.n367 VSS.n366 20.8338
R3260 VSS.n1161 VSS.n18 20.8338
R3261 Isum VSS.n1171 19.8023
R3262 VSS.n443 VSS.t59 19.215
R3263 VSS.n442 VSS.t57 19.215
R3264 VSS.n741 VSS.n696 15.8697
R3265 VSS.n776 VSS.n666 15.8697
R3266 VSS.n133 VSS.n116 15.8697
R3267 VSS.n149 VSS.n0 15.8697
R3268 VSS.n973 VSS.n583 15.5561
R3269 VSS.n979 VSS.n583 15.5561
R3270 VSS.n979 VSS.n571 15.5561
R3271 VSS.n989 VSS.n571 15.5561
R3272 VSS.n989 VSS.n567 15.5561
R3273 VSS.n995 VSS.n567 15.5561
R3274 VSS.n995 VSS.n556 15.5561
R3275 VSS.n1005 VSS.n556 15.5561
R3276 VSS.n1005 VSS.n552 15.5561
R3277 VSS.n1011 VSS.n552 15.5561
R3278 VSS.n1011 VSS.n541 15.5561
R3279 VSS.n1021 VSS.n541 15.5561
R3280 VSS.n1021 VSS.n537 15.5561
R3281 VSS.n1027 VSS.n537 15.5561
R3282 VSS.n1027 VSS.n525 15.5561
R3283 VSS.n1037 VSS.n525 15.5561
R3284 VSS.n1037 VSS.n521 15.5561
R3285 VSS.n1043 VSS.n521 15.5561
R3286 VSS.n1043 VSS.n508 15.5561
R3287 VSS.n1053 VSS.n508 15.5561
R3288 VSS.n1053 VSS.n504 15.5561
R3289 VSS.n1059 VSS.n504 15.5561
R3290 VSS.n1059 VSS.n493 15.5561
R3291 VSS.n1069 VSS.n493 15.5561
R3292 VSS.n1069 VSS.n489 15.5561
R3293 VSS.n1078 VSS.n489 15.5561
R3294 VSS.n1078 VSS.n478 15.5561
R3295 VSS.n1088 VSS.n478 15.5561
R3296 VSS.n1089 VSS.n1088 15.5561
R3297 VSS.n1089 VSS.n37 15.5561
R3298 VSS.n1092 VSS.n37 15.5561
R3299 VSS.n1092 VSS.n473 15.5561
R3300 VSS.n1099 VSS.n473 15.5561
R3301 VSS.n1099 VSS.n447 15.5561
R3302 VSS.n823 VSS.n588 15.5561
R3303 VSS.n823 VSS.n581 15.5561
R3304 VSS.n820 VSS.n581 15.5561
R3305 VSS.n820 VSS.n573 15.5561
R3306 VSS.n817 VSS.n573 15.5561
R3307 VSS.n817 VSS.n565 15.5561
R3308 VSS.n814 VSS.n565 15.5561
R3309 VSS.n814 VSS.n558 15.5561
R3310 VSS.n811 VSS.n558 15.5561
R3311 VSS.n811 VSS.n550 15.5561
R3312 VSS.n808 VSS.n550 15.5561
R3313 VSS.n808 VSS.n543 15.5561
R3314 VSS.n805 VSS.n543 15.5561
R3315 VSS.n805 VSS.n534 15.5561
R3316 VSS.n802 VSS.n534 15.5561
R3317 VSS.n802 VSS.n526 15.5561
R3318 VSS.n799 VSS.n526 15.5561
R3319 VSS.n799 VSS.n519 15.5561
R3320 VSS.n796 VSS.n519 15.5561
R3321 VSS.n796 VSS.n510 15.5561
R3322 VSS.n793 VSS.n510 15.5561
R3323 VSS.n793 VSS.n501 15.5561
R3324 VSS.n790 VSS.n501 15.5561
R3325 VSS.n790 VSS.n494 15.5561
R3326 VSS.n787 VSS.n494 15.5561
R3327 VSS.n787 VSS.n487 15.5561
R3328 VSS.n784 VSS.n487 15.5561
R3329 VSS.n784 VSS.n480 15.5561
R3330 VSS.n781 VSS.n480 15.5561
R3331 VSS.n781 VSS.n34 15.5561
R3332 VSS.n664 VSS.n34 15.5561
R3333 VSS.n906 VSS.n664 15.5561
R3334 VSS.n906 VSS.n472 15.5561
R3335 VSS.n472 VSS.n446 15.5561
R3336 VSS.n286 VSS.n278 15.5561
R3337 VSS.n286 VSS.n270 15.5561
R3338 VSS.n296 VSS.n270 15.5561
R3339 VSS.n296 VSS.n265 15.5561
R3340 VSS.n365 VSS.n265 15.5561
R3341 VSS.n365 VSS.n266 15.5561
R3342 VSS.n266 VSS.n114 15.5561
R3343 VSS.n360 VSS.n114 15.5561
R3344 VSS.n360 VSS.n107 15.5561
R3345 VSS.n357 VSS.n107 15.5561
R3346 VSS.n357 VSS.n98 15.5561
R3347 VSS.n354 VSS.n98 15.5561
R3348 VSS.n354 VSS.n90 15.5561
R3349 VSS.n351 VSS.n90 15.5561
R3350 VSS.n351 VSS.n82 15.5561
R3351 VSS.n348 VSS.n82 15.5561
R3352 VSS.n348 VSS.n73 15.5561
R3353 VSS.n345 VSS.n73 15.5561
R3354 VSS.n345 VSS.n65 15.5561
R3355 VSS.n342 VSS.n65 15.5561
R3356 VSS.n342 VSS.n54 15.5561
R3357 VSS.n339 VSS.n54 15.5561
R3358 VSS.n339 VSS.n7 15.5561
R3359 VSS.n336 VSS.n7 15.5561
R3360 VSS.n336 VSS.n19 15.5561
R3361 VSS.n20 VSS.n19 15.5561
R3362 VSS.n21 VSS.n20 15.5561
R3363 VSS.n331 VSS.n21 15.5561
R3364 VSS.n331 VSS.n30 15.5561
R3365 VSS.n31 VSS.n30 15.5561
R3366 VSS.n288 VSS.n276 15.5561
R3367 VSS.n288 VSS.n272 15.5561
R3368 VSS.n294 VSS.n272 15.5561
R3369 VSS.n294 VSS.n263 15.5561
R3370 VSS.n368 VSS.n263 15.5561
R3371 VSS.n368 VSS.n259 15.5561
R3372 VSS.n374 VSS.n259 15.5561
R3373 VSS.n374 VSS.n104 15.5561
R3374 VSS.n384 VSS.n104 15.5561
R3375 VSS.n384 VSS.n100 15.5561
R3376 VSS.n390 VSS.n100 15.5561
R3377 VSS.n390 VSS.n87 15.5561
R3378 VSS.n400 VSS.n87 15.5561
R3379 VSS.n400 VSS.n83 15.5561
R3380 VSS.n406 VSS.n83 15.5561
R3381 VSS.n406 VSS.n70 15.5561
R3382 VSS.n416 VSS.n70 15.5561
R3383 VSS.n416 VSS.n66 15.5561
R3384 VSS.n422 VSS.n66 15.5561
R3385 VSS.n422 VSS.n51 15.5561
R3386 VSS.n437 VSS.n51 15.5561
R3387 VSS.n437 VSS.n10 15.5561
R3388 VSS.n1166 VSS.n10 15.5561
R3389 VSS.n1166 VSS.n11 15.5561
R3390 VSS.n1162 VSS.n11 15.5561
R3391 VSS.n1162 VSS.n17 15.5561
R3392 VSS.n1158 VSS.n17 15.5561
R3393 VSS.n1158 VSS.n23 15.5561
R3394 VSS.n1154 VSS.n23 15.5561
R3395 VSS.n1154 VSS.n29 15.5561
R3396 VSS.n376 VSS.n108 15.5561
R3397 VSS.n382 VSS.n108 15.5561
R3398 VSS.n382 VSS.n95 15.5561
R3399 VSS.n392 VSS.n95 15.5561
R3400 VSS.n392 VSS.n91 15.5561
R3401 VSS.n398 VSS.n91 15.5561
R3402 VSS.n398 VSS.n79 15.5561
R3403 VSS.n408 VSS.n79 15.5561
R3404 VSS.n408 VSS.n75 15.5561
R3405 VSS.n414 VSS.n75 15.5561
R3406 VSS.n414 VSS.n62 15.5561
R3407 VSS.n424 VSS.n62 15.5561
R3408 VSS.n424 VSS.n57 15.5561
R3409 VSS.n435 VSS.n57 15.5561
R3410 VSS.n435 VSS.n58 15.5561
R3411 VSS.n58 VSS.n9 15.5561
R3412 VSS.n256 VSS.n113 15.5561
R3413 VSS.n256 VSS.n106 15.5561
R3414 VSS.n252 VSS.n106 15.5561
R3415 VSS.n252 VSS.n97 15.5561
R3416 VSS.n249 VSS.n97 15.5561
R3417 VSS.n249 VSS.n89 15.5561
R3418 VSS.n246 VSS.n89 15.5561
R3419 VSS.n246 VSS.n81 15.5561
R3420 VSS.n243 VSS.n81 15.5561
R3421 VSS.n243 VSS.n72 15.5561
R3422 VSS.n240 VSS.n72 15.5561
R3423 VSS.n240 VSS.n64 15.5561
R3424 VSS.n237 VSS.n64 15.5561
R3425 VSS.n237 VSS.n53 15.5561
R3426 VSS.n53 VSS.n4 15.5561
R3427 VSS.n1168 VSS.n4 15.5561
R3428 VSS.n621 VSS.n609 15.5561
R3429 VSS.n621 VSS.n605 15.5561
R3430 VSS.n627 VSS.n605 15.5561
R3431 VSS.n627 VSS.n595 15.5561
R3432 VSS.n965 VSS.n595 15.5561
R3433 VSS.n965 VSS.n591 15.5561
R3434 VSS.n971 VSS.n591 15.5561
R3435 VSS.n971 VSS.n580 15.5561
R3436 VSS.n981 VSS.n580 15.5561
R3437 VSS.n981 VSS.n576 15.5561
R3438 VSS.n987 VSS.n576 15.5561
R3439 VSS.n987 VSS.n564 15.5561
R3440 VSS.n997 VSS.n564 15.5561
R3441 VSS.n997 VSS.n560 15.5561
R3442 VSS.n1003 VSS.n560 15.5561
R3443 VSS.n1003 VSS.n549 15.5561
R3444 VSS.n1013 VSS.n549 15.5561
R3445 VSS.n1013 VSS.n545 15.5561
R3446 VSS.n1019 VSS.n545 15.5561
R3447 VSS.n1019 VSS.n532 15.5561
R3448 VSS.n1029 VSS.n532 15.5561
R3449 VSS.n1029 VSS.n528 15.5561
R3450 VSS.n1035 VSS.n528 15.5561
R3451 VSS.n1035 VSS.n517 15.5561
R3452 VSS.n1045 VSS.n517 15.5561
R3453 VSS.n1045 VSS.n513 15.5561
R3454 VSS.n1051 VSS.n513 15.5561
R3455 VSS.n1051 VSS.n500 15.5561
R3456 VSS.n1061 VSS.n500 15.5561
R3457 VSS.n1061 VSS.n496 15.5561
R3458 VSS.n1067 VSS.n496 15.5561
R3459 VSS.n1067 VSS.n486 15.5561
R3460 VSS.n1080 VSS.n486 15.5561
R3461 VSS.n1080 VSS.n482 15.5561
R3462 VSS.n1086 VSS.n482 15.5561
R3463 VSS.n1086 VSS.n38 15.5561
R3464 VSS.n1148 VSS.n38 15.5561
R3465 VSS.n1148 VSS.n39 15.5561
R3466 VSS.n44 VSS.n39 15.5561
R3467 VSS.n45 VSS.n44 15.5561
R3468 VSS.n46 VSS.n45 15.5561
R3469 VSS.n451 VSS.n46 15.5561
R3470 VSS.n1132 VSS.n451 15.5561
R3471 VSS.n1132 VSS.n452 15.5561
R3472 VSS.n455 VSS.n452 15.5561
R3473 VSS.n456 VSS.n455 15.5561
R3474 VSS.n457 VSS.n456 15.5561
R3475 VSS.n460 VSS.n457 15.5561
R3476 VSS.n619 VSS.n611 15.5561
R3477 VSS.n619 VSS.n603 15.5561
R3478 VSS.n629 VSS.n603 15.5561
R3479 VSS.n629 VSS.n597 15.5561
R3480 VSS.n962 VSS.n597 15.5561
R3481 VSS.n962 VSS.n598 15.5561
R3482 VSS.n598 VSS.n589 15.5561
R3483 VSS.n634 VSS.n589 15.5561
R3484 VSS.n634 VSS.n582 15.5561
R3485 VSS.n635 VSS.n582 15.5561
R3486 VSS.n635 VSS.n574 15.5561
R3487 VSS.n638 VSS.n574 15.5561
R3488 VSS.n638 VSS.n566 15.5561
R3489 VSS.n639 VSS.n566 15.5561
R3490 VSS.n639 VSS.n559 15.5561
R3491 VSS.n642 VSS.n559 15.5561
R3492 VSS.n642 VSS.n551 15.5561
R3493 VSS.n643 VSS.n551 15.5561
R3494 VSS.n643 VSS.n544 15.5561
R3495 VSS.n646 VSS.n544 15.5561
R3496 VSS.n646 VSS.n535 15.5561
R3497 VSS.n647 VSS.n535 15.5561
R3498 VSS.n647 VSS.n527 15.5561
R3499 VSS.n649 VSS.n527 15.5561
R3500 VSS.n649 VSS.n520 15.5561
R3501 VSS.n650 VSS.n520 15.5561
R3502 VSS.n650 VSS.n511 15.5561
R3503 VSS.n653 VSS.n511 15.5561
R3504 VSS.n653 VSS.n502 15.5561
R3505 VSS.n654 VSS.n502 15.5561
R3506 VSS.n654 VSS.n495 15.5561
R3507 VSS.n657 VSS.n495 15.5561
R3508 VSS.n657 VSS.n488 15.5561
R3509 VSS.n658 VSS.n488 15.5561
R3510 VSS.n658 VSS.n481 15.5561
R3511 VSS.n661 VSS.n481 15.5561
R3512 VSS.n661 VSS.n35 15.5561
R3513 VSS.n663 VSS.n35 15.5561
R3514 VSS.n908 VSS.n663 15.5561
R3515 VSS.n908 VSS.n470 15.5561
R3516 VSS.n1102 VSS.n470 15.5561
R3517 VSS.n1102 VSS.n471 15.5561
R3518 VSS.n471 VSS.n449 15.5561
R3519 VSS.n1109 VSS.n449 15.5561
R3520 VSS.n1111 VSS.n1109 15.5561
R3521 VSS.n1111 VSS.n463 15.5561
R3522 VSS.n1117 VSS.n463 15.5561
R3523 VSS.n1117 VSS.n461 15.5561
R3524 VSS.n964 VSS.n963 15.3942
R3525 VSS.n996 VSS.t25 15.3942
R3526 VSS.n1020 VSS.t19 15.3942
R3527 VSS.n1060 VSS.t10 15.3942
R3528 VSS.n1087 VSS.t4 15.3942
R3529 VSS.n1134 VSS.n1133 15.3942
R3530 VSS.n442 VSS.n441 14.6021
R3531 VSS.n892 VSS.n891 12.5005
R3532 VSS.n672 VSS.n671 12.5005
R3533 VSS.n884 VSS.n674 12.5005
R3534 VSS.n886 VSS.n885 12.5005
R3535 VSS.n882 VSS.n673 12.5005
R3536 VSS.n881 VSS.n880 12.5005
R3537 VSS.n879 VSS.n675 12.5005
R3538 VSS.n870 VSS.n676 12.5005
R3539 VSS.n871 VSS.n678 12.5005
R3540 VSS.n874 VSS.n873 12.5005
R3541 VSS.n869 VSS.n677 12.5005
R3542 VSS.n868 VSS.n867 12.5005
R3543 VSS.n866 VSS.n865 12.5005
R3544 VSS.n864 VSS.n680 12.5005
R3545 VSS.n863 VSS.n862 12.5005
R3546 VSS.n861 VSS.n860 12.5005
R3547 VSS.n859 VSS.n682 12.5005
R3548 VSS.n858 VSS.n857 12.5005
R3549 VSS.n849 VSS.n684 12.5005
R3550 VSS.n851 VSS.n850 12.5005
R3551 VSS.n848 VSS.n685 12.5005
R3552 VSS.n847 VSS.n846 12.5005
R3553 VSS.n845 VSS.n686 12.5005
R3554 VSS.n836 VSS.n687 12.5005
R3555 VSS.n837 VSS.n689 12.5005
R3556 VSS.n840 VSS.n839 12.5005
R3557 VSS.n835 VSS.n688 12.5005
R3558 VSS.n778 VSS.n777 12.5005
R3559 VSS.n779 VSS.n775 12.5005
R3560 VSS.n774 VSS.n723 12.5005
R3561 VSS.n772 VSS.n722 12.5005
R3562 VSS.n771 VSS.n721 12.5005
R3563 VSS.n770 VSS.n720 12.5005
R3564 VSS.n769 VSS.n719 12.5005
R3565 VSS.n768 VSS.n718 12.5005
R3566 VSS.n767 VSS.n717 12.5005
R3567 VSS.n766 VSS.n716 12.5005
R3568 VSS.n764 VSS.n715 12.5005
R3569 VSS.n763 VSS.n714 12.5005
R3570 VSS.n762 VSS.n713 12.5005
R3571 VSS.n760 VSS.n712 12.5005
R3572 VSS.n759 VSS.n711 12.5005
R3573 VSS.n758 VSS.n710 12.5005
R3574 VSS.n756 VSS.n709 12.5005
R3575 VSS.n755 VSS.n708 12.5005
R3576 VSS.n754 VSS.n707 12.5005
R3577 VSS.n752 VSS.n706 12.5005
R3578 VSS.n751 VSS.n705 12.5005
R3579 VSS.n750 VSS.n704 12.5005
R3580 VSS.n749 VSS.n703 12.5005
R3581 VSS.n748 VSS.n702 12.5005
R3582 VSS.n747 VSS.n701 12.5005
R3583 VSS.n746 VSS.n700 12.5005
R3584 VSS.n744 VSS.n699 12.5005
R3585 VSS.n743 VSS.n698 12.5005
R3586 VSS.n742 VSS.n697 12.5005
R3587 VSS.n221 VSS.n220 12.5005
R3588 VSS.n219 VSS.n218 12.5005
R3589 VSS.n217 VSS.n160 12.5005
R3590 VSS.n216 VSS.n215 12.5005
R3591 VSS.n163 VSS.n162 12.5005
R3592 VSS.n208 VSS.n207 12.5005
R3593 VSS.n206 VSS.n165 12.5005
R3594 VSS.n205 VSS.n204 12.5005
R3595 VSS.n203 VSS.n202 12.5005
R3596 VSS.n235 VSS.n150 12.5005
R3597 VSS.n147 VSS.n128 12.5005
R3598 VSS.n146 VSS.n127 12.5005
R3599 VSS.n144 VSS.n126 12.5005
R3600 VSS.n143 VSS.n125 12.5005
R3601 VSS.n142 VSS.n124 12.5005
R3602 VSS.n141 VSS.n123 12.5005
R3603 VSS.n140 VSS.n122 12.5005
R3604 VSS.n139 VSS.n121 12.5005
R3605 VSS.n138 VSS.n120 12.5005
R3606 VSS.n136 VSS.n119 12.5005
R3607 VSS.n135 VSS.n118 12.5005
R3608 VSS.n134 VSS.n117 12.5005
R3609 VSS.n223 VSS.n221 12.4735
R3610 VSS.n202 VSS.n201 12.4729
R3611 VSS.n183 VSS.n182 12.1637
R3612 VSS.n902 VSS.t2 12.1268
R3613 VSS.n825 VSS.t29 12.1268
R3614 VSS.n1170 VSS.n1 12.1268
R3615 VSS.n897 VSS.t30 11.3053
R3616 VSS.n830 VSS.t33 11.3053
R3617 VSS.n99 VSS.n88 10.5825
R3618 VSS.n74 VSS.n63 10.5825
R3619 VSS.n748 VSS.n747 9.86111
R3620 VSS.n751 VSS.n750 9.86111
R3621 VSS.n768 VSS.n767 9.86111
R3622 VSS.n771 VSS.n770 9.86111
R3623 VSS.n836 VSS.n686 9.86111
R3624 VSS.n850 VSS.n848 9.86111
R3625 VSS.n870 VSS.n675 9.86111
R3626 VSS.n885 VSS.n882 9.86111
R3627 VSS.n140 VSS.n139 9.86111
R3628 VSS.n143 VSS.n142 9.86111
R3629 VSS.n207 VSS.n206 9.86111
R3630 VSS.n217 VSS.n216 9.86111
R3631 VSS.n832 VSS.t55 9.8285
R3632 VSS.n895 VSS.t37 9.8285
R3633 VSS.n191 VSS.n190 9.8285
R3634 VSS.n190 VSS.n186 9.8285
R3635 VSS.n197 VSS.n170 9.8285
R3636 VSS.n230 VSS.n152 9.8285
R3637 VSS.n232 VSS.n152 9.8285
R3638 VSS.n225 VSS.n224 9.8285
R3639 VSS.n744 VSS.n743 8.95142
R3640 VSS.n755 VSS.n754 8.95142
R3641 VSS.n764 VSS.n763 8.95142
R3642 VSS.n775 VSS.n774 8.95142
R3643 VSS.n839 VSS.n835 8.95142
R3644 VSS.n859 VSS.n858 8.95142
R3645 VSS.n873 VSS.n869 8.95142
R3646 VSS.n892 VSS.n671 8.95142
R3647 VSS.n136 VSS.n135 8.95142
R3648 VSS.n147 VSS.n146 8.95142
R3649 VSS.n740 VSS.n739 8.63568
R3650 VSS.n736 VSS.n735 8.63568
R3651 VSS.n732 VSS.n711 8.63568
R3652 VSS.n729 VSS.n728 8.63568
R3653 VSS.n725 VSS.n724 8.63568
R3654 VSS.n890 VSS.n889 8.63568
R3655 VSS.n878 VSS.n877 8.63568
R3656 VSS.n854 VSS.n680 8.63568
R3657 VSS.n853 VSS.n852 8.63568
R3658 VSS.n842 VSS.n841 8.63568
R3659 VSS.n172 VSS.n171 8.63568
R3660 VSS.n178 VSS.n177 8.63568
R3661 VSS.n210 VSS.n209 8.63568
R3662 VSS.n738 VSS.n737 8.59884
R3663 VSS.n734 VSS.n733 8.59884
R3664 VSS.n731 VSS.n730 8.59884
R3665 VSS.n727 VSS.n726 8.59884
R3666 VSS.n888 VSS.n887 8.59884
R3667 VSS.n876 VSS.n875 8.59884
R3668 VSS.n856 VSS.n855 8.59884
R3669 VSS.n844 VSS.n843 8.59884
R3670 VSS.n175 VSS.n174 8.59884
R3671 VSS.n181 VSS.n180 8.59884
R3672 VSS.n214 VSS.n213 8.59884
R3673 VSS.n229 VSS.n154 8.56785
R3674 VSS.n194 VSS.n193 8.56785
R3675 VSS.n759 VSS.n758 7.7385
R3676 VSS.n760 VSS.n759 7.7385
R3677 VSS.n864 VSS.n863 7.7385
R3678 VSS.n865 VSS.n864 7.7385
R3679 VSS.n1151 VSS.n32 7.69736
R3680 VSS.n835 VSS.n834 7.44316
R3681 VSS.n893 VSS.n892 7.44316
R3682 VSS.n615 VSS.n607 7.21377
R3683 VSS.n616 VSS.n615 7.21377
R3684 VSS.n1123 VSS.n1122 7.12426
R3685 VSS.n1122 VSS.n459 7.12426
R3686 VSS.n327 VSS.n325 7.03823
R3687 VSS.n328 VSS.n327 7.03823
R3688 VSS.n283 VSS.n282 7.03823
R3689 VSS.n282 VSS.n274 7.03823
R3690 VSS.n743 VSS.n742 6.52558
R3691 VSS.n756 VSS.n755 6.52558
R3692 VSS.n763 VSS.n762 6.52558
R3693 VSS.n777 VSS.n775 6.52558
R3694 VSS.n860 VSS.n859 6.52558
R3695 VSS.n869 VSS.n868 6.52558
R3696 VSS.n135 VSS.n134 6.52558
R3697 VSS.n150 VSS.n147 6.52558
R3698 VSS.n894 VSS.n893 6.51288
R3699 VSS.n834 VSS.n833 6.51288
R3700 VSS.n199 VSS.n198 6.3005
R3701 VSS.n227 VSS.n156 6.3005
R3702 VSS.n1136 VSS.n445 6.14817
R3703 VSS.n975 VSS.n585 6.14817
R3704 VSS.n693 VSS.n585 6.14817
R3705 VSS.n1137 VSS.n1136 6.13016
R3706 VSS.n431 VSS.n430 5.97353
R3707 VSS.n378 VSS.n110 5.97353
R3708 VSS.n430 VSS.n2 5.85293
R3709 VSS.n184 VSS.n110 5.85293
R3710 VSS.n1138 VSS.n443 5.6183
R3711 VSS.n747 VSS.n746 5.61588
R3712 VSS.n749 VSS.n748 5.61588
R3713 VSS.n750 VSS.n749 5.61588
R3714 VSS.n752 VSS.n751 5.61588
R3715 VSS.n767 VSS.n766 5.61588
R3716 VSS.n769 VSS.n768 5.61588
R3717 VSS.n770 VSS.n769 5.61588
R3718 VSS.n772 VSS.n771 5.61588
R3719 VSS.n837 VSS.n836 5.61588
R3720 VSS.n847 VSS.n686 5.61588
R3721 VSS.n848 VSS.n847 5.61588
R3722 VSS.n850 VSS.n849 5.61588
R3723 VSS.n871 VSS.n870 5.61588
R3724 VSS.n881 VSS.n675 5.61588
R3725 VSS.n882 VSS.n881 5.61588
R3726 VSS.n885 VSS.n884 5.61588
R3727 VSS.n139 VSS.n138 5.61588
R3728 VSS.n141 VSS.n140 5.61588
R3729 VSS.n142 VSS.n141 5.61588
R3730 VSS.n144 VSS.n143 5.61588
R3731 VSS.n206 VSS.n205 5.61588
R3732 VSS.n207 VSS.n162 5.61588
R3733 VSS.n216 VSS.n162 5.61588
R3734 VSS.n218 VSS.n217 5.61588
R3735 VSS.n1138 VSS.n1137 5.4941
R3736 VSS.n1169 VSS.n1168 5.2005
R3737 VSS.n1168 VSS.n1167 5.2005
R3738 VSS.n4 VSS.n3 5.2005
R3739 VSS.n6 VSS.n4 5.2005
R3740 VSS.n236 VSS.n53 5.2005
R3741 VSS.n436 VSS.n53 5.2005
R3742 VSS.n238 VSS.n237 5.2005
R3743 VSS.n237 VSS.n52 5.2005
R3744 VSS.n239 VSS.n64 5.2005
R3745 VSS.n423 VSS.n64 5.2005
R3746 VSS.n241 VSS.n240 5.2005
R3747 VSS.n240 VSS.n74 5.2005
R3748 VSS.n242 VSS.n72 5.2005
R3749 VSS.n415 VSS.n72 5.2005
R3750 VSS.n244 VSS.n243 5.2005
R3751 VSS.n243 VSS.n71 5.2005
R3752 VSS.n245 VSS.n81 5.2005
R3753 VSS.n407 VSS.n81 5.2005
R3754 VSS.n247 VSS.n246 5.2005
R3755 VSS.n246 VSS.n80 5.2005
R3756 VSS.n248 VSS.n89 5.2005
R3757 VSS.n399 VSS.n89 5.2005
R3758 VSS.n250 VSS.n249 5.2005
R3759 VSS.n249 VSS.n88 5.2005
R3760 VSS.n251 VSS.n97 5.2005
R3761 VSS.n391 VSS.n97 5.2005
R3762 VSS.n253 VSS.n252 5.2005
R3763 VSS.n252 VSS.n96 5.2005
R3764 VSS.n254 VSS.n106 5.2005
R3765 VSS.n383 VSS.n106 5.2005
R3766 VSS.n256 VSS.n255 5.2005
R3767 VSS.n258 VSS.n256 5.2005
R3768 VSS.n115 VSS.n113 5.2005
R3769 VSS.n375 VSS.n113 5.2005
R3770 VSS.n432 VSS.n9 5.2005
R3771 VSS.n1167 VSS.n9 5.2005
R3772 VSS.n433 VSS.n58 5.2005
R3773 VSS.n58 VSS.n6 5.2005
R3774 VSS.n435 VSS.n434 5.2005
R3775 VSS.n436 VSS.n435 5.2005
R3776 VSS.n59 VSS.n57 5.2005
R3777 VSS.n57 VSS.n52 5.2005
R3778 VSS.n425 VSS.n424 5.2005
R3779 VSS.n424 VSS.n423 5.2005
R3780 VSS.n62 VSS.n61 5.2005
R3781 VSS.n74 VSS.n62 5.2005
R3782 VSS.n414 VSS.n413 5.2005
R3783 VSS.n415 VSS.n414 5.2005
R3784 VSS.n76 VSS.n75 5.2005
R3785 VSS.n75 VSS.n71 5.2005
R3786 VSS.n409 VSS.n408 5.2005
R3787 VSS.n408 VSS.n407 5.2005
R3788 VSS.n79 VSS.n78 5.2005
R3789 VSS.n80 VSS.n79 5.2005
R3790 VSS.n398 VSS.n397 5.2005
R3791 VSS.n399 VSS.n398 5.2005
R3792 VSS.n92 VSS.n91 5.2005
R3793 VSS.n91 VSS.n88 5.2005
R3794 VSS.n393 VSS.n392 5.2005
R3795 VSS.n392 VSS.n391 5.2005
R3796 VSS.n95 VSS.n94 5.2005
R3797 VSS.n96 VSS.n95 5.2005
R3798 VSS.n382 VSS.n381 5.2005
R3799 VSS.n383 VSS.n382 5.2005
R3800 VSS.n109 VSS.n108 5.2005
R3801 VSS.n258 VSS.n108 5.2005
R3802 VSS.n377 VSS.n376 5.2005
R3803 VSS.n376 VSS.n375 5.2005
R3804 VSS.n29 VSS.n28 5.2005
R3805 VSS.n1152 VSS.n29 5.2005
R3806 VSS.n1155 VSS.n1154 5.2005
R3807 VSS.n1154 VSS.n1153 5.2005
R3808 VSS.n1156 VSS.n23 5.2005
R3809 VSS.n23 VSS.n22 5.2005
R3810 VSS.n1158 VSS.n1157 5.2005
R3811 VSS.n1159 VSS.n1158 5.2005
R3812 VSS.n17 VSS.n16 5.2005
R3813 VSS.n1160 VSS.n17 5.2005
R3814 VSS.n1163 VSS.n1162 5.2005
R3815 VSS.n1162 VSS.n1161 5.2005
R3816 VSS.n1164 VSS.n11 5.2005
R3817 VSS.n11 VSS.n8 5.2005
R3818 VSS.n1166 VSS.n1165 5.2005
R3819 VSS.n1167 VSS.n1166 5.2005
R3820 VSS.n12 VSS.n10 5.2005
R3821 VSS.n10 VSS.n6 5.2005
R3822 VSS.n438 VSS.n437 5.2005
R3823 VSS.n437 VSS.n436 5.2005
R3824 VSS.n51 VSS.n50 5.2005
R3825 VSS.n52 VSS.n51 5.2005
R3826 VSS.n422 VSS.n421 5.2005
R3827 VSS.n423 VSS.n422 5.2005
R3828 VSS.n67 VSS.n66 5.2005
R3829 VSS.n74 VSS.n66 5.2005
R3830 VSS.n417 VSS.n416 5.2005
R3831 VSS.n416 VSS.n415 5.2005
R3832 VSS.n70 VSS.n69 5.2005
R3833 VSS.n71 VSS.n70 5.2005
R3834 VSS.n406 VSS.n405 5.2005
R3835 VSS.n407 VSS.n406 5.2005
R3836 VSS.n84 VSS.n83 5.2005
R3837 VSS.n83 VSS.n80 5.2005
R3838 VSS.n401 VSS.n400 5.2005
R3839 VSS.n400 VSS.n399 5.2005
R3840 VSS.n87 VSS.n86 5.2005
R3841 VSS.n88 VSS.n87 5.2005
R3842 VSS.n390 VSS.n389 5.2005
R3843 VSS.n391 VSS.n390 5.2005
R3844 VSS.n101 VSS.n100 5.2005
R3845 VSS.n100 VSS.n96 5.2005
R3846 VSS.n385 VSS.n384 5.2005
R3847 VSS.n384 VSS.n383 5.2005
R3848 VSS.n104 VSS.n103 5.2005
R3849 VSS.n258 VSS.n104 5.2005
R3850 VSS.n374 VSS.n373 5.2005
R3851 VSS.n375 VSS.n374 5.2005
R3852 VSS.n260 VSS.n259 5.2005
R3853 VSS.n259 VSS.n112 5.2005
R3854 VSS.n369 VSS.n368 5.2005
R3855 VSS.n368 VSS.n367 5.2005
R3856 VSS.n263 VSS.n262 5.2005
R3857 VSS.n264 VSS.n263 5.2005
R3858 VSS.n294 VSS.n293 5.2005
R3859 VSS.n295 VSS.n294 5.2005
R3860 VSS.n273 VSS.n272 5.2005
R3861 VSS.n272 VSS.n271 5.2005
R3862 VSS.n289 VSS.n288 5.2005
R3863 VSS.n288 VSS.n287 5.2005
R3864 VSS.n276 VSS.n275 5.2005
R3865 VSS.n277 VSS.n276 5.2005
R3866 VSS.n329 VSS.n31 5.2005
R3867 VSS.n1152 VSS.n31 5.2005
R3868 VSS.n330 VSS.n30 5.2005
R3869 VSS.n1153 VSS.n30 5.2005
R3870 VSS.n332 VSS.n331 5.2005
R3871 VSS.n331 VSS.n22 5.2005
R3872 VSS.n333 VSS.n21 5.2005
R3873 VSS.n1159 VSS.n21 5.2005
R3874 VSS.n334 VSS.n20 5.2005
R3875 VSS.n1160 VSS.n20 5.2005
R3876 VSS.n335 VSS.n19 5.2005
R3877 VSS.n1161 VSS.n19 5.2005
R3878 VSS.n337 VSS.n336 5.2005
R3879 VSS.n336 VSS.n8 5.2005
R3880 VSS.n338 VSS.n7 5.2005
R3881 VSS.n1167 VSS.n7 5.2005
R3882 VSS.n340 VSS.n339 5.2005
R3883 VSS.n339 VSS.n6 5.2005
R3884 VSS.n341 VSS.n54 5.2005
R3885 VSS.n436 VSS.n54 5.2005
R3886 VSS.n343 VSS.n342 5.2005
R3887 VSS.n342 VSS.n52 5.2005
R3888 VSS.n344 VSS.n65 5.2005
R3889 VSS.n423 VSS.n65 5.2005
R3890 VSS.n346 VSS.n345 5.2005
R3891 VSS.n345 VSS.n74 5.2005
R3892 VSS.n347 VSS.n73 5.2005
R3893 VSS.n415 VSS.n73 5.2005
R3894 VSS.n349 VSS.n348 5.2005
R3895 VSS.n348 VSS.n71 5.2005
R3896 VSS.n350 VSS.n82 5.2005
R3897 VSS.n407 VSS.n82 5.2005
R3898 VSS.n352 VSS.n351 5.2005
R3899 VSS.n351 VSS.n80 5.2005
R3900 VSS.n353 VSS.n90 5.2005
R3901 VSS.n399 VSS.n90 5.2005
R3902 VSS.n355 VSS.n354 5.2005
R3903 VSS.n354 VSS.n88 5.2005
R3904 VSS.n356 VSS.n98 5.2005
R3905 VSS.n391 VSS.n98 5.2005
R3906 VSS.n358 VSS.n357 5.2005
R3907 VSS.n357 VSS.n96 5.2005
R3908 VSS.n359 VSS.n107 5.2005
R3909 VSS.n383 VSS.n107 5.2005
R3910 VSS.n361 VSS.n360 5.2005
R3911 VSS.n360 VSS.n258 5.2005
R3912 VSS.n362 VSS.n114 5.2005
R3913 VSS.n375 VSS.n114 5.2005
R3914 VSS.n363 VSS.n266 5.2005
R3915 VSS.n266 VSS.n112 5.2005
R3916 VSS.n365 VSS.n364 5.2005
R3917 VSS.n367 VSS.n365 5.2005
R3918 VSS.n267 VSS.n265 5.2005
R3919 VSS.n265 VSS.n264 5.2005
R3920 VSS.n297 VSS.n296 5.2005
R3921 VSS.n296 VSS.n295 5.2005
R3922 VSS.n270 VSS.n269 5.2005
R3923 VSS.n271 VSS.n270 5.2005
R3924 VSS.n286 VSS.n285 5.2005
R3925 VSS.n287 VSS.n286 5.2005
R3926 VSS.n279 VSS.n278 5.2005
R3927 VSS.n903 VSS.n446 5.2005
R3928 VSS.n1101 VSS.n446 5.2005
R3929 VSS.n904 VSS.n472 5.2005
R3930 VSS.n1100 VSS.n472 5.2005
R3931 VSS.n906 VSS.n905 5.2005
R3932 VSS.n907 VSS.n906 5.2005
R3933 VSS.n665 VSS.n664 5.2005
R3934 VSS.n664 VSS.n36 5.2005
R3935 VSS.n780 VSS.n34 5.2005
R3936 VSS.n1149 VSS.n34 5.2005
R3937 VSS.n782 VSS.n781 5.2005
R3938 VSS.n781 VSS.n33 5.2005
R3939 VSS.n783 VSS.n480 5.2005
R3940 VSS.n1087 VSS.n480 5.2005
R3941 VSS.n785 VSS.n784 5.2005
R3942 VSS.n784 VSS.n479 5.2005
R3943 VSS.n786 VSS.n487 5.2005
R3944 VSS.n1079 VSS.n487 5.2005
R3945 VSS.n788 VSS.n787 5.2005
R3946 VSS.n787 VSS.t7 5.2005
R3947 VSS.n789 VSS.n494 5.2005
R3948 VSS.n1068 VSS.n494 5.2005
R3949 VSS.n791 VSS.n790 5.2005
R3950 VSS.n790 VSS.n503 5.2005
R3951 VSS.n792 VSS.n501 5.2005
R3952 VSS.n1060 VSS.n501 5.2005
R3953 VSS.n794 VSS.n793 5.2005
R3954 VSS.n793 VSS.n512 5.2005
R3955 VSS.n795 VSS.n510 5.2005
R3956 VSS.n1052 VSS.n510 5.2005
R3957 VSS.n797 VSS.n796 5.2005
R3958 VSS.n796 VSS.n509 5.2005
R3959 VSS.n798 VSS.n519 5.2005
R3960 VSS.n1044 VSS.n519 5.2005
R3961 VSS.n800 VSS.n799 5.2005
R3962 VSS.n799 VSS.n518 5.2005
R3963 VSS.n801 VSS.n526 5.2005
R3964 VSS.n1036 VSS.n526 5.2005
R3965 VSS.n803 VSS.n802 5.2005
R3966 VSS.n802 VSS.n536 5.2005
R3967 VSS.n804 VSS.n534 5.2005
R3968 VSS.n1028 VSS.n534 5.2005
R3969 VSS.n806 VSS.n805 5.2005
R3970 VSS.n805 VSS.n533 5.2005
R3971 VSS.n807 VSS.n543 5.2005
R3972 VSS.n1020 VSS.n543 5.2005
R3973 VSS.n809 VSS.n808 5.2005
R3974 VSS.n808 VSS.n542 5.2005
R3975 VSS.n810 VSS.n550 5.2005
R3976 VSS.n1012 VSS.n550 5.2005
R3977 VSS.n812 VSS.n811 5.2005
R3978 VSS.n811 VSS.t22 5.2005
R3979 VSS.n813 VSS.n558 5.2005
R3980 VSS.n1004 VSS.n558 5.2005
R3981 VSS.n815 VSS.n814 5.2005
R3982 VSS.n814 VSS.n557 5.2005
R3983 VSS.n816 VSS.n565 5.2005
R3984 VSS.n996 VSS.n565 5.2005
R3985 VSS.n818 VSS.n817 5.2005
R3986 VSS.n817 VSS.n575 5.2005
R3987 VSS.n819 VSS.n573 5.2005
R3988 VSS.n988 VSS.n573 5.2005
R3989 VSS.n821 VSS.n820 5.2005
R3990 VSS.n820 VSS.n572 5.2005
R3991 VSS.n822 VSS.n581 5.2005
R3992 VSS.n980 VSS.n581 5.2005
R3993 VSS.n824 VSS.n823 5.2005
R3994 VSS.n823 VSS.n590 5.2005
R3995 VSS.n695 VSS.n588 5.2005
R3996 VSS.n972 VSS.n588 5.2005
R3997 VSS.n1097 VSS.n447 5.2005
R3998 VSS.n1101 VSS.n447 5.2005
R3999 VSS.n1099 VSS.n1098 5.2005
R4000 VSS.n1100 VSS.n1099 5.2005
R4001 VSS.n474 VSS.n473 5.2005
R4002 VSS.n907 VSS.n473 5.2005
R4003 VSS.n1093 VSS.n1092 5.2005
R4004 VSS.n1092 VSS.n36 5.2005
R4005 VSS.n1091 VSS.n37 5.2005
R4006 VSS.n1149 VSS.n37 5.2005
R4007 VSS.n1090 VSS.n1089 5.2005
R4008 VSS.n1089 VSS.n33 5.2005
R4009 VSS.n1088 VSS.n476 5.2005
R4010 VSS.n1088 VSS.n1087 5.2005
R4011 VSS.n1076 VSS.n478 5.2005
R4012 VSS.n479 VSS.n478 5.2005
R4013 VSS.n1078 VSS.n1077 5.2005
R4014 VSS.n1079 VSS.n1078 5.2005
R4015 VSS.n490 VSS.n489 5.2005
R4016 VSS.n489 VSS.t7 5.2005
R4017 VSS.n1070 VSS.n1069 5.2005
R4018 VSS.n1069 VSS.n1068 5.2005
R4019 VSS.n493 VSS.n492 5.2005
R4020 VSS.n503 VSS.n493 5.2005
R4021 VSS.n1059 VSS.n1058 5.2005
R4022 VSS.n1060 VSS.n1059 5.2005
R4023 VSS.n505 VSS.n504 5.2005
R4024 VSS.n512 VSS.n504 5.2005
R4025 VSS.n1054 VSS.n1053 5.2005
R4026 VSS.n1053 VSS.n1052 5.2005
R4027 VSS.n508 VSS.n507 5.2005
R4028 VSS.n509 VSS.n508 5.2005
R4029 VSS.n1043 VSS.n1042 5.2005
R4030 VSS.n1044 VSS.n1043 5.2005
R4031 VSS.n522 VSS.n521 5.2005
R4032 VSS.n521 VSS.n518 5.2005
R4033 VSS.n1038 VSS.n1037 5.2005
R4034 VSS.n1037 VSS.n1036 5.2005
R4035 VSS.n525 VSS.n524 5.2005
R4036 VSS.n536 VSS.n525 5.2005
R4037 VSS.n1027 VSS.n1026 5.2005
R4038 VSS.n1028 VSS.n1027 5.2005
R4039 VSS.n538 VSS.n537 5.2005
R4040 VSS.n537 VSS.n533 5.2005
R4041 VSS.n1022 VSS.n1021 5.2005
R4042 VSS.n1021 VSS.n1020 5.2005
R4043 VSS.n541 VSS.n540 5.2005
R4044 VSS.n542 VSS.n541 5.2005
R4045 VSS.n1011 VSS.n1010 5.2005
R4046 VSS.n1012 VSS.n1011 5.2005
R4047 VSS.n553 VSS.n552 5.2005
R4048 VSS.n552 VSS.t22 5.2005
R4049 VSS.n1006 VSS.n1005 5.2005
R4050 VSS.n1005 VSS.n1004 5.2005
R4051 VSS.n556 VSS.n555 5.2005
R4052 VSS.n557 VSS.n556 5.2005
R4053 VSS.n995 VSS.n994 5.2005
R4054 VSS.n996 VSS.n995 5.2005
R4055 VSS.n568 VSS.n567 5.2005
R4056 VSS.n575 VSS.n567 5.2005
R4057 VSS.n990 VSS.n989 5.2005
R4058 VSS.n989 VSS.n988 5.2005
R4059 VSS.n571 VSS.n570 5.2005
R4060 VSS.n572 VSS.n571 5.2005
R4061 VSS.n979 VSS.n978 5.2005
R4062 VSS.n980 VSS.n979 5.2005
R4063 VSS.n584 VSS.n583 5.2005
R4064 VSS.n590 VSS.n583 5.2005
R4065 VSS.n974 VSS.n973 5.2005
R4066 VSS.n973 VSS.n972 5.2005
R4067 VSS.n609 VSS.n608 5.2005
R4068 VSS.n610 VSS.n609 5.2005
R4069 VSS.n622 VSS.n621 5.2005
R4070 VSS.n621 VSS.n620 5.2005
R4071 VSS.n606 VSS.n605 5.2005
R4072 VSS.n605 VSS.n604 5.2005
R4073 VSS.n627 VSS.n626 5.2005
R4074 VSS.n628 VSS.n627 5.2005
R4075 VSS.n595 VSS.n594 5.2005
R4076 VSS.n596 VSS.n595 5.2005
R4077 VSS.n966 VSS.n965 5.2005
R4078 VSS.n965 VSS.n964 5.2005
R4079 VSS.n592 VSS.n591 5.2005
R4080 VSS.n591 VSS.n587 5.2005
R4081 VSS.n971 VSS.n970 5.2005
R4082 VSS.n972 VSS.n971 5.2005
R4083 VSS.n580 VSS.n579 5.2005
R4084 VSS.n590 VSS.n580 5.2005
R4085 VSS.n982 VSS.n981 5.2005
R4086 VSS.n981 VSS.n980 5.2005
R4087 VSS.n577 VSS.n576 5.2005
R4088 VSS.n576 VSS.n572 5.2005
R4089 VSS.n987 VSS.n986 5.2005
R4090 VSS.n988 VSS.n987 5.2005
R4091 VSS.n564 VSS.n563 5.2005
R4092 VSS.n575 VSS.n564 5.2005
R4093 VSS.n998 VSS.n997 5.2005
R4094 VSS.n997 VSS.n996 5.2005
R4095 VSS.n561 VSS.n560 5.2005
R4096 VSS.n560 VSS.n557 5.2005
R4097 VSS.n1003 VSS.n1002 5.2005
R4098 VSS.n1004 VSS.n1003 5.2005
R4099 VSS.n549 VSS.n548 5.2005
R4100 VSS.t22 VSS.n549 5.2005
R4101 VSS.n1014 VSS.n1013 5.2005
R4102 VSS.n1013 VSS.n1012 5.2005
R4103 VSS.n546 VSS.n545 5.2005
R4104 VSS.n545 VSS.n542 5.2005
R4105 VSS.n1019 VSS.n1018 5.2005
R4106 VSS.n1020 VSS.n1019 5.2005
R4107 VSS.n532 VSS.n531 5.2005
R4108 VSS.n533 VSS.n532 5.2005
R4109 VSS.n1030 VSS.n1029 5.2005
R4110 VSS.n1029 VSS.n1028 5.2005
R4111 VSS.n529 VSS.n528 5.2005
R4112 VSS.n536 VSS.n528 5.2005
R4113 VSS.n1035 VSS.n1034 5.2005
R4114 VSS.n1036 VSS.n1035 5.2005
R4115 VSS.n517 VSS.n516 5.2005
R4116 VSS.n518 VSS.n517 5.2005
R4117 VSS.n1046 VSS.n1045 5.2005
R4118 VSS.n1045 VSS.n1044 5.2005
R4119 VSS.n514 VSS.n513 5.2005
R4120 VSS.n513 VSS.n509 5.2005
R4121 VSS.n1051 VSS.n1050 5.2005
R4122 VSS.n1052 VSS.n1051 5.2005
R4123 VSS.n500 VSS.n499 5.2005
R4124 VSS.n512 VSS.n500 5.2005
R4125 VSS.n1062 VSS.n1061 5.2005
R4126 VSS.n1061 VSS.n1060 5.2005
R4127 VSS.n497 VSS.n496 5.2005
R4128 VSS.n503 VSS.n496 5.2005
R4129 VSS.n1067 VSS.n1066 5.2005
R4130 VSS.n1068 VSS.n1067 5.2005
R4131 VSS.n486 VSS.n485 5.2005
R4132 VSS.t7 VSS.n486 5.2005
R4133 VSS.n1081 VSS.n1080 5.2005
R4134 VSS.n1080 VSS.n1079 5.2005
R4135 VSS.n483 VSS.n482 5.2005
R4136 VSS.n482 VSS.n479 5.2005
R4137 VSS.n1086 VSS.n1085 5.2005
R4138 VSS.n1087 VSS.n1086 5.2005
R4139 VSS.n40 VSS.n38 5.2005
R4140 VSS.n38 VSS.n33 5.2005
R4141 VSS.n1148 VSS.n1147 5.2005
R4142 VSS.n1149 VSS.n1148 5.2005
R4143 VSS.n41 VSS.n39 5.2005
R4144 VSS.n39 VSS.n36 5.2005
R4145 VSS.n1143 VSS.n44 5.2005
R4146 VSS.n907 VSS.n44 5.2005
R4147 VSS.n1142 VSS.n45 5.2005
R4148 VSS.n1100 VSS.n45 5.2005
R4149 VSS.n1141 VSS.n46 5.2005
R4150 VSS.n1101 VSS.n46 5.2005
R4151 VSS.n451 VSS.n47 5.2005
R4152 VSS.n451 VSS.n448 5.2005
R4153 VSS.n1132 VSS.n1131 5.2005
R4154 VSS.n1133 VSS.n1132 5.2005
R4155 VSS.n453 VSS.n452 5.2005
R4156 VSS.n452 VSS.n450 5.2005
R4157 VSS.n1127 VSS.n455 5.2005
R4158 VSS.n1110 VSS.n455 5.2005
R4159 VSS.n1126 VSS.n456 5.2005
R4160 VSS.n462 VSS.n456 5.2005
R4161 VSS.n1125 VSS.n457 5.2005
R4162 VSS.n1118 VSS.n457 5.2005
R4163 VSS.n460 VSS.n458 5.2005
R4164 VSS.n1119 VSS.n460 5.2005
R4165 VSS.n465 VSS.n461 5.2005
R4166 VSS.n1117 VSS.n1116 5.2005
R4167 VSS.n1118 VSS.n1117 5.2005
R4168 VSS.n464 VSS.n463 5.2005
R4169 VSS.n463 VSS.n462 5.2005
R4170 VSS.n1112 VSS.n1111 5.2005
R4171 VSS.n1111 VSS.n1110 5.2005
R4172 VSS.n1109 VSS.n1108 5.2005
R4173 VSS.n1109 VSS.n450 5.2005
R4174 VSS.n1107 VSS.n449 5.2005
R4175 VSS.n1133 VSS.n449 5.2005
R4176 VSS.n471 VSS.n467 5.2005
R4177 VSS.n471 VSS.n448 5.2005
R4178 VSS.n1103 VSS.n1102 5.2005
R4179 VSS.n1102 VSS.n1101 5.2005
R4180 VSS.n470 VSS.n469 5.2005
R4181 VSS.n1100 VSS.n470 5.2005
R4182 VSS.n909 VSS.n908 5.2005
R4183 VSS.n908 VSS.n907 5.2005
R4184 VSS.n663 VSS.n662 5.2005
R4185 VSS.n663 VSS.n36 5.2005
R4186 VSS.n913 VSS.n35 5.2005
R4187 VSS.n1149 VSS.n35 5.2005
R4188 VSS.n914 VSS.n661 5.2005
R4189 VSS.n661 VSS.n33 5.2005
R4190 VSS.n915 VSS.n481 5.2005
R4191 VSS.n1087 VSS.n481 5.2005
R4192 VSS.n659 VSS.n658 5.2005
R4193 VSS.n658 VSS.n479 5.2005
R4194 VSS.n919 VSS.n488 5.2005
R4195 VSS.n1079 VSS.n488 5.2005
R4196 VSS.n920 VSS.n657 5.2005
R4197 VSS.n657 VSS.t7 5.2005
R4198 VSS.n921 VSS.n495 5.2005
R4199 VSS.n1068 VSS.n495 5.2005
R4200 VSS.n655 VSS.n654 5.2005
R4201 VSS.n654 VSS.n503 5.2005
R4202 VSS.n925 VSS.n502 5.2005
R4203 VSS.n1060 VSS.n502 5.2005
R4204 VSS.n926 VSS.n653 5.2005
R4205 VSS.n653 VSS.n512 5.2005
R4206 VSS.n927 VSS.n511 5.2005
R4207 VSS.n1052 VSS.n511 5.2005
R4208 VSS.n651 VSS.n650 5.2005
R4209 VSS.n650 VSS.n509 5.2005
R4210 VSS.n931 VSS.n520 5.2005
R4211 VSS.n1044 VSS.n520 5.2005
R4212 VSS.n932 VSS.n649 5.2005
R4213 VSS.n649 VSS.n518 5.2005
R4214 VSS.n933 VSS.n527 5.2005
R4215 VSS.n1036 VSS.n527 5.2005
R4216 VSS.n648 VSS.n647 5.2005
R4217 VSS.n647 VSS.n536 5.2005
R4218 VSS.n937 VSS.n535 5.2005
R4219 VSS.n1028 VSS.n535 5.2005
R4220 VSS.n938 VSS.n646 5.2005
R4221 VSS.n646 VSS.n533 5.2005
R4222 VSS.n939 VSS.n544 5.2005
R4223 VSS.n1020 VSS.n544 5.2005
R4224 VSS.n644 VSS.n643 5.2005
R4225 VSS.n643 VSS.n542 5.2005
R4226 VSS.n943 VSS.n551 5.2005
R4227 VSS.n1012 VSS.n551 5.2005
R4228 VSS.n944 VSS.n642 5.2005
R4229 VSS.n642 VSS.t22 5.2005
R4230 VSS.n945 VSS.n559 5.2005
R4231 VSS.n1004 VSS.n559 5.2005
R4232 VSS.n640 VSS.n639 5.2005
R4233 VSS.n639 VSS.n557 5.2005
R4234 VSS.n949 VSS.n566 5.2005
R4235 VSS.n996 VSS.n566 5.2005
R4236 VSS.n950 VSS.n638 5.2005
R4237 VSS.n638 VSS.n575 5.2005
R4238 VSS.n951 VSS.n574 5.2005
R4239 VSS.n988 VSS.n574 5.2005
R4240 VSS.n636 VSS.n635 5.2005
R4241 VSS.n635 VSS.n572 5.2005
R4242 VSS.n955 VSS.n582 5.2005
R4243 VSS.n980 VSS.n582 5.2005
R4244 VSS.n956 VSS.n634 5.2005
R4245 VSS.n634 VSS.n590 5.2005
R4246 VSS.n957 VSS.n589 5.2005
R4247 VSS.n972 VSS.n589 5.2005
R4248 VSS.n600 VSS.n598 5.2005
R4249 VSS.n598 VSS.n587 5.2005
R4250 VSS.n962 VSS.n961 5.2005
R4251 VSS.n964 VSS.n962 5.2005
R4252 VSS.n599 VSS.n597 5.2005
R4253 VSS.n597 VSS.n596 5.2005
R4254 VSS.n630 VSS.n629 5.2005
R4255 VSS.n629 VSS.n628 5.2005
R4256 VSS.n603 VSS.n602 5.2005
R4257 VSS.n604 VSS.n603 5.2005
R4258 VSS.n619 VSS.n618 5.2005
R4259 VSS.n620 VSS.n619 5.2005
R4260 VSS.n612 VSS.n611 5.2005
R4261 VSS.n611 VSS.n610 5.2005
R4262 VSS.n188 VSS.n186 4.85463
R4263 VSS.n195 VSS.n170 4.85463
R4264 VSS.n233 VSS.n232 4.85463
R4265 VSS.n228 VSS.n227 4.85463
R4266 VSS.n832 VSS.n831 4.69811
R4267 VSS.n896 VSS.n895 4.69811
R4268 VSS.n191 VSS.n189 4.69811
R4269 VSS.n199 VSS.n196 4.69811
R4270 VSS.n230 VSS.n151 4.69811
R4271 VSS.n225 VSS.n155 4.69811
R4272 VSS.n257 VSS.n105 4.63013
R4273 VSS.n56 VSS.n55 4.63013
R4274 VSS.n829 VSS.n828 4.5725
R4275 VSS.n899 VSS.n898 4.5725
R4276 VSS.t35 VSS.n827 4.5276
R4277 VSS.n900 VSS.t32 4.52597
R4278 VSS.n285 VSS.n284 4.5005
R4279 VSS.n269 VSS.n268 4.5005
R4280 VSS.n298 VSS.n297 4.5005
R4281 VSS.n299 VSS.n267 4.5005
R4282 VSS.n364 VSS.n300 4.5005
R4283 VSS.n363 VSS.n301 4.5005
R4284 VSS.n362 VSS.n302 4.5005
R4285 VSS.n361 VSS.n303 4.5005
R4286 VSS.n359 VSS.n304 4.5005
R4287 VSS.n358 VSS.n305 4.5005
R4288 VSS.n356 VSS.n306 4.5005
R4289 VSS.n355 VSS.n307 4.5005
R4290 VSS.n353 VSS.n308 4.5005
R4291 VSS.n352 VSS.n309 4.5005
R4292 VSS.n350 VSS.n310 4.5005
R4293 VSS.n349 VSS.n311 4.5005
R4294 VSS.n347 VSS.n312 4.5005
R4295 VSS.n346 VSS.n313 4.5005
R4296 VSS.n344 VSS.n314 4.5005
R4297 VSS.n343 VSS.n315 4.5005
R4298 VSS.n341 VSS.n316 4.5005
R4299 VSS.n340 VSS.n317 4.5005
R4300 VSS.n338 VSS.n318 4.5005
R4301 VSS.n337 VSS.n319 4.5005
R4302 VSS.n335 VSS.n320 4.5005
R4303 VSS.n334 VSS.n321 4.5005
R4304 VSS.n333 VSS.n322 4.5005
R4305 VSS.n332 VSS.n323 4.5005
R4306 VSS.n330 VSS.n324 4.5005
R4307 VSS.n329 VSS.n328 4.5005
R4308 VSS.n283 VSS.n279 4.5005
R4309 VSS.n976 VSS.n584 4.5005
R4310 VSS.n978 VSS.n977 4.5005
R4311 VSS.n570 VSS.n569 4.5005
R4312 VSS.n991 VSS.n990 4.5005
R4313 VSS.n992 VSS.n568 4.5005
R4314 VSS.n994 VSS.n993 4.5005
R4315 VSS.n555 VSS.n554 4.5005
R4316 VSS.n1007 VSS.n1006 4.5005
R4317 VSS.n1008 VSS.n553 4.5005
R4318 VSS.n1010 VSS.n1009 4.5005
R4319 VSS.n540 VSS.n539 4.5005
R4320 VSS.n1023 VSS.n1022 4.5005
R4321 VSS.n1024 VSS.n538 4.5005
R4322 VSS.n1026 VSS.n1025 4.5005
R4323 VSS.n524 VSS.n523 4.5005
R4324 VSS.n1039 VSS.n1038 4.5005
R4325 VSS.n1040 VSS.n522 4.5005
R4326 VSS.n1042 VSS.n1041 4.5005
R4327 VSS.n507 VSS.n506 4.5005
R4328 VSS.n1055 VSS.n1054 4.5005
R4329 VSS.n1056 VSS.n505 4.5005
R4330 VSS.n1058 VSS.n1057 4.5005
R4331 VSS.n492 VSS.n491 4.5005
R4332 VSS.n1071 VSS.n1070 4.5005
R4333 VSS.n1072 VSS.n490 4.5005
R4334 VSS.n1077 VSS.n1073 4.5005
R4335 VSS.n1076 VSS.n1075 4.5005
R4336 VSS.n1074 VSS.n476 4.5005
R4337 VSS.n1090 VSS.n477 4.5005
R4338 VSS.n1091 VSS.n475 4.5005
R4339 VSS.n1094 VSS.n1093 4.5005
R4340 VSS.n1095 VSS.n474 4.5005
R4341 VSS.n1098 VSS.n1096 4.5005
R4342 VSS.n1097 VSS.n445 4.5005
R4343 VSS.n975 VSS.n974 4.5005
R4344 VSS.n695 VSS.n693 4.5005
R4345 VSS.n895 VSS.n894 4.5005
R4346 VSS.n833 VSS.n832 4.5005
R4347 VSS.n825 VSS.n824 4.5005
R4348 VSS.n822 VSS.n696 4.5005
R4349 VSS.n821 VSS.n697 4.5005
R4350 VSS.n819 VSS.n698 4.5005
R4351 VSS.n818 VSS.n699 4.5005
R4352 VSS.n816 VSS.n700 4.5005
R4353 VSS.n815 VSS.n701 4.5005
R4354 VSS.n813 VSS.n702 4.5005
R4355 VSS.n812 VSS.n703 4.5005
R4356 VSS.n810 VSS.n704 4.5005
R4357 VSS.n809 VSS.n705 4.5005
R4358 VSS.n807 VSS.n706 4.5005
R4359 VSS.n806 VSS.n707 4.5005
R4360 VSS.n804 VSS.n708 4.5005
R4361 VSS.n803 VSS.n709 4.5005
R4362 VSS.n801 VSS.n710 4.5005
R4363 VSS.n800 VSS.n711 4.5005
R4364 VSS.n798 VSS.n712 4.5005
R4365 VSS.n797 VSS.n713 4.5005
R4366 VSS.n795 VSS.n714 4.5005
R4367 VSS.n794 VSS.n715 4.5005
R4368 VSS.n792 VSS.n716 4.5005
R4369 VSS.n791 VSS.n717 4.5005
R4370 VSS.n789 VSS.n718 4.5005
R4371 VSS.n788 VSS.n719 4.5005
R4372 VSS.n786 VSS.n720 4.5005
R4373 VSS.n785 VSS.n721 4.5005
R4374 VSS.n783 VSS.n722 4.5005
R4375 VSS.n782 VSS.n723 4.5005
R4376 VSS.n780 VSS.n779 4.5005
R4377 VSS.n778 VSS.n665 4.5005
R4378 VSS.n905 VSS.n666 4.5005
R4379 VSS.n904 VSS.n902 4.5005
R4380 VSS.n903 VSS.n444 4.5005
R4381 VSS.n290 VSS.n289 4.5005
R4382 VSS.n291 VSS.n273 4.5005
R4383 VSS.n293 VSS.n292 4.5005
R4384 VSS.n262 VSS.n261 4.5005
R4385 VSS.n370 VSS.n369 4.5005
R4386 VSS.n371 VSS.n260 4.5005
R4387 VSS.n373 VSS.n372 4.5005
R4388 VSS.n103 VSS.n102 4.5005
R4389 VSS.n386 VSS.n385 4.5005
R4390 VSS.n387 VSS.n101 4.5005
R4391 VSS.n389 VSS.n388 4.5005
R4392 VSS.n86 VSS.n85 4.5005
R4393 VSS.n402 VSS.n401 4.5005
R4394 VSS.n403 VSS.n84 4.5005
R4395 VSS.n405 VSS.n404 4.5005
R4396 VSS.n69 VSS.n68 4.5005
R4397 VSS.n418 VSS.n417 4.5005
R4398 VSS.n419 VSS.n67 4.5005
R4399 VSS.n421 VSS.n420 4.5005
R4400 VSS.n50 VSS.n49 4.5005
R4401 VSS.n439 VSS.n438 4.5005
R4402 VSS.n440 VSS.n12 4.5005
R4403 VSS.n1165 VSS.n13 4.5005
R4404 VSS.n1164 VSS.n14 4.5005
R4405 VSS.n1163 VSS.n15 4.5005
R4406 VSS.n24 VSS.n16 4.5005
R4407 VSS.n1157 VSS.n25 4.5005
R4408 VSS.n1156 VSS.n26 4.5005
R4409 VSS.n1155 VSS.n27 4.5005
R4410 VSS.n325 VSS.n28 4.5005
R4411 VSS.n275 VSS.n274 4.5005
R4412 VSS.n379 VSS.n109 4.5005
R4413 VSS.n381 VSS.n380 4.5005
R4414 VSS.n94 VSS.n93 4.5005
R4415 VSS.n394 VSS.n393 4.5005
R4416 VSS.n395 VSS.n92 4.5005
R4417 VSS.n397 VSS.n396 4.5005
R4418 VSS.n78 VSS.n77 4.5005
R4419 VSS.n410 VSS.n409 4.5005
R4420 VSS.n411 VSS.n76 4.5005
R4421 VSS.n413 VSS.n412 4.5005
R4422 VSS.n61 VSS.n60 4.5005
R4423 VSS.n426 VSS.n425 4.5005
R4424 VSS.n427 VSS.n59 4.5005
R4425 VSS.n434 VSS.n428 4.5005
R4426 VSS.n433 VSS.n429 4.5005
R4427 VSS.n432 VSS.n431 4.5005
R4428 VSS.n378 VSS.n377 4.5005
R4429 VSS.n227 VSS.n226 4.5005
R4430 VSS.n226 VSS.n225 4.5005
R4431 VSS.n232 VSS.n231 4.5005
R4432 VSS.n231 VSS.n230 4.5005
R4433 VSS.n200 VSS.n170 4.5005
R4434 VSS.n200 VSS.n199 4.5005
R4435 VSS.n192 VSS.n186 4.5005
R4436 VSS.n192 VSS.n191 4.5005
R4437 VSS.n255 VSS.n116 4.5005
R4438 VSS.n254 VSS.n117 4.5005
R4439 VSS.n253 VSS.n118 4.5005
R4440 VSS.n251 VSS.n119 4.5005
R4441 VSS.n250 VSS.n120 4.5005
R4442 VSS.n248 VSS.n121 4.5005
R4443 VSS.n247 VSS.n122 4.5005
R4444 VSS.n245 VSS.n123 4.5005
R4445 VSS.n244 VSS.n124 4.5005
R4446 VSS.n242 VSS.n125 4.5005
R4447 VSS.n241 VSS.n126 4.5005
R4448 VSS.n239 VSS.n127 4.5005
R4449 VSS.n238 VSS.n128 4.5005
R4450 VSS.n236 VSS.n235 4.5005
R4451 VSS.n3 VSS.n0 4.5005
R4452 VSS.n1170 VSS.n1169 4.5005
R4453 VSS.n183 VSS.n115 4.5005
R4454 VSS.n608 VSS.n607 4.5005
R4455 VSS.n623 VSS.n622 4.5005
R4456 VSS.n624 VSS.n606 4.5005
R4457 VSS.n626 VSS.n625 4.5005
R4458 VSS.n594 VSS.n593 4.5005
R4459 VSS.n967 VSS.n966 4.5005
R4460 VSS.n968 VSS.n592 4.5005
R4461 VSS.n970 VSS.n969 4.5005
R4462 VSS.n579 VSS.n578 4.5005
R4463 VSS.n983 VSS.n982 4.5005
R4464 VSS.n984 VSS.n577 4.5005
R4465 VSS.n986 VSS.n985 4.5005
R4466 VSS.n563 VSS.n562 4.5005
R4467 VSS.n999 VSS.n998 4.5005
R4468 VSS.n1000 VSS.n561 4.5005
R4469 VSS.n1002 VSS.n1001 4.5005
R4470 VSS.n548 VSS.n547 4.5005
R4471 VSS.n1015 VSS.n1014 4.5005
R4472 VSS.n1016 VSS.n546 4.5005
R4473 VSS.n1018 VSS.n1017 4.5005
R4474 VSS.n531 VSS.n530 4.5005
R4475 VSS.n1031 VSS.n1030 4.5005
R4476 VSS.n1032 VSS.n529 4.5005
R4477 VSS.n1034 VSS.n1033 4.5005
R4478 VSS.n516 VSS.n515 4.5005
R4479 VSS.n1047 VSS.n1046 4.5005
R4480 VSS.n1048 VSS.n514 4.5005
R4481 VSS.n1050 VSS.n1049 4.5005
R4482 VSS.n499 VSS.n498 4.5005
R4483 VSS.n1063 VSS.n1062 4.5005
R4484 VSS.n1064 VSS.n497 4.5005
R4485 VSS.n1066 VSS.n1065 4.5005
R4486 VSS.n485 VSS.n484 4.5005
R4487 VSS.n1082 VSS.n1081 4.5005
R4488 VSS.n1083 VSS.n483 4.5005
R4489 VSS.n1085 VSS.n1084 4.5005
R4490 VSS.n42 VSS.n40 4.5005
R4491 VSS.n1147 VSS.n1146 4.5005
R4492 VSS.n1145 VSS.n41 4.5005
R4493 VSS.n1144 VSS.n1143 4.5005
R4494 VSS.n1142 VSS.n43 4.5005
R4495 VSS.n1139 VSS.n1138 4.5005
R4496 VSS.n1141 VSS.n1140 4.5005
R4497 VSS.n48 VSS.n47 4.5005
R4498 VSS.n1131 VSS.n1130 4.5005
R4499 VSS.n1129 VSS.n453 4.5005
R4500 VSS.n1128 VSS.n1127 4.5005
R4501 VSS.n1126 VSS.n454 4.5005
R4502 VSS.n1125 VSS.n1124 4.5005
R4503 VSS.n1123 VSS.n458 4.5005
R4504 VSS.n618 VSS.n617 4.5005
R4505 VSS.n602 VSS.n601 4.5005
R4506 VSS.n631 VSS.n630 4.5005
R4507 VSS.n632 VSS.n599 4.5005
R4508 VSS.n961 VSS.n960 4.5005
R4509 VSS.n959 VSS.n600 4.5005
R4510 VSS.n958 VSS.n957 4.5005
R4511 VSS.n956 VSS.n633 4.5005
R4512 VSS.n955 VSS.n954 4.5005
R4513 VSS.n953 VSS.n636 4.5005
R4514 VSS.n952 VSS.n951 4.5005
R4515 VSS.n950 VSS.n637 4.5005
R4516 VSS.n949 VSS.n948 4.5005
R4517 VSS.n947 VSS.n640 4.5005
R4518 VSS.n946 VSS.n945 4.5005
R4519 VSS.n944 VSS.n641 4.5005
R4520 VSS.n943 VSS.n942 4.5005
R4521 VSS.n941 VSS.n644 4.5005
R4522 VSS.n940 VSS.n939 4.5005
R4523 VSS.n938 VSS.n645 4.5005
R4524 VSS.n937 VSS.n936 4.5005
R4525 VSS.n935 VSS.n648 4.5005
R4526 VSS.n934 VSS.n933 4.5005
R4527 VSS.n932 VSS 4.5005
R4528 VSS.n931 VSS.n930 4.5005
R4529 VSS.n929 VSS.n651 4.5005
R4530 VSS.n928 VSS.n927 4.5005
R4531 VSS.n926 VSS.n652 4.5005
R4532 VSS.n925 VSS.n924 4.5005
R4533 VSS.n923 VSS.n655 4.5005
R4534 VSS.n922 VSS.n921 4.5005
R4535 VSS.n920 VSS.n656 4.5005
R4536 VSS.n919 VSS.n918 4.5005
R4537 VSS.n917 VSS.n659 4.5005
R4538 VSS.n916 VSS.n915 4.5005
R4539 VSS.n914 VSS.n660 4.5005
R4540 VSS.n913 VSS.n912 4.5005
R4541 VSS.n911 VSS.n662 4.5005
R4542 VSS.n910 VSS.n909 4.5005
R4543 VSS.n469 VSS.n468 4.5005
R4544 VSS.n1104 VSS.n1103 4.5005
R4545 VSS.n1105 VSS.n467 4.5005
R4546 VSS.n1107 VSS.n1106 4.5005
R4547 VSS.n1108 VSS.n466 4.5005
R4548 VSS.n1113 VSS.n1112 4.5005
R4549 VSS.n1114 VSS.n464 4.5005
R4550 VSS.n1116 VSS.n1115 4.5005
R4551 VSS.n465 VSS.n459 4.5005
R4552 VSS.n616 VSS.n612 4.5005
R4553 VSS.n745 VSS.n744 4.49281
R4554 VSS.n754 VSS.n753 4.49281
R4555 VSS.n765 VSS.n764 4.49281
R4556 VSS.n774 VSS.n773 4.49281
R4557 VSS.n839 VSS.n838 4.49281
R4558 VSS.n858 VSS.n683 4.49281
R4559 VSS.n873 VSS.n872 4.49281
R4560 VSS.n883 VSS.n671 4.49281
R4561 VSS.n137 VSS.n136 4.49281
R4562 VSS.n146 VSS.n145 4.49281
R4563 VSS.n202 VSS.n167 4.49281
R4564 VSS.n221 VSS.n159 4.49281
R4565 VSS.n201 VSS.n169 3.9035
R4566 VSS.n223 VSS.n222 3.90299
R4567 VSS.n280 VSS.n278 3.89052
R4568 VSS.n739 VSS.t5 3.5285
R4569 VSS.n739 VSS.t2 3.5285
R4570 VSS.n738 VSS.t8 3.5285
R4571 VSS.t5 VSS.n738 3.5285
R4572 VSS.n736 VSS.t11 3.5285
R4573 VSS.t8 VSS.n736 3.5285
R4574 VSS.n734 VSS.t14 3.5285
R4575 VSS.t11 VSS.n734 3.5285
R4576 VSS.n732 VSS.t17 3.5285
R4577 VSS.t14 VSS.n732 3.5285
R4578 VSS.n731 VSS.t20 3.5285
R4579 VSS.t17 VSS.n731 3.5285
R4580 VSS.n729 VSS.t23 3.5285
R4581 VSS.t20 VSS.n729 3.5285
R4582 VSS.n727 VSS.t26 3.5285
R4583 VSS.t23 VSS.n727 3.5285
R4584 VSS.n725 VSS.t29 3.5285
R4585 VSS.t26 VSS.n725 3.5285
R4586 VSS.n889 VSS.t39 3.5285
R4587 VSS.n889 VSS.t37 3.5285
R4588 VSS.n888 VSS.t41 3.5285
R4589 VSS.t39 VSS.n888 3.5285
R4590 VSS.n877 VSS.t43 3.5285
R4591 VSS.n877 VSS.t41 3.5285
R4592 VSS.n876 VSS.t45 3.5285
R4593 VSS.t43 VSS.n876 3.5285
R4594 VSS.t47 VSS.n854 3.5285
R4595 VSS.n854 VSS.t45 3.5285
R4596 VSS.n855 VSS.t49 3.5285
R4597 VSS.n855 VSS.t47 3.5285
R4598 VSS.n853 VSS.t51 3.5285
R4599 VSS.t49 VSS.n853 3.5285
R4600 VSS.n843 VSS.t53 3.5285
R4601 VSS.n843 VSS.t51 3.5285
R4602 VSS.n842 VSS.t55 3.5285
R4603 VSS.t53 VSS.n842 3.5285
R4604 VSS.n173 VSS.n172 3.5285
R4605 VSS.n172 VSS.n1 3.5285
R4606 VSS.n176 VSS.n175 3.5285
R4607 VSS.n175 VSS.n173 3.5285
R4608 VSS.n179 VSS.n178 3.5285
R4609 VSS.n178 VSS.n176 3.5285
R4610 VSS.n182 VSS.n181 3.5285
R4611 VSS.n181 VSS.n179 3.5285
R4612 VSS.n198 VSS.n197 3.5285
R4613 VSS.n198 VSS.n164 3.5285
R4614 VSS.n213 VSS.n211 3.5285
R4615 VSS.n213 VSS.n212 3.5285
R4616 VSS.n210 VSS.n164 3.5285
R4617 VSS.n211 VSS.n210 3.5285
R4618 VSS.n212 VSS.n156 3.5285
R4619 VSS.n224 VSS.n156 3.5285
R4620 VSS.n153 VSS.n2 3.49121
R4621 VSS.n185 VSS.n184 3.49121
R4622 VSS.n1120 VSS.n461 3.45362
R4623 VSS.n758 VSS.n757 3.36973
R4624 VSS.n761 VSS.n760 3.36973
R4625 VSS.n863 VSS.n681 3.36973
R4626 VSS.n865 VSS.n679 3.36973
R4627 VSS.n226 VSS.n223 3.09098
R4628 VSS.n201 VSS.n200 3.09091
R4629 VSS.n828 VSS.t35 2.9825
R4630 VSS.t32 VSS.n899 2.9825
R4631 VSS.n899 VSS.n669 2.40683
R4632 VSS.n828 VSS.n692 2.3767
R4633 VSS.n742 VSS.n741 2.24665
R4634 VSS.n757 VSS.n756 2.24665
R4635 VSS.n762 VSS.n761 2.24665
R4636 VSS.n777 VSS.n776 2.24665
R4637 VSS.n860 VSS.n681 2.24665
R4638 VSS.n868 VSS.n679 2.24665
R4639 VSS.n134 VSS.n133 2.24665
R4640 VSS.n150 VSS.n149 2.24665
R4641 VSS.n834 VSS.t54 2.07778
R4642 VSS.n893 VSS.t36 2.07778
R4643 VSS.n443 VSS.n442 1.8905
R4644 VSS.n1120 VSS.n1119 1.68164
R4645 VSS.n280 VSS.n277 1.231
R4646 VSS.n746 VSS.n745 1.12358
R4647 VSS.n753 VSS.n752 1.12358
R4648 VSS.n766 VSS.n765 1.12358
R4649 VSS.n773 VSS.n772 1.12358
R4650 VSS.n838 VSS.n837 1.12358
R4651 VSS.n849 VSS.n683 1.12358
R4652 VSS.n872 VSS.n871 1.12358
R4653 VSS.n884 VSS.n883 1.12358
R4654 VSS.n138 VSS.n137 1.12358
R4655 VSS.n145 VSS.n144 1.12358
R4656 VSS.n205 VSS.n167 1.12358
R4657 VSS.n218 VSS.n159 1.12358
R4658 VSS.n769 VSS.t6 0.913
R4659 VSS.n749 VSS.t21 0.913
R4660 VSS.n741 VSS.t27 0.913
R4661 VSS.n745 VSS.t24 0.913
R4662 VSS.n753 VSS.t18 0.913
R4663 VSS.n757 VSS.t15 0.913
R4664 VSS.n761 VSS.t12 0.913
R4665 VSS.n765 VSS.t9 0.913
R4666 VSS.n773 VSS.t3 0.913
R4667 VSS.n776 VSS.t0 0.913
R4668 VSS.n881 VSS.t40 0.913
R4669 VSS.n847 VSS.t50 0.913
R4670 VSS.n838 VSS.t52 0.913
R4671 VSS.n683 VSS.t48 0.913
R4672 VSS.n681 VSS.t46 0.913
R4673 VSS.n679 VSS.t44 0.913
R4674 VSS.n872 VSS.t42 0.913
R4675 VSS.n883 VSS.t38 0.913
R4676 VSS.n141 VSS.n130 0.913
R4677 VSS.n133 VSS.n132 0.913
R4678 VSS.n137 VSS.n131 0.913
R4679 VSS.n145 VSS.n129 0.913
R4680 VSS.n149 VSS.n148 0.913
R4681 VSS.n162 VSS.n161 0.913
R4682 VSS.n167 VSS.n166 0.913
R4683 VSS.n159 VSS.n158 0.913
R4684 VSS.n901 VSS.n900 0.249527
R4685 VSS.n827 VSS.n826 0.226446
R4686 VSS.n111 VSS.n110 0.217167
R4687 VSS.n366 VSS.n111 0.217167
R4688 VSS.n430 VSS.n5 0.217167
R4689 VSS.n18 VSS.n5 0.217167
R4690 VSS.n586 VSS.n585 0.193093
R4691 VSS.n963 VSS.n586 0.193093
R4692 VSS.n1136 VSS.n1135 0.193093
R4693 VSS.n1135 VSS.n1134 0.193093
R4694 VSS.n618 VSS.n612 0.1445
R4695 VSS.n618 VSS.n602 0.1445
R4696 VSS.n630 VSS.n602 0.1445
R4697 VSS.n630 VSS.n599 0.1445
R4698 VSS.n961 VSS.n599 0.1445
R4699 VSS.n961 VSS.n600 0.1445
R4700 VSS.n957 VSS.n600 0.1445
R4701 VSS.n957 VSS.n956 0.1445
R4702 VSS.n956 VSS.n955 0.1445
R4703 VSS.n955 VSS.n636 0.1445
R4704 VSS.n951 VSS.n636 0.1445
R4705 VSS.n951 VSS.n950 0.1445
R4706 VSS.n950 VSS.n949 0.1445
R4707 VSS.n949 VSS.n640 0.1445
R4708 VSS.n945 VSS.n640 0.1445
R4709 VSS.n945 VSS.n944 0.1445
R4710 VSS.n944 VSS.n943 0.1445
R4711 VSS.n943 VSS.n644 0.1445
R4712 VSS.n939 VSS.n644 0.1445
R4713 VSS.n939 VSS.n938 0.1445
R4714 VSS.n938 VSS.n937 0.1445
R4715 VSS.n937 VSS.n648 0.1445
R4716 VSS.n933 VSS.n648 0.1445
R4717 VSS.n933 VSS.n932 0.1445
R4718 VSS.n932 VSS.n931 0.1445
R4719 VSS.n931 VSS.n651 0.1445
R4720 VSS.n927 VSS.n651 0.1445
R4721 VSS.n927 VSS.n926 0.1445
R4722 VSS.n926 VSS.n925 0.1445
R4723 VSS.n925 VSS.n655 0.1445
R4724 VSS.n921 VSS.n655 0.1445
R4725 VSS.n921 VSS.n920 0.1445
R4726 VSS.n920 VSS.n919 0.1445
R4727 VSS.n919 VSS.n659 0.1445
R4728 VSS.n915 VSS.n659 0.1445
R4729 VSS.n915 VSS.n914 0.1445
R4730 VSS.n914 VSS.n913 0.1445
R4731 VSS.n913 VSS.n662 0.1445
R4732 VSS.n909 VSS.n662 0.1445
R4733 VSS.n909 VSS.n469 0.1445
R4734 VSS.n1103 VSS.n469 0.1445
R4735 VSS.n1103 VSS.n467 0.1445
R4736 VSS.n1107 VSS.n467 0.1445
R4737 VSS.n1108 VSS.n1107 0.1445
R4738 VSS.n1112 VSS.n1108 0.1445
R4739 VSS.n1112 VSS.n464 0.1445
R4740 VSS.n1116 VSS.n464 0.1445
R4741 VSS.n1116 VSS.n465 0.1445
R4742 VSS.n285 VSS.n279 0.1445
R4743 VSS.n285 VSS.n269 0.1445
R4744 VSS.n297 VSS.n269 0.1445
R4745 VSS.n297 VSS.n267 0.1445
R4746 VSS.n364 VSS.n267 0.1445
R4747 VSS.n364 VSS.n363 0.1445
R4748 VSS.n363 VSS.n362 0.1445
R4749 VSS.n362 VSS.n361 0.1445
R4750 VSS.n361 VSS.n359 0.1445
R4751 VSS.n359 VSS.n358 0.1445
R4752 VSS.n358 VSS.n356 0.1445
R4753 VSS.n356 VSS.n355 0.1445
R4754 VSS.n355 VSS.n353 0.1445
R4755 VSS.n353 VSS.n352 0.1445
R4756 VSS.n352 VSS.n350 0.1445
R4757 VSS.n350 VSS.n349 0.1445
R4758 VSS.n349 VSS.n347 0.1445
R4759 VSS.n347 VSS.n346 0.1445
R4760 VSS.n346 VSS.n344 0.1445
R4761 VSS.n344 VSS.n343 0.1445
R4762 VSS.n343 VSS.n341 0.1445
R4763 VSS.n341 VSS.n340 0.1445
R4764 VSS.n340 VSS.n338 0.1445
R4765 VSS.n338 VSS.n337 0.1445
R4766 VSS.n337 VSS.n335 0.1445
R4767 VSS.n335 VSS.n334 0.1445
R4768 VSS.n334 VSS.n333 0.1445
R4769 VSS.n333 VSS.n332 0.1445
R4770 VSS.n332 VSS.n330 0.1445
R4771 VSS.n330 VSS.n329 0.1445
R4772 VSS.n284 VSS.n283 0.1445
R4773 VSS.n284 VSS.n268 0.1445
R4774 VSS.n298 VSS.n268 0.1445
R4775 VSS.n299 VSS.n298 0.1445
R4776 VSS.n300 VSS.n299 0.1445
R4777 VSS.n301 VSS.n300 0.1445
R4778 VSS.n302 VSS.n301 0.1445
R4779 VSS.n303 VSS.n302 0.1445
R4780 VSS.n304 VSS.n303 0.1445
R4781 VSS.n305 VSS.n304 0.1445
R4782 VSS.n306 VSS.n305 0.1445
R4783 VSS.n307 VSS.n306 0.1445
R4784 VSS.n308 VSS.n307 0.1445
R4785 VSS.n309 VSS.n308 0.1445
R4786 VSS.n310 VSS.n309 0.1445
R4787 VSS.n311 VSS.n310 0.1445
R4788 VSS.n312 VSS.n311 0.1445
R4789 VSS.n313 VSS.n312 0.1445
R4790 VSS.n314 VSS.n313 0.1445
R4791 VSS.n315 VSS.n314 0.1445
R4792 VSS.n316 VSS.n315 0.1445
R4793 VSS.n317 VSS.n316 0.1445
R4794 VSS.n318 VSS.n317 0.1445
R4795 VSS.n319 VSS.n318 0.1445
R4796 VSS.n320 VSS.n319 0.1445
R4797 VSS.n321 VSS.n320 0.1445
R4798 VSS.n322 VSS.n321 0.1445
R4799 VSS.n323 VSS.n322 0.1445
R4800 VSS.n324 VSS.n323 0.1445
R4801 VSS.n328 VSS.n324 0.1445
R4802 VSS.n824 VSS.n695 0.1445
R4803 VSS.n824 VSS.n822 0.1445
R4804 VSS.n822 VSS.n821 0.1445
R4805 VSS.n821 VSS.n819 0.1445
R4806 VSS.n819 VSS.n818 0.1445
R4807 VSS.n818 VSS.n816 0.1445
R4808 VSS.n816 VSS.n815 0.1445
R4809 VSS.n815 VSS.n813 0.1445
R4810 VSS.n813 VSS.n812 0.1445
R4811 VSS.n812 VSS.n810 0.1445
R4812 VSS.n810 VSS.n809 0.1445
R4813 VSS.n809 VSS.n807 0.1445
R4814 VSS.n807 VSS.n806 0.1445
R4815 VSS.n806 VSS.n804 0.1445
R4816 VSS.n804 VSS.n803 0.1445
R4817 VSS.n803 VSS.n801 0.1445
R4818 VSS.n801 VSS.n800 0.1445
R4819 VSS.n800 VSS.n798 0.1445
R4820 VSS.n798 VSS.n797 0.1445
R4821 VSS.n797 VSS.n795 0.1445
R4822 VSS.n795 VSS.n794 0.1445
R4823 VSS.n794 VSS.n792 0.1445
R4824 VSS.n792 VSS.n791 0.1445
R4825 VSS.n791 VSS.n789 0.1445
R4826 VSS.n789 VSS.n788 0.1445
R4827 VSS.n788 VSS.n786 0.1445
R4828 VSS.n786 VSS.n785 0.1445
R4829 VSS.n785 VSS.n783 0.1445
R4830 VSS.n783 VSS.n782 0.1445
R4831 VSS.n782 VSS.n780 0.1445
R4832 VSS.n780 VSS.n665 0.1445
R4833 VSS.n905 VSS.n665 0.1445
R4834 VSS.n905 VSS.n904 0.1445
R4835 VSS.n904 VSS.n903 0.1445
R4836 VSS.n974 VSS.n584 0.1445
R4837 VSS.n978 VSS.n584 0.1445
R4838 VSS.n978 VSS.n570 0.1445
R4839 VSS.n990 VSS.n570 0.1445
R4840 VSS.n990 VSS.n568 0.1445
R4841 VSS.n994 VSS.n568 0.1445
R4842 VSS.n994 VSS.n555 0.1445
R4843 VSS.n1006 VSS.n555 0.1445
R4844 VSS.n1006 VSS.n553 0.1445
R4845 VSS.n1010 VSS.n553 0.1445
R4846 VSS.n1010 VSS.n540 0.1445
R4847 VSS.n1022 VSS.n540 0.1445
R4848 VSS.n1022 VSS.n538 0.1445
R4849 VSS.n1026 VSS.n538 0.1445
R4850 VSS.n1026 VSS.n524 0.1445
R4851 VSS.n1038 VSS.n524 0.1445
R4852 VSS.n1038 VSS.n522 0.1445
R4853 VSS.n1042 VSS.n522 0.1445
R4854 VSS.n1042 VSS.n507 0.1445
R4855 VSS.n1054 VSS.n507 0.1445
R4856 VSS.n1054 VSS.n505 0.1445
R4857 VSS.n1058 VSS.n505 0.1445
R4858 VSS.n1058 VSS.n492 0.1445
R4859 VSS.n1070 VSS.n492 0.1445
R4860 VSS.n1070 VSS.n490 0.1445
R4861 VSS.n1077 VSS.n490 0.1445
R4862 VSS.n1077 VSS.n1076 0.1445
R4863 VSS.n1076 VSS.n476 0.1445
R4864 VSS.n1090 VSS.n476 0.1445
R4865 VSS.n1091 VSS.n1090 0.1445
R4866 VSS.n1093 VSS.n1091 0.1445
R4867 VSS.n1093 VSS.n474 0.1445
R4868 VSS.n1098 VSS.n474 0.1445
R4869 VSS.n1098 VSS.n1097 0.1445
R4870 VSS.n976 VSS.n975 0.1445
R4871 VSS.n977 VSS.n976 0.1445
R4872 VSS.n977 VSS.n569 0.1445
R4873 VSS.n991 VSS.n569 0.1445
R4874 VSS.n992 VSS.n991 0.1445
R4875 VSS.n993 VSS.n992 0.1445
R4876 VSS.n993 VSS.n554 0.1445
R4877 VSS.n1007 VSS.n554 0.1445
R4878 VSS.n1008 VSS.n1007 0.1445
R4879 VSS.n1009 VSS.n1008 0.1445
R4880 VSS.n1009 VSS.n539 0.1445
R4881 VSS.n1023 VSS.n539 0.1445
R4882 VSS.n1024 VSS.n1023 0.1445
R4883 VSS.n1025 VSS.n1024 0.1445
R4884 VSS.n1025 VSS.n523 0.1445
R4885 VSS.n1039 VSS.n523 0.1445
R4886 VSS.n1040 VSS.n1039 0.1445
R4887 VSS.n1041 VSS.n1040 0.1445
R4888 VSS.n1041 VSS.n506 0.1445
R4889 VSS.n1055 VSS.n506 0.1445
R4890 VSS.n1056 VSS.n1055 0.1445
R4891 VSS.n1057 VSS.n1056 0.1445
R4892 VSS.n1057 VSS.n491 0.1445
R4893 VSS.n1071 VSS.n491 0.1445
R4894 VSS.n1072 VSS.n1071 0.1445
R4895 VSS.n1073 VSS.n1072 0.1445
R4896 VSS.n1075 VSS.n1073 0.1445
R4897 VSS.n1075 VSS.n1074 0.1445
R4898 VSS.n1074 VSS.n477 0.1445
R4899 VSS.n477 VSS.n475 0.1445
R4900 VSS.n1094 VSS.n475 0.1445
R4901 VSS.n1095 VSS.n1094 0.1445
R4902 VSS.n1096 VSS.n1095 0.1445
R4903 VSS.n1096 VSS.n445 0.1445
R4904 VSS.n290 VSS.n274 0.1445
R4905 VSS.n291 VSS.n290 0.1445
R4906 VSS.n292 VSS.n291 0.1445
R4907 VSS.n292 VSS.n261 0.1445
R4908 VSS.n370 VSS.n261 0.1445
R4909 VSS.n371 VSS.n370 0.1445
R4910 VSS.n372 VSS.n371 0.1445
R4911 VSS.n372 VSS.n102 0.1445
R4912 VSS.n386 VSS.n102 0.1445
R4913 VSS.n387 VSS.n386 0.1445
R4914 VSS.n388 VSS.n387 0.1445
R4915 VSS.n388 VSS.n85 0.1445
R4916 VSS.n402 VSS.n85 0.1445
R4917 VSS.n403 VSS.n402 0.1445
R4918 VSS.n404 VSS.n403 0.1445
R4919 VSS.n404 VSS.n68 0.1445
R4920 VSS.n418 VSS.n68 0.1445
R4921 VSS.n419 VSS.n418 0.1445
R4922 VSS.n420 VSS.n419 0.1445
R4923 VSS.n420 VSS.n49 0.1445
R4924 VSS.n439 VSS.n49 0.1445
R4925 VSS.n440 VSS.n13 0.1445
R4926 VSS.n14 VSS.n13 0.1445
R4927 VSS.n15 VSS.n14 0.1445
R4928 VSS.n24 VSS.n15 0.1445
R4929 VSS.n25 VSS.n24 0.1445
R4930 VSS.n26 VSS.n25 0.1445
R4931 VSS.n27 VSS.n26 0.1445
R4932 VSS.n325 VSS.n27 0.1445
R4933 VSS.n289 VSS.n275 0.1445
R4934 VSS.n289 VSS.n273 0.1445
R4935 VSS.n293 VSS.n273 0.1445
R4936 VSS.n293 VSS.n262 0.1445
R4937 VSS.n369 VSS.n262 0.1445
R4938 VSS.n369 VSS.n260 0.1445
R4939 VSS.n373 VSS.n260 0.1445
R4940 VSS.n373 VSS.n103 0.1445
R4941 VSS.n385 VSS.n103 0.1445
R4942 VSS.n385 VSS.n101 0.1445
R4943 VSS.n389 VSS.n101 0.1445
R4944 VSS.n389 VSS.n86 0.1445
R4945 VSS.n401 VSS.n86 0.1445
R4946 VSS.n401 VSS.n84 0.1445
R4947 VSS.n405 VSS.n84 0.1445
R4948 VSS.n405 VSS.n69 0.1445
R4949 VSS.n417 VSS.n69 0.1445
R4950 VSS.n417 VSS.n67 0.1445
R4951 VSS.n421 VSS.n67 0.1445
R4952 VSS.n421 VSS.n50 0.1445
R4953 VSS.n438 VSS.n50 0.1445
R4954 VSS.n438 VSS.n12 0.1445
R4955 VSS.n1165 VSS.n12 0.1445
R4956 VSS.n1165 VSS.n1164 0.1445
R4957 VSS.n1164 VSS.n1163 0.1445
R4958 VSS.n1163 VSS.n16 0.1445
R4959 VSS.n1157 VSS.n16 0.1445
R4960 VSS.n1157 VSS.n1156 0.1445
R4961 VSS.n1156 VSS.n1155 0.1445
R4962 VSS.n1155 VSS.n28 0.1445
R4963 VSS.n377 VSS.n109 0.1445
R4964 VSS.n381 VSS.n109 0.1445
R4965 VSS.n381 VSS.n94 0.1445
R4966 VSS.n393 VSS.n94 0.1445
R4967 VSS.n393 VSS.n92 0.1445
R4968 VSS.n397 VSS.n92 0.1445
R4969 VSS.n397 VSS.n78 0.1445
R4970 VSS.n409 VSS.n78 0.1445
R4971 VSS.n409 VSS.n76 0.1445
R4972 VSS.n413 VSS.n76 0.1445
R4973 VSS.n413 VSS.n61 0.1445
R4974 VSS.n425 VSS.n61 0.1445
R4975 VSS.n425 VSS.n59 0.1445
R4976 VSS.n434 VSS.n59 0.1445
R4977 VSS.n434 VSS.n433 0.1445
R4978 VSS.n433 VSS.n432 0.1445
R4979 VSS.n379 VSS.n378 0.1445
R4980 VSS.n380 VSS.n379 0.1445
R4981 VSS.n380 VSS.n93 0.1445
R4982 VSS.n394 VSS.n93 0.1445
R4983 VSS.n395 VSS.n394 0.1445
R4984 VSS.n396 VSS.n395 0.1445
R4985 VSS.n396 VSS.n77 0.1445
R4986 VSS.n410 VSS.n77 0.1445
R4987 VSS.n411 VSS.n410 0.1445
R4988 VSS.n412 VSS.n411 0.1445
R4989 VSS.n412 VSS.n60 0.1445
R4990 VSS.n426 VSS.n60 0.1445
R4991 VSS.n427 VSS.n426 0.1445
R4992 VSS.n428 VSS.n427 0.1445
R4993 VSS.n429 VSS.n428 0.1445
R4994 VSS.n431 VSS.n429 0.1445
R4995 VSS.n255 VSS.n115 0.1445
R4996 VSS.n255 VSS.n254 0.1445
R4997 VSS.n254 VSS.n253 0.1445
R4998 VSS.n253 VSS.n251 0.1445
R4999 VSS.n251 VSS.n250 0.1445
R5000 VSS.n250 VSS.n248 0.1445
R5001 VSS.n248 VSS.n247 0.1445
R5002 VSS.n247 VSS.n245 0.1445
R5003 VSS.n245 VSS.n244 0.1445
R5004 VSS.n244 VSS.n242 0.1445
R5005 VSS.n242 VSS.n241 0.1445
R5006 VSS.n241 VSS.n239 0.1445
R5007 VSS.n239 VSS.n238 0.1445
R5008 VSS.n238 VSS.n236 0.1445
R5009 VSS.n236 VSS.n3 0.1445
R5010 VSS.n1169 VSS.n3 0.1445
R5011 VSS.n622 VSS.n608 0.1445
R5012 VSS.n622 VSS.n606 0.1445
R5013 VSS.n626 VSS.n606 0.1445
R5014 VSS.n626 VSS.n594 0.1445
R5015 VSS.n966 VSS.n594 0.1445
R5016 VSS.n966 VSS.n592 0.1445
R5017 VSS.n970 VSS.n592 0.1445
R5018 VSS.n970 VSS.n579 0.1445
R5019 VSS.n982 VSS.n579 0.1445
R5020 VSS.n982 VSS.n577 0.1445
R5021 VSS.n986 VSS.n577 0.1445
R5022 VSS.n986 VSS.n563 0.1445
R5023 VSS.n998 VSS.n563 0.1445
R5024 VSS.n998 VSS.n561 0.1445
R5025 VSS.n1002 VSS.n561 0.1445
R5026 VSS.n1002 VSS.n548 0.1445
R5027 VSS.n1014 VSS.n548 0.1445
R5028 VSS.n1014 VSS.n546 0.1445
R5029 VSS.n1018 VSS.n546 0.1445
R5030 VSS.n1018 VSS.n531 0.1445
R5031 VSS.n1030 VSS.n531 0.1445
R5032 VSS.n1030 VSS.n529 0.1445
R5033 VSS.n1034 VSS.n529 0.1445
R5034 VSS.n1034 VSS.n516 0.1445
R5035 VSS.n1046 VSS.n516 0.1445
R5036 VSS.n1046 VSS.n514 0.1445
R5037 VSS.n1050 VSS.n514 0.1445
R5038 VSS.n1050 VSS.n499 0.1445
R5039 VSS.n1062 VSS.n499 0.1445
R5040 VSS.n1062 VSS.n497 0.1445
R5041 VSS.n1066 VSS.n497 0.1445
R5042 VSS.n1066 VSS.n485 0.1445
R5043 VSS.n1081 VSS.n485 0.1445
R5044 VSS.n1081 VSS.n483 0.1445
R5045 VSS.n1085 VSS.n483 0.1445
R5046 VSS.n1085 VSS.n40 0.1445
R5047 VSS.n1147 VSS.n40 0.1445
R5048 VSS.n1147 VSS.n41 0.1445
R5049 VSS.n1143 VSS.n41 0.1445
R5050 VSS.n1143 VSS.n1142 0.1445
R5051 VSS.n1142 VSS.n1141 0.1445
R5052 VSS.n1141 VSS.n47 0.1445
R5053 VSS.n1131 VSS.n47 0.1445
R5054 VSS.n1131 VSS.n453 0.1445
R5055 VSS.n1127 VSS.n453 0.1445
R5056 VSS.n1127 VSS.n1126 0.1445
R5057 VSS.n1126 VSS.n1125 0.1445
R5058 VSS.n1125 VSS.n458 0.1445
R5059 VSS.n623 VSS.n607 0.1445
R5060 VSS.n624 VSS.n623 0.1445
R5061 VSS.n625 VSS.n624 0.1445
R5062 VSS.n625 VSS.n593 0.1445
R5063 VSS.n967 VSS.n593 0.1445
R5064 VSS.n968 VSS.n967 0.1445
R5065 VSS.n969 VSS.n968 0.1445
R5066 VSS.n969 VSS.n578 0.1445
R5067 VSS.n983 VSS.n578 0.1445
R5068 VSS.n984 VSS.n983 0.1445
R5069 VSS.n985 VSS.n984 0.1445
R5070 VSS.n985 VSS.n562 0.1445
R5071 VSS.n999 VSS.n562 0.1445
R5072 VSS.n1000 VSS.n999 0.1445
R5073 VSS.n1001 VSS.n1000 0.1445
R5074 VSS.n1001 VSS.n547 0.1445
R5075 VSS.n1015 VSS.n547 0.1445
R5076 VSS.n1016 VSS.n1015 0.1445
R5077 VSS.n1017 VSS.n1016 0.1445
R5078 VSS.n1017 VSS.n530 0.1445
R5079 VSS.n1031 VSS.n530 0.1445
R5080 VSS.n1032 VSS.n1031 0.1445
R5081 VSS.n1033 VSS.n1032 0.1445
R5082 VSS.n1033 VSS.n515 0.1445
R5083 VSS.n1047 VSS.n515 0.1445
R5084 VSS.n1048 VSS.n1047 0.1445
R5085 VSS.n1049 VSS.n1048 0.1445
R5086 VSS.n1049 VSS.n498 0.1445
R5087 VSS.n1063 VSS.n498 0.1445
R5088 VSS.n1064 VSS.n1063 0.1445
R5089 VSS.n1065 VSS.n1064 0.1445
R5090 VSS.n1065 VSS.n484 0.1445
R5091 VSS.n1082 VSS.n484 0.1445
R5092 VSS.n1083 VSS.n1082 0.1445
R5093 VSS.n1084 VSS.n1083 0.1445
R5094 VSS.n1084 VSS.n42 0.1445
R5095 VSS.n1146 VSS.n42 0.1445
R5096 VSS.n1146 VSS.n1145 0.1445
R5097 VSS.n1145 VSS.n1144 0.1445
R5098 VSS.n1144 VSS.n43 0.1445
R5099 VSS.n1140 VSS.n43 0.1445
R5100 VSS.n1130 VSS.n48 0.1445
R5101 VSS.n1130 VSS.n1129 0.1445
R5102 VSS.n1129 VSS.n1128 0.1445
R5103 VSS.n1128 VSS.n454 0.1445
R5104 VSS.n1124 VSS.n454 0.1445
R5105 VSS.n1124 VSS.n1123 0.1445
R5106 VSS.n617 VSS.n616 0.1445
R5107 VSS.n617 VSS.n601 0.1445
R5108 VSS.n631 VSS.n601 0.1445
R5109 VSS.n632 VSS.n631 0.1445
R5110 VSS.n960 VSS.n632 0.1445
R5111 VSS.n960 VSS.n959 0.1445
R5112 VSS.n959 VSS.n958 0.1445
R5113 VSS.n958 VSS.n633 0.1445
R5114 VSS.n954 VSS.n633 0.1445
R5115 VSS.n954 VSS.n953 0.1445
R5116 VSS.n953 VSS.n952 0.1445
R5117 VSS.n952 VSS.n637 0.1445
R5118 VSS.n948 VSS.n637 0.1445
R5119 VSS.n948 VSS.n947 0.1445
R5120 VSS.n947 VSS.n946 0.1445
R5121 VSS.n946 VSS.n641 0.1445
R5122 VSS.n942 VSS.n641 0.1445
R5123 VSS.n942 VSS.n941 0.1445
R5124 VSS.n941 VSS.n940 0.1445
R5125 VSS.n940 VSS.n645 0.1445
R5126 VSS.n936 VSS.n645 0.1445
R5127 VSS.n936 VSS.n935 0.1445
R5128 VSS.n935 VSS.n934 0.1445
R5129 VSS.n934 VSS 0.1445
R5130 VSS.n930 VSS 0.1445
R5131 VSS.n930 VSS.n929 0.1445
R5132 VSS.n929 VSS.n928 0.1445
R5133 VSS.n928 VSS.n652 0.1445
R5134 VSS.n924 VSS.n652 0.1445
R5135 VSS.n924 VSS.n923 0.1445
R5136 VSS.n923 VSS.n922 0.1445
R5137 VSS.n922 VSS.n656 0.1445
R5138 VSS.n918 VSS.n656 0.1445
R5139 VSS.n918 VSS.n917 0.1445
R5140 VSS.n917 VSS.n916 0.1445
R5141 VSS.n916 VSS.n660 0.1445
R5142 VSS.n912 VSS.n660 0.1445
R5143 VSS.n912 VSS.n911 0.1445
R5144 VSS.n911 VSS.n910 0.1445
R5145 VSS.n910 VSS.n468 0.1445
R5146 VSS.n1104 VSS.n468 0.1445
R5147 VSS.n1105 VSS.n1104 0.1445
R5148 VSS.n1106 VSS.n1105 0.1445
R5149 VSS.n1106 VSS.n466 0.1445
R5150 VSS.n1113 VSS.n466 0.1445
R5151 VSS.n1114 VSS.n1113 0.1445
R5152 VSS.n1115 VSS.n1114 0.1445
R5153 VSS.n1115 VSS.n459 0.1445
R5154 VSS.n441 VSS.n439 0.1337
R5155 VSS.n1139 VSS.n48 0.1265
R5156 VSS.n282 VSS.n281 0.111138
R5157 VSS.n327 VSS.n326 0.111138
R5158 VSS.n326 VSS.n32 0.111138
R5159 VSS.n1122 VSS.n1121 0.102461
R5160 VSS.n615 VSS.n614 0.102461
R5161 VSS.n614 VSS.n613 0.102461
R5162 VSS.n827 VSS.n691 0.0737173
R5163 VSS.n694 VSS.n692 0.0727085
R5164 VSS.n897 VSS.n896 0.0613362
R5165 VSS.n831 VSS.n830 0.0613362
R5166 VSS.n669 VSS.n667 0.0609263
R5167 VSS.n900 VSS.n668 0.0537268
R5168 VSS.n898 VSS.n897 0.0440889
R5169 VSS.n830 VSS.n829 0.0440889
R5170 VSS.n669 VSS.n668 0.0413911
R5171 VSS.n692 VSS.n691 0.0299032
R5172 VSS.n229 VSS.n228 0.0272885
R5173 VSS.n195 VSS.n194 0.0272885
R5174 VSS.n231 VSS.n229 0.0249386
R5175 VSS.n194 VSS.n192 0.0249386
R5176 VSS.n826 VSS.n693 0.0239
R5177 VSS.n901 VSS.n444 0.0239
R5178 VSS.n153 VSS.n151 0.0215313
R5179 VSS.n189 VSS.n185 0.0215313
R5180 VSS.n896 VSS.n670 0.0207265
R5181 VSS.n831 VSS.n690 0.0207265
R5182 VSS.n840 VSS.n689 0.0203347
R5183 VSS.n689 VSS.n687 0.0203347
R5184 VSS.n846 VSS.n845 0.0203347
R5185 VSS.n846 VSS.n685 0.0203347
R5186 VSS.n851 VSS.n684 0.0203347
R5187 VSS.n857 VSS.n684 0.0203347
R5188 VSS.n861 VSS.n682 0.0203347
R5189 VSS.n862 VSS.n861 0.0203347
R5190 VSS.n862 VSS.n680 0.0203347
R5191 VSS.n866 VSS.n680 0.0203347
R5192 VSS.n867 VSS.n866 0.0203347
R5193 VSS.n867 VSS.n677 0.0203347
R5194 VSS.n874 VSS.n678 0.0203347
R5195 VSS.n678 VSS.n676 0.0203347
R5196 VSS.n880 VSS.n879 0.0203347
R5197 VSS.n880 VSS.n673 0.0203347
R5198 VSS.n886 VSS.n674 0.0203347
R5199 VSS.n674 VSS.n672 0.0203347
R5200 VSS.n204 VSS.n203 0.0203347
R5201 VSS.n204 VSS.n165 0.0203347
R5202 VSS.n208 VSS.n163 0.0203347
R5203 VSS.n215 VSS.n163 0.0203347
R5204 VSS.n219 VSS.n160 0.0203347
R5205 VSS.n220 VSS.n219 0.0203347
R5206 VSS.n233 VSS.n151 0.019299
R5207 VSS.n228 VSS.n155 0.019299
R5208 VSS.n189 VSS.n188 0.019299
R5209 VSS.n196 VSS.n195 0.019299
R5210 VSS.n234 VSS.n233 0.018594
R5211 VSS.n188 VSS.n187 0.018594
R5212 VSS.n1137 VSS.n444 0.0185
R5213 VSS.n1140 VSS.n1139 0.0185
R5214 VSS.n898 VSS.n668 0.0179042
R5215 VSS.n829 VSS.n691 0.0179042
R5216 VSS.n697 VSS.n696 0.0167896
R5217 VSS.n698 VSS.n697 0.0167896
R5218 VSS.n700 VSS.n699 0.0167896
R5219 VSS.n701 VSS.n700 0.0167896
R5220 VSS.n703 VSS.n702 0.0167896
R5221 VSS.n704 VSS.n703 0.0167896
R5222 VSS.n706 VSS.n705 0.0167896
R5223 VSS.n707 VSS.n706 0.0167896
R5224 VSS.n709 VSS.n708 0.0167896
R5225 VSS.n710 VSS.n709 0.0167896
R5226 VSS.n711 VSS.n710 0.0167896
R5227 VSS.n712 VSS.n711 0.0167896
R5228 VSS.n713 VSS.n712 0.0167896
R5229 VSS.n714 VSS.n713 0.0167896
R5230 VSS.n716 VSS.n715 0.0167896
R5231 VSS.n717 VSS.n716 0.0167896
R5232 VSS.n719 VSS.n718 0.0167896
R5233 VSS.n720 VSS.n719 0.0167896
R5234 VSS.n722 VSS.n721 0.0167896
R5235 VSS.n723 VSS.n722 0.0167896
R5236 VSS.n779 VSS.n778 0.0167896
R5237 VSS.n778 VSS.n666 0.0167896
R5238 VSS.n183 VSS.n116 0.0167896
R5239 VSS.n118 VSS.n117 0.0167896
R5240 VSS.n120 VSS.n119 0.0167896
R5241 VSS.n121 VSS.n120 0.0167896
R5242 VSS.n123 VSS.n122 0.0167896
R5243 VSS.n124 VSS.n123 0.0167896
R5244 VSS.n126 VSS.n125 0.0167896
R5245 VSS.n127 VSS.n126 0.0167896
R5246 VSS.n235 VSS.n128 0.0167896
R5247 VSS.n841 VSS.n840 0.0163678
R5248 VSS.n857 VSS.n856 0.0163678
R5249 VSS.n875 VSS.n874 0.0163678
R5250 VSS.n890 VSS.n672 0.0163678
R5251 VSS.n825 VSS.n694 0.0160769
R5252 VSS.n902 VSS.n667 0.0160769
R5253 VSS.n157 VSS.n155 0.0156567
R5254 VSS.n196 VSS.n168 0.0156567
R5255 VSS.n1171 VSS.n0 0.0155679
R5256 VSS.n826 VSS.n825 0.0141425
R5257 VSS.n902 VSS.n901 0.0141425
R5258 VSS.n184 VSS.n183 0.0141425
R5259 VSS.n1170 VSS.n2 0.0141425
R5260 VSS.n724 VSS.n699 0.0135317
R5261 VSS.n730 VSS.n707 0.0135317
R5262 VSS.n733 VSS.n715 0.0135317
R5263 VSS.n740 VSS.n723 0.0135317
R5264 VSS.n180 VSS.n119 0.0135317
R5265 VSS.n171 VSS.n127 0.0135317
R5266 VSS.n894 VSS.n670 0.0132003
R5267 VSS.n833 VSS.n690 0.0132003
R5268 VSS.n845 VSS.n844 0.0124008
R5269 VSS.n852 VSS.n685 0.0124008
R5270 VSS.n879 VSS.n878 0.0124008
R5271 VSS.n887 VSS.n673 0.0124008
R5272 VSS.n209 VSS.n208 0.0124008
R5273 VSS.n215 VSS.n214 0.0124008
R5274 VSS.n441 VSS.n440 0.0113
R5275 VSS.n726 VSS.n702 0.0102738
R5276 VSS.n728 VSS.n704 0.0102738
R5277 VSS.n735 VSS.n718 0.0102738
R5278 VSS.n737 VSS.n720 0.0102738
R5279 VSS.n177 VSS.n122 0.0102738
R5280 VSS.n174 VSS.n124 0.0102738
R5281 VSS.n226 VSS.n157 0.010017
R5282 VSS.n200 VSS.n168 0.010017
R5283 VSS.n187 VSS.n116 0.00956109
R5284 VSS.n234 VSS.n0 0.00956109
R5285 VSS.n844 VSS.n687 0.00843388
R5286 VSS.n852 VSS.n851 0.00843388
R5287 VSS.n878 VSS.n676 0.00843388
R5288 VSS.n887 VSS.n886 0.00843388
R5289 VSS.n209 VSS.n165 0.00843388
R5290 VSS.n214 VSS.n160 0.00843388
R5291 VSS.n187 VSS.n117 0.00772851
R5292 VSS.n235 VSS.n234 0.00772851
R5293 VSS.n726 VSS.n701 0.00701584
R5294 VSS.n728 VSS.n705 0.00701584
R5295 VSS.n735 VSS.n717 0.00701584
R5296 VSS.n737 VSS.n721 0.00701584
R5297 VSS.n177 VSS.n121 0.00701584
R5298 VSS.n174 VSS.n125 0.00701584
R5299 VSS.n690 VSS.n688 0.00545868
R5300 VSS.n891 VSS.n670 0.00545868
R5301 VSS.n841 VSS.n688 0.00446694
R5302 VSS.n856 VSS.n682 0.00446694
R5303 VSS.n875 VSS.n677 0.00446694
R5304 VSS.n891 VSS.n890 0.00446694
R5305 VSS.n231 VSS.n153 0.0041423
R5306 VSS.n192 VSS.n185 0.0041423
R5307 VSS.n724 VSS.n698 0.00375792
R5308 VSS.n730 VSS.n708 0.00375792
R5309 VSS.n733 VSS.n714 0.00375792
R5310 VSS.n779 VSS.n740 0.00375792
R5311 VSS.n180 VSS.n118 0.00375792
R5312 VSS.n171 VSS.n128 0.00375792
R5313 VSS.n1171 VSS.n1170 0.00172172
R5314 VSS.n203 VSS.n168 0.00149173
R5315 VSS.n220 VSS.n157 0.00149173
R5316 VSS.n696 VSS.n694 0.00121267
R5317 VSS.n667 VSS.n666 0.00121267
C0 a_190_n489# VDD 1.66941f
C1 VDD VT 1.82314f
C2 Isum a_4290_5135# 1.18044f
C3 VDD Vthr 1.35931f
C4 Iout a_4290_5135# 4.95826f
C5 VDD Isum 8.01483f
C6 a_190_n489# a_4290_5135# 8.60086f
C7 VDD a_4290_5135# 2.4634f
C8 Vthr VSS 7.60214f
C9 Iout VSS 10.64746f
C10 VT VSS 2.17559f
C11 Isum VSS 22.14378f
C12 VDD VSS 80.56086f
C13 a_190_n489# VSS 15.276f
C14 a_4290_5135# VSS 18.1674f
C15 VDD.t36 VSS 8.76552f
C16 Isum.n74 VSS 0.88245f
C17 Isum.n340 VSS 1.79833f
C18 VT.t0 VSS 6.46118f
C19 Iout.t0 VSS 0.98802f
.ends
