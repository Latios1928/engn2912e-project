* LVS reference for DPI_inh.gds (glayout_floorplan.two_row)
* note: ground net GND drawn as VSS
.subckt DPI_inh Vthr VT Isum VDD Iout VSS
Xx1_M1 VDD Vthr Isum Isum nfet_03v3 L=5.12u W=4u nf=1
Xx1_M2 x1_net1 x1_net1 Isum Isum nfet_03v3 L=5.12u W=4u nf=1
XMi1 Im Im VSS VSS nfet_03v3 L=8u W=2u nf=1
XMi2 Iout Im VSS VSS nfet_03v3 L=8u W=2.4u nf=1
Xx1_M3 x1_net1 VT VDD VDD pfet_03v3 L=5.12u W=4u nf=1
Xx1_M4 Im x1_net1 VDD VDD pfet_03v3 L=5.12u W=4u nf=1
XCx1_C2 VDD x1_net1 cap_mim_2f0fF c_width=22.18e-6 c_length=22.18e-6 m=1
XDNN0 VSS VSS VSS VSS nfet_03v3 L=2u W=0.5u nf=1
XDNN1 VSS VSS VSS VSS nfet_03v3 L=2u W=0.5u nf=1
XDNN2 VSS VSS VSS VSS nfet_03v3 L=2u W=0.5u nf=1
XDNN3 VSS VSS VSS VSS nfet_03v3 L=2u W=0.5u nf=1
XDNN4 VSS VSS VSS VSS nfet_03v3 L=2u W=0.5u nf=1
XDNN5 VSS VSS VSS VSS nfet_03v3 L=2u W=0.5u nf=1
XDNN6 VSS VSS VSS VSS nfet_03v3 L=2u W=0.5u nf=1
XDNN7 VSS VSS VSS VSS nfet_03v3 L=2u W=0.5u nf=1
XDNN8 VSS VSS VSS VSS nfet_03v3 L=2u W=0.5u nf=1
XDNN9 VSS VSS VSS VSS nfet_03v3 L=2u W=0.5u nf=1
XDNS0 VSS VSS VSS VSS nfet_03v3 L=2u W=0.5u nf=1
XDNS1 VSS VSS VSS VSS nfet_03v3 L=2u W=0.5u nf=1
XDNS2 VSS VSS VSS VSS nfet_03v3 L=2u W=0.5u nf=1
XDNS3 VSS VSS VSS VSS nfet_03v3 L=2u W=0.5u nf=1
XDNS4 VSS VSS VSS VSS nfet_03v3 L=2u W=0.5u nf=1
XDNS5 VSS VSS VSS VSS nfet_03v3 L=2u W=0.5u nf=1
XDNS6 VSS VSS VSS VSS nfet_03v3 L=2u W=0.5u nf=1
XDNS7 VSS VSS VSS VSS nfet_03v3 L=2u W=0.5u nf=1
XDNS8 VSS VSS VSS VSS nfet_03v3 L=2u W=0.5u nf=1
XDNS9 VSS VSS VSS VSS nfet_03v3 L=2u W=0.5u nf=1
XDNW0 VSS VSS VSS VSS nfet_03v3 L=2u W=2.4u nf=1
XDNE0 VSS VSS VSS VSS nfet_03v3 L=2u W=2.4u nf=1
XDNI1N0 Isum Isum Isum Isum nfet_03v3 L=2u W=0.5u nf=1
XDNI1N1 Isum Isum Isum Isum nfet_03v3 L=2u W=0.5u nf=1
XDNI1N2 Isum Isum Isum Isum nfet_03v3 L=2u W=0.5u nf=1
XDNI1N3 Isum Isum Isum Isum nfet_03v3 L=2u W=0.5u nf=1
XDNI1N4 Isum Isum Isum Isum nfet_03v3 L=2u W=0.5u nf=1
XDNI1N5 Isum Isum Isum Isum nfet_03v3 L=2u W=0.5u nf=1
XDNI1N6 Isum Isum Isum Isum nfet_03v3 L=2u W=0.5u nf=1
XDNI1N7 Isum Isum Isum Isum nfet_03v3 L=2u W=0.5u nf=1
XDNI1S0 Isum Isum Isum Isum nfet_03v3 L=2u W=0.5u nf=1
XDNI1S1 Isum Isum Isum Isum nfet_03v3 L=2u W=0.5u nf=1
XDNI1S2 Isum Isum Isum Isum nfet_03v3 L=2u W=0.5u nf=1
XDNI1S3 Isum Isum Isum Isum nfet_03v3 L=2u W=0.5u nf=1
XDNI1S4 Isum Isum Isum Isum nfet_03v3 L=2u W=0.5u nf=1
XDNI1S5 Isum Isum Isum Isum nfet_03v3 L=2u W=0.5u nf=1
XDNI1S6 Isum Isum Isum Isum nfet_03v3 L=2u W=0.5u nf=1
XDNI1S7 Isum Isum Isum Isum nfet_03v3 L=2u W=0.5u nf=1
XDNI1W0 Isum Isum Isum Isum nfet_03v3 L=2u W=4u nf=1
XDNI1E0 Isum Isum Isum Isum nfet_03v3 L=2u W=4u nf=1
XDPN0 VDD VDD VDD VDD pfet_03v3 L=2u W=0.5u nf=1
XDPN1 VDD VDD VDD VDD pfet_03v3 L=2u W=0.5u nf=1
XDPN2 VDD VDD VDD VDD pfet_03v3 L=2u W=0.5u nf=1
XDPN3 VDD VDD VDD VDD pfet_03v3 L=2u W=0.5u nf=1
XDPN4 VDD VDD VDD VDD pfet_03v3 L=2u W=0.5u nf=1
XDPN5 VDD VDD VDD VDD pfet_03v3 L=2u W=0.5u nf=1
XDPN6 VDD VDD VDD VDD pfet_03v3 L=2u W=0.5u nf=1
XDPN7 VDD VDD VDD VDD pfet_03v3 L=2u W=0.5u nf=1
XDPS0 VDD VDD VDD VDD pfet_03v3 L=2u W=0.5u nf=1
XDPS1 VDD VDD VDD VDD pfet_03v3 L=2u W=0.5u nf=1
XDPS2 VDD VDD VDD VDD pfet_03v3 L=2u W=0.5u nf=1
XDPS3 VDD VDD VDD VDD pfet_03v3 L=2u W=0.5u nf=1
XDPS4 VDD VDD VDD VDD pfet_03v3 L=2u W=0.5u nf=1
XDPS5 VDD VDD VDD VDD pfet_03v3 L=2u W=0.5u nf=1
XDPS6 VDD VDD VDD VDD pfet_03v3 L=2u W=0.5u nf=1
XDPS7 VDD VDD VDD VDD pfet_03v3 L=2u W=0.5u nf=1
XDPW0 VDD VDD VDD VDD pfet_03v3 L=2u W=4u nf=1
XDPE0 VDD VDD VDD VDD pfet_03v3 L=2u W=4u nf=1
Cpred_Im Im VSS 3.7e-14
Cpred_Iout Iout VSS 1.883e-14
Cpred_Isum Isum VSS 3.392e-14
Cpred_VT VT VSS 1.22e-14
Cpred_Vthr Vthr VSS 1.058e-14
Cpred_x1_net1 x1_net1 VSS 9.362e-14
.ends
