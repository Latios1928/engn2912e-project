* Extracted by KLayout with GF180MCU LVS runset on : 18/11/2026 23:25

.SUBCKT DPI_inh
M$1 VDD VDD VDD VDD pfet_03v3 L=2U W=4U AS=2.4P AD=2.4P PS=9.2U PD=9.2U
M$2 VDD VDD VDD VDD pfet_03v3 L=2U W=4U AS=2.4P AD=2.4P PS=9.2U PD=9.2U
M$3 VDD VDD VDD VDD pfet_03v3 L=2U W=0.5U AS=0.3P AD=0.14P PS=2.2U PD=1.06U
M$4 VDD VDD VDD VDD pfet_03v3 L=2U W=0.5U AS=0.14P AD=0.14P PS=1.06U PD=1.06U
M$5 VDD VDD VDD VDD pfet_03v3 L=2U W=0.5U AS=0.14P AD=0.14P PS=1.06U PD=1.06U
M$6 VDD VDD VDD VDD pfet_03v3 L=2U W=0.5U AS=0.14P AD=0.14P PS=1.06U PD=1.06U
M$7 VDD VDD VDD VDD pfet_03v3 L=2U W=0.5U AS=0.14P AD=0.14P PS=1.06U PD=1.06U
M$8 VDD VDD VDD VDD pfet_03v3 L=2U W=0.5U AS=0.14P AD=0.14P PS=1.06U PD=1.06U
M$9 VDD VDD VDD VDD pfet_03v3 L=2U W=0.5U AS=0.14P AD=0.14P PS=1.06U PD=1.06U
M$10 VDD VDD VDD VDD pfet_03v3 L=2U W=0.5U AS=0.14P AD=0.3P PS=1.06U PD=2.2U
M$11 VDD VT \$179 VDD pfet_03v3 L=5.12U W=4U AS=2.4P AD=2.4P PS=9.2U PD=9.2U
M$12 VDD VDD VDD VDD pfet_03v3 L=2U W=0.5U AS=0.3P AD=0.14P PS=2.2U PD=1.06U
M$13 VDD VDD VDD VDD pfet_03v3 L=2U W=0.5U AS=0.14P AD=0.14P PS=1.06U PD=1.06U
M$14 VDD VDD VDD VDD pfet_03v3 L=2U W=0.5U AS=0.14P AD=0.14P PS=1.06U PD=1.06U
M$15 VDD VDD VDD VDD pfet_03v3 L=2U W=0.5U AS=0.14P AD=0.14P PS=1.06U PD=1.06U
M$16 VDD VDD VDD VDD pfet_03v3 L=2U W=0.5U AS=0.14P AD=0.14P PS=1.06U PD=1.06U
M$17 VDD VDD VDD VDD pfet_03v3 L=2U W=0.5U AS=0.14P AD=0.14P PS=1.06U PD=1.06U
M$18 VDD VDD VDD VDD pfet_03v3 L=2U W=0.5U AS=0.14P AD=0.14P PS=1.06U PD=1.06U
M$19 VDD VDD VDD VDD pfet_03v3 L=2U W=0.5U AS=0.14P AD=0.3P PS=1.06U PD=2.2U
M$20 VDD \$179 \$211 VDD pfet_03v3 L=5.12U W=4U AS=2.4P AD=2.4P PS=9.2U PD=9.2U
M$21 Isum Isum Isum Isum nfet_03v3 L=2U W=0.5U AS=0.3P AD=0.14P PS=2.2U PD=1.06U
M$22 Isum Isum Isum Isum nfet_03v3 L=2U W=0.5U AS=0.14P AD=0.14P PS=1.06U
+ PD=1.06U
M$23 Isum Isum Isum Isum nfet_03v3 L=2U W=0.5U AS=0.14P AD=0.14P PS=1.06U
+ PD=1.06U
M$24 Isum Isum Isum Isum nfet_03v3 L=2U W=0.5U AS=0.14P AD=0.14P PS=1.06U
+ PD=1.06U
M$25 Isum Isum Isum Isum nfet_03v3 L=2U W=0.5U AS=0.14P AD=0.14P PS=1.06U
+ PD=1.06U
M$26 Isum Isum Isum Isum nfet_03v3 L=2U W=0.5U AS=0.14P AD=0.14P PS=1.06U
+ PD=1.06U
M$27 Isum Isum Isum Isum nfet_03v3 L=2U W=0.5U AS=0.14P AD=0.14P PS=1.06U
+ PD=1.06U
M$28 Isum Isum Isum Isum nfet_03v3 L=2U W=0.5U AS=0.14P AD=0.3P PS=1.06U PD=2.2U
M$29 VSS VSS VSS VSS nfet_03v3 L=2U W=0.5U AS=0.3P AD=0.14P PS=2.2U PD=1.06U
M$30 VSS VSS VSS VSS nfet_03v3 L=2U W=0.5U AS=0.14P AD=0.14P PS=1.06U PD=1.06U
M$31 VSS VSS VSS VSS nfet_03v3 L=2U W=0.5U AS=0.14P AD=0.14P PS=1.06U PD=1.06U
M$32 VSS VSS VSS VSS nfet_03v3 L=2U W=0.5U AS=0.14P AD=0.14P PS=1.06U PD=1.06U
M$33 VSS VSS VSS VSS nfet_03v3 L=2U W=0.5U AS=0.14P AD=0.14P PS=1.06U PD=1.06U
M$34 VSS VSS VSS VSS nfet_03v3 L=2U W=0.5U AS=0.14P AD=0.14P PS=1.06U PD=1.06U
M$35 VSS VSS VSS VSS nfet_03v3 L=2U W=0.5U AS=0.14P AD=0.14P PS=1.06U PD=1.06U
M$36 VSS VSS VSS VSS nfet_03v3 L=2U W=0.5U AS=0.14P AD=0.14P PS=1.06U PD=1.06U
M$37 VSS VSS VSS VSS nfet_03v3 L=2U W=0.5U AS=0.14P AD=0.14P PS=1.06U PD=1.06U
M$38 VSS VSS VSS VSS nfet_03v3 L=2U W=0.5U AS=0.14P AD=0.3P PS=1.06U PD=2.2U
M$39 Isum Isum Isum Isum nfet_03v3 L=2U W=4U AS=2.4P AD=2.4P PS=9.2U PD=9.2U
M$40 \$179 \$179 Isum Isum nfet_03v3 L=5.12U W=4U AS=2.4P AD=2.4P PS=9.2U
+ PD=9.2U
M$41 VDD Vthr Isum Isum nfet_03v3 L=5.12U W=4U AS=2.4P AD=2.4P PS=9.2U PD=9.2U
M$42 Isum Isum Isum Isum nfet_03v3 L=2U W=4U AS=2.4P AD=2.4P PS=9.2U PD=9.2U
M$43 VSS VSS VSS VSS nfet_03v3 L=2U W=0.5U AS=0.3P AD=0.14P PS=2.2U PD=1.06U
M$44 VSS VSS VSS VSS nfet_03v3 L=2U W=0.5U AS=0.14P AD=0.14P PS=1.06U PD=1.06U
M$45 VSS VSS VSS VSS nfet_03v3 L=2U W=0.5U AS=0.14P AD=0.14P PS=1.06U PD=1.06U
M$46 VSS VSS VSS VSS nfet_03v3 L=2U W=0.5U AS=0.14P AD=0.14P PS=1.06U PD=1.06U
M$47 VSS VSS VSS VSS nfet_03v3 L=2U W=0.5U AS=0.14P AD=0.14P PS=1.06U PD=1.06U
M$48 VSS VSS VSS VSS nfet_03v3 L=2U W=0.5U AS=0.14P AD=0.14P PS=1.06U PD=1.06U
M$49 VSS VSS VSS VSS nfet_03v3 L=2U W=0.5U AS=0.14P AD=0.14P PS=1.06U PD=1.06U
M$50 VSS VSS VSS VSS nfet_03v3 L=2U W=0.5U AS=0.14P AD=0.14P PS=1.06U PD=1.06U
M$51 VSS VSS VSS VSS nfet_03v3 L=2U W=0.5U AS=0.14P AD=0.14P PS=1.06U PD=1.06U
M$52 VSS VSS VSS VSS nfet_03v3 L=2U W=0.5U AS=0.14P AD=0.3P PS=1.06U PD=2.2U
M$53 Iout \$211 VSS VSS nfet_03v3 L=8U W=2.4U AS=1.44P AD=1.44P PS=6U PD=6U
M$54 Isum Isum Isum Isum nfet_03v3 L=2U W=0.5U AS=0.3P AD=0.14P PS=2.2U PD=1.06U
M$55 Isum Isum Isum Isum nfet_03v3 L=2U W=0.5U AS=0.14P AD=0.14P PS=1.06U
+ PD=1.06U
M$56 Isum Isum Isum Isum nfet_03v3 L=2U W=0.5U AS=0.14P AD=0.14P PS=1.06U
+ PD=1.06U
M$57 Isum Isum Isum Isum nfet_03v3 L=2U W=0.5U AS=0.14P AD=0.14P PS=1.06U
+ PD=1.06U
M$58 Isum Isum Isum Isum nfet_03v3 L=2U W=0.5U AS=0.14P AD=0.14P PS=1.06U
+ PD=1.06U
M$59 Isum Isum Isum Isum nfet_03v3 L=2U W=0.5U AS=0.14P AD=0.14P PS=1.06U
+ PD=1.06U
M$60 Isum Isum Isum Isum nfet_03v3 L=2U W=0.5U AS=0.14P AD=0.14P PS=1.06U
+ PD=1.06U
M$61 Isum Isum Isum Isum nfet_03v3 L=2U W=0.5U AS=0.14P AD=0.3P PS=1.06U PD=2.2U
M$62 VSS VSS VSS VSS nfet_03v3 L=2U W=2.4U AS=1.44P AD=1.44P PS=6U PD=6U
M$63 VSS VSS VSS VSS nfet_03v3 L=2U W=2.4U AS=1.44P AD=1.44P PS=6U PD=6U
M$64 \$211 \$211 VSS VSS nfet_03v3 L=8U W=2U AS=1.2P AD=1.2P PS=5.2U PD=5.2U
C$65 \$179 VDD 9.839048e-13 cap_mim_2f0fF A=491.9524P P=88.72U
.ENDS DPI_inh
