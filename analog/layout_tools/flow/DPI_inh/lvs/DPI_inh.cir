* Extracted by KLayout with GF180MCU LVS runset on : 18/11/2026 08:23

.SUBCKT DPI_inh Iout Isum VDD VSS VT Vthr
M$1 VDD VDD VDD VDD pfet_03v3 L=2U W=0.5U AS=0.3P AD=0.14P PS=2.2U PD=1.06U
M$2 VDD VDD VDD VDD pfet_03v3 L=2U W=0.5U AS=0.14P AD=0.14P PS=1.06U PD=1.06U
M$3 VDD VDD VDD VDD pfet_03v3 L=2U W=0.5U AS=0.14P AD=0.14P PS=1.06U PD=1.06U
M$4 VDD VDD VDD VDD pfet_03v3 L=2U W=0.5U AS=0.14P AD=0.14P PS=1.06U PD=1.06U
M$5 VDD VDD VDD VDD pfet_03v3 L=2U W=0.5U AS=0.14P AD=0.3P PS=1.06U PD=2.2U
M$6 VDD \$1 \$6 VDD pfet_03v3 L=0.64U W=0.5U AS=0.3P AD=0.3P PS=2.2U PD=2.2U
M$7 VDD VDD VDD VDD pfet_03v3 L=2U W=0.5U AS=0.3P AD=0.3P PS=2.2U PD=2.2U
M$8 VDD VT \$1 VDD pfet_03v3 L=0.64U W=0.5U AS=0.3P AD=0.3P PS=2.2U PD=2.2U
M$9 VDD VDD VDD VDD pfet_03v3 L=2U W=0.5U AS=0.3P AD=0.14P PS=2.2U PD=1.06U
M$10 VDD VDD VDD VDD pfet_03v3 L=2U W=0.5U AS=0.14P AD=0.14P PS=1.06U PD=1.06U
M$11 VDD VDD VDD VDD pfet_03v3 L=2U W=0.5U AS=0.14P AD=0.14P PS=1.06U PD=1.06U
M$12 VDD VDD VDD VDD pfet_03v3 L=2U W=0.5U AS=0.14P AD=0.14P PS=1.06U PD=1.06U
M$13 VDD VDD VDD VDD pfet_03v3 L=2U W=0.5U AS=0.14P AD=0.3P PS=1.06U PD=2.2U
M$14 VDD VDD VDD VDD pfet_03v3 L=2U W=0.5U AS=0.3P AD=0.3P PS=2.2U PD=2.2U
M$15 VSS VSS VSS VSS nfet_03v3 L=2U W=0.5U AS=0.3P AD=0.14P PS=2.2U PD=1.06U
M$16 VSS VSS VSS VSS nfet_03v3 L=2U W=0.5U AS=0.14P AD=0.14P PS=1.06U PD=1.06U
M$17 VSS VSS VSS VSS nfet_03v3 L=2U W=0.5U AS=0.14P AD=0.14P PS=1.06U PD=1.06U
M$18 VSS VSS VSS VSS nfet_03v3 L=2U W=0.5U AS=0.14P AD=0.14P PS=1.06U PD=1.06U
M$19 VSS VSS VSS VSS nfet_03v3 L=2U W=0.5U AS=0.14P AD=0.14P PS=1.06U PD=1.06U
M$20 VSS VSS VSS VSS nfet_03v3 L=2U W=0.5U AS=0.14P AD=0.14P PS=1.06U PD=1.06U
M$21 VSS VSS VSS VSS nfet_03v3 L=2U W=0.5U AS=0.14P AD=0.14P PS=1.06U PD=1.06U
M$22 VSS VSS VSS VSS nfet_03v3 L=2U W=0.5U AS=0.14P AD=0.14P PS=1.06U PD=1.06U
M$23 VSS VSS VSS VSS nfet_03v3 L=2U W=0.5U AS=0.14P AD=0.14P PS=1.06U PD=1.06U
M$24 VSS VSS VSS VSS nfet_03v3 L=2U W=0.5U AS=0.14P AD=0.3P PS=1.06U PD=2.2U
M$25 Isum Isum Isum Isum nfet_03v3 L=2U W=0.5U AS=0.3P AD=0.14P PS=2.2U PD=1.06U
M$26 Isum Isum Isum Isum nfet_03v3 L=2U W=0.5U AS=0.14P AD=0.14P PS=1.06U
+ PD=1.06U
M$27 Isum Isum Isum Isum nfet_03v3 L=2U W=0.5U AS=0.14P AD=0.14P PS=1.06U
+ PD=1.06U
M$28 Isum Isum Isum Isum nfet_03v3 L=2U W=0.5U AS=0.14P AD=0.14P PS=1.06U
+ PD=1.06U
M$29 Isum Isum Isum Isum nfet_03v3 L=2U W=0.5U AS=0.14P AD=0.3P PS=1.06U PD=2.2U
M$30 VSS VSS VSS VSS nfet_03v3 L=2U W=2.4U AS=1.44P AD=1.44P PS=6U PD=6U
M$31 Iout \$6 VSS VSS nfet_03v3 L=8U W=2.4U AS=1.44P AD=1.44P PS=6U PD=6U
M$32 Isum Isum Isum Isum nfet_03v3 L=2U W=0.5U AS=0.3P AD=0.14P PS=2.2U PD=1.06U
M$33 Isum Isum Isum Isum nfet_03v3 L=2U W=0.5U AS=0.14P AD=0.14P PS=1.06U
+ PD=1.06U
M$34 Isum Isum Isum Isum nfet_03v3 L=2U W=0.5U AS=0.14P AD=0.14P PS=1.06U
+ PD=1.06U
M$35 Isum Isum Isum Isum nfet_03v3 L=2U W=0.5U AS=0.14P AD=0.14P PS=1.06U
+ PD=1.06U
M$36 Isum Isum Isum Isum nfet_03v3 L=2U W=0.5U AS=0.14P AD=0.3P PS=1.06U PD=2.2U
M$37 Isum Isum Isum Isum nfet_03v3 L=2U W=0.5U AS=0.3P AD=0.3P PS=2.2U PD=2.2U
M$38 VSS VSS VSS VSS nfet_03v3 L=2U W=2.4U AS=1.44P AD=1.44P PS=6U PD=6U
M$39 VSS VSS VSS VSS nfet_03v3 L=2U W=0.5U AS=0.3P AD=0.14P PS=2.2U PD=1.06U
M$40 VSS VSS VSS VSS nfet_03v3 L=2U W=0.5U AS=0.14P AD=0.14P PS=1.06U PD=1.06U
M$41 VSS VSS VSS VSS nfet_03v3 L=2U W=0.5U AS=0.14P AD=0.14P PS=1.06U PD=1.06U
M$42 VSS VSS VSS VSS nfet_03v3 L=2U W=0.5U AS=0.14P AD=0.14P PS=1.06U PD=1.06U
M$43 VSS VSS VSS VSS nfet_03v3 L=2U W=0.5U AS=0.14P AD=0.14P PS=1.06U PD=1.06U
M$44 VSS VSS VSS VSS nfet_03v3 L=2U W=0.5U AS=0.14P AD=0.14P PS=1.06U PD=1.06U
M$45 VSS VSS VSS VSS nfet_03v3 L=2U W=0.5U AS=0.14P AD=0.14P PS=1.06U PD=1.06U
M$46 VSS VSS VSS VSS nfet_03v3 L=2U W=0.5U AS=0.14P AD=0.14P PS=1.06U PD=1.06U
M$47 VSS VSS VSS VSS nfet_03v3 L=2U W=0.5U AS=0.14P AD=0.14P PS=1.06U PD=1.06U
M$48 VSS VSS VSS VSS nfet_03v3 L=2U W=0.5U AS=0.14P AD=0.3P PS=1.06U PD=2.2U
M$49 VDD Vthr Isum Isum nfet_03v3 L=0.64U W=0.5U AS=0.3P AD=0.3P PS=2.2U PD=2.2U
M$50 \$1 \$1 Isum Isum nfet_03v3 L=0.64U W=0.5U AS=0.3P AD=0.3P PS=2.2U PD=2.2U
M$51 Isum Isum Isum Isum nfet_03v3 L=2U W=0.5U AS=0.3P AD=0.3P PS=2.2U PD=2.2U
M$52 \$6 \$6 VSS VSS nfet_03v3 L=8U W=2U AS=1.2P AD=1.2P PS=5.2U PD=5.2U
C$53 \$1 VDD 9.839048e-13 cap_mim_2f0fF A=491.9524P P=88.72U
.ENDS DPI_inh
