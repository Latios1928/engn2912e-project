* NGSPICE file created from DPI_inh_flat.ext - technology: gf180mcuD

.subckt DPI_inh_flat Vthr Isum Iout VT VSS VDD
X0 VSS.t39 VSS.t36 VSS.t38 VSS.t37 nfet_03v3 ad=0.14p pd=1.06u as=0 ps=0 w=0.5u l=2u
X1 Isum Isum Isum Isum nfet_03v3 ad=0.14p pd=1.06u as=5.24p ps=38.96u w=0.5u l=2u
X2 VSS.t7 VSS.t4 VSS.t6 VSS.t5 nfet_03v3 ad=0.14p pd=1.06u as=0 ps=0 w=0.5u l=2u
X3 VDD Vthr Isum Isum nfet_03v3 ad=0.3p pd=2.2u as=0.3p ps=2.2u w=0.5u l=0.64u
X4 VDD a_4290_5175# cap_mim_2f0_m4m5_noshield c_width=22.18u c_length=22.18u
X5 VDD VDD VDD VDD pfet_03v3 ad=0.3p pd=2.2u as=5.24p ps=38.96u w=0.5u l=2u
X6 VSS.t31 VSS.t28 VSS.t30 VSS.t29 nfet_03v3 ad=0.14p pd=1.06u as=0 ps=0 w=0.5u l=2u
X7 VSS.t77 VSS.t75 VSS.t76 VSS.t37 nfet_03v3 ad=0.14p pd=1.06u as=0 ps=0 w=0.5u l=2u
X8 VSS.t3 VSS.t0 VSS.t2 VSS.t1 nfet_03v3 ad=0.3p pd=2.2u as=0 ps=0 w=0.5u l=2u
X9 VSS.t59 VSS.t57 VSS.t58 VSS.t13 nfet_03v3 ad=0.14p pd=1.06u as=0 ps=0 w=0.5u l=2u
X10 Isum Isum Isum Isum nfet_03v3 ad=0.14p pd=1.06u as=0 ps=0 w=0.5u l=2u
X11 VDD VDD VDD VDD pfet_03v3 ad=0.14p pd=1.06u as=0 ps=0 w=0.5u l=2u
X12 VDD VDD VDD VDD pfet_03v3 ad=0.14p pd=1.06u as=0 ps=0 w=0.5u l=2u
X13 VSS.t11 VSS.t8 VSS.t10 VSS.t9 nfet_03v3 ad=0.14p pd=1.06u as=0 ps=0 w=0.5u l=2u
X14 VSS.t47 VSS.t44 VSS.t46 VSS.t45 nfet_03v3 ad=1.44p pd=6u as=0 ps=0 w=2.4u l=2u
X15 Isum Isum Isum Isum nfet_03v3 ad=0.14p pd=1.06u as=0 ps=0 w=0.5u l=2u
X16 a_4290_5175# a_4290_5175# Isum Isum nfet_03v3 ad=0.3p pd=2.2u as=0.3p ps=2.2u w=0.5u l=0.64u
X17 Isum Isum Isum Isum nfet_03v3 ad=0.14p pd=1.06u as=0 ps=0 w=0.5u l=2u
X18 VDD VDD VDD VDD pfet_03v3 ad=0.14p pd=1.06u as=0 ps=0 w=0.5u l=2u
X19 VDD VDD VDD VDD pfet_03v3 ad=0.14p pd=1.06u as=0 ps=0 w=0.5u l=2u
X20 VSS.t65 VSS.t63 VSS.t64 VSS.t21 nfet_03v3 ad=0.14p pd=1.06u as=0 ps=0 w=0.5u l=2u
X21 Iout a_190_n489# VSS.t79 VSS.t78 nfet_03v3 ad=1.44p pd=6u as=1.44p ps=6u w=2.4u l=8u
X22 VSS.t68 VSS.t66 VSS.t67 VSS.t25 nfet_03v3 ad=0.14p pd=1.06u as=0 ps=0 w=0.5u l=2u
X23 VSS.t19 VSS.t16 VSS.t18 VSS.t17 nfet_03v3 ad=0.14p pd=1.06u as=0 ps=0 w=0.5u l=2u
X24 VSS.t74 VSS.t72 VSS.t73 VSS.t33 nfet_03v3 ad=0.14p pd=1.06u as=0 ps=0 w=0.5u l=2u
X25 Isum Isum Isum Isum nfet_03v3 ad=0.14p pd=1.06u as=0 ps=0 w=0.5u l=2u
X26 VSS.t43 VSS.t40 VSS.t42 VSS.t41 nfet_03v3 ad=1.44p pd=6u as=0 ps=0 w=2.4u l=2u
X27 VSS.t53 VSS.t51 VSS.t52 VSS.t5 nfet_03v3 ad=0.14p pd=1.06u as=0 ps=0 w=0.5u l=2u
X28 Isum Isum Isum Isum nfet_03v3 ad=0.14p pd=1.06u as=0 ps=0 w=0.5u l=2u
X29 VDD VDD VDD VDD pfet_03v3 ad=0.3p pd=2.2u as=0 ps=0 w=0.5u l=2u
X30 VSS.t56 VSS.t54 VSS.t55 VSS.t9 nfet_03v3 ad=0.14p pd=1.06u as=0 ps=0 w=0.5u l=2u
X31 Isum Isum Isum Isum nfet_03v3 ad=0.3p pd=2.2u as=0 ps=0 w=0.5u l=2u
X32 VDD VDD VDD VDD pfet_03v3 ad=0.14p pd=1.06u as=0 ps=0 w=0.5u l=2u
X33 VSS.t35 VSS.t32 VSS.t34 VSS.t33 nfet_03v3 ad=0.14p pd=1.06u as=0 ps=0 w=0.5u l=2u
X34 VDD VDD VDD VDD pfet_03v3 ad=0.14p pd=1.06u as=0 ps=0 w=0.5u l=2u
X35 VDD VT a_4290_5175# VDD pfet_03v3 ad=0.3p pd=2.2u as=0.3p ps=2.2u w=0.5u l=0.64u
X36 Isum Isum Isum Isum nfet_03v3 ad=0.3p pd=2.2u as=0 ps=0 w=0.5u l=2u
X37 VSS.t27 VSS.t24 VSS.t26 VSS.t25 nfet_03v3 ad=0.14p pd=1.06u as=0 ps=0 w=0.5u l=2u
X38 a_190_n489# a_190_n489# VSS.t81 VSS.t80 nfet_03v3 ad=1.2p pd=5.2u as=1.2p ps=5.2u w=2u l=8u
X39 VDD VDD VDD VDD pfet_03v3 ad=0.3p pd=2.2u as=0 ps=0 w=0.5u l=2u
X40 VSS.t50 VSS.t48 VSS.t49 VSS.t1 nfet_03v3 ad=0.3p pd=2.2u as=0 ps=0 w=0.5u l=2u
X41 Isum Isum Isum Isum nfet_03v3 ad=0.3p pd=2.2u as=0 ps=0 w=0.5u l=2u
X42 VDD VDD VDD VDD pfet_03v3 ad=0.3p pd=2.2u as=0 ps=0 w=0.5u l=2u
X43 VSS.t62 VSS.t60 VSS.t61 VSS.t17 nfet_03v3 ad=0.14p pd=1.06u as=0 ps=0 w=0.5u l=2u
X44 VSS.t71 VSS.t69 VSS.t70 VSS.t29 nfet_03v3 ad=0.14p pd=1.06u as=0 ps=0 w=0.5u l=2u
X45 VDD VDD VDD VDD pfet_03v3 ad=0.14p pd=1.06u as=0 ps=0 w=0.5u l=2u
X46 VSS.t23 VSS.t20 VSS.t22 VSS.t21 nfet_03v3 ad=0.14p pd=1.06u as=0 ps=0 w=0.5u l=2u
X47 VDD VDD VDD VDD pfet_03v3 ad=0.14p pd=1.06u as=0 ps=0 w=0.5u l=2u
X48 VSS.t15 VSS.t12 VSS.t14 VSS.t13 nfet_03v3 ad=0.14p pd=1.06u as=0 ps=0 w=0.5u l=2u
X49 Isum Isum Isum Isum nfet_03v3 ad=0.14p pd=1.06u as=0 ps=0 w=0.5u l=2u
X50 VDD a_4290_5175# a_190_n489# VDD pfet_03v3 ad=0.3p pd=2.2u as=0.3p ps=2.2u w=0.5u l=0.64u
X51 Isum Isum Isum Isum nfet_03v3 ad=0.3p pd=2.2u as=0 ps=0 w=0.5u l=2u
X52 Isum Isum Isum Isum nfet_03v3 ad=0.14p pd=1.06u as=0 ps=0 w=0.5u l=2u
R0 VSS.n417 VSS.n416 30877.6
R1 VSS.n920 VSS.n53 450.233
R2 VSS.n63 VSS.n53 389.238
R3 VSS.n416 VSS.n311 389.238
R4 VSS.n311 VSS.n52 313.084
R5 VSS.n860 VSS.n116 272.904
R6 VSS.n785 VSS.n179 272.904
R7 VSS.n860 VSS.n115 272.904
R8 VSS.n919 VSS.n55 251.32
R9 VSS.n919 VSS.n56 251.32
R10 VSS.n864 VSS.n863 251.32
R11 VSS.n863 VSS.n112 251.32
R12 VSS.n621 VSS.n548 167.125
R13 VSS.n621 VSS.n520 167.125
R14 VSS.n764 VSS.n763 167.125
R15 VSS.n764 VSS.n193 167.125
R16 VSS.n310 VSS.n54 145.639
R17 VSS.n278 VSS.n54 145.639
R18 VSS.n921 VSS.n50 145.639
R19 VSS.n922 VSS.n921 145.639
R20 VSS.n920 VSS.n52 137.15
R21 VSS.n861 VSS.n114 129.315
R22 VSS.n862 VSS.n861 102.692
R23 VSS.n785 VSS.n784 86.6666
R24 VSS.n783 VSS.n782 76.0684
R25 VSS.n782 VSS.n181 76.0684
R26 VSS.n774 VSS.n181 76.0684
R27 VSS.n774 VSS.n773 76.0684
R28 VSS.n773 VSS.n771 76.0684
R29 VSS.n762 VSS.n198 76.0684
R30 VSS.n762 VSS.n197 76.0684
R31 VSS.n753 VSS.n205 76.0684
R32 VSS.n733 VSS.n425 76.0684
R33 VSS.n733 VSS.n423 76.0684
R34 VSS.t9 VSS.n423 76.0684
R35 VSS.t9 VSS.n431 76.0684
R36 VSS.n718 VSS.n439 76.0684
R37 VSS.n710 VSS.n446 76.0684
R38 VSS.n702 VSS.n446 76.0684
R39 VSS.n694 VSS.n464 76.0684
R40 VSS.n694 VSS.n460 76.0684
R41 VSS.n686 VSS.n470 76.0684
R42 VSS.n678 VSS.n470 76.0684
R43 VSS.n670 VSS.n485 76.0684
R44 VSS.t29 VSS.n494 76.0684
R45 VSS.t29 VSS.n492 76.0684
R46 VSS.n655 VSS.n492 76.0684
R47 VSS.n655 VSS.n500 76.0684
R48 VSS.n647 VSS.n508 76.0684
R49 VSS.n639 VSS.n508 76.0684
R50 VSS.n631 VSS.n522 76.0684
R51 VSS.n623 VSS.n522 76.0684
R52 VSS.n547 VSS.n546 76.0684
R53 VSS.n546 VSS.n530 76.0684
R54 VSS.n538 VSS.n530 76.0684
R55 VSS.n538 VSS.n537 76.0684
R56 VSS.n537 VSS.n114 76.0684
R57 VSS.n198 VSS.n188 60.8548
R58 VSS.n741 VSS.t5 60.8548
R59 VSS.n710 VSS.t13 60.8548
R60 VSS.n678 VSS.t25 60.8548
R61 VSS.n647 VSS.t33 60.8548
R62 VSS.n623 VSS.n622 60.8548
R63 VSS.n417 VSS.n205 55.1497
R64 VSS.n570 VSS.t41 52.2972
R65 VSS.n616 VSS.t45 52.2972
R66 VSS.n570 VSS.t1 45.6412
R67 VSS.n464 VSS.t17 45.6412
R68 VSS.t21 VSS.n460 45.6412
R69 VSS.n616 VSS.t37 45.6412
R70 VSS.n718 VSS.t80 42.7887
R71 VSS.n670 VSS.t78 42.7887
R72 VSS.t80 VSS.n431 33.2802
R73 VSS.n494 VSS.t78 33.2802
R74 VSS.n753 VSS.t1 30.4277
R75 VSS.n702 VSS.t17 30.4277
R76 VSS.n686 VSS.t21 30.4277
R77 VSS.n639 VSS.t37 30.4277
R78 VSS.t41 VSS.n197 23.7717
R79 VSS.n631 VSS.t45 23.7717
R80 VSS.n741 VSS.n417 20.9192
R81 Isum VSS.n4 19.8383
R82 VSS.n191 VSS.t81 19.251
R83 VSS.n350 VSS.t79 19.1072
R84 VSS.n16 VSS.n0 1.36777
R85 VSS.n180 VSS.n176 15.5561
R86 VSS.n176 VSS.n175 15.5561
R87 VSS.n175 VSS.n174 15.5561
R88 VSS.n772 VSS.n174 15.5561
R89 VSS.n772 VSS.n171 15.5561
R90 VSS.n171 VSS.n170 15.5561
R91 VSS.n170 VSS.n169 15.5561
R92 VSS.n196 VSS.n169 15.5561
R93 VSS.n196 VSS.n166 15.5561
R94 VSS.n166 VSS.n165 15.5561
R95 VSS.n165 VSS.n164 15.5561
R96 VSS.n214 VSS.n164 15.5561
R97 VSS.n214 VSS.n161 15.5561
R98 VSS.n161 VSS.n160 15.5561
R99 VSS.n160 VSS.n159 15.5561
R100 VSS.n433 VSS.n159 15.5561
R101 VSS.n433 VSS.n156 15.5561
R102 VSS.n156 VSS.n155 15.5561
R103 VSS.n155 VSS.n154 15.5561
R104 VSS.n448 VSS.n154 15.5561
R105 VSS.n448 VSS.n151 15.5561
R106 VSS.n151 VSS.n150 15.5561
R107 VSS.n150 VSS.n149 15.5561
R108 VSS.n463 VSS.n149 15.5561
R109 VSS.n463 VSS.n462 15.5561
R110 VSS.n462 VSS.n145 15.5561
R111 VSS.n145 VSS.n144 15.5561
R112 VSS.n144 VSS.n143 15.5561
R113 VSS.n484 VSS.n143 15.5561
R114 VSS.n484 VSS.n140 15.5561
R115 VSS.n140 VSS.n139 15.5561
R116 VSS.n139 VSS.n138 15.5561
R117 VSS.n491 VSS.n138 15.5561
R118 VSS.n491 VSS.n135 15.5561
R119 VSS.n135 VSS.n134 15.5561
R120 VSS.n134 VSS.n133 15.5561
R121 VSS.n507 VSS.n133 15.5561
R122 VSS.n507 VSS.n130 15.5561
R123 VSS.n130 VSS.n129 15.5561
R124 VSS.n129 VSS.n128 15.5561
R125 VSS.n521 VSS.n128 15.5561
R126 VSS.n521 VSS.n125 15.5561
R127 VSS.n125 VSS.n124 15.5561
R128 VSS.n124 VSS.n123 15.5561
R129 VSS.n529 VSS.n123 15.5561
R130 VSS.n529 VSS.n120 15.5561
R131 VSS.n120 VSS.n119 15.5561
R132 VSS.n119 VSS.n116 15.5561
R133 VSS.n781 VSS.n179 15.5561
R134 VSS.n781 VSS.n182 15.5561
R135 VSS.n775 VSS.n182 15.5561
R136 VSS.n775 VSS.n187 15.5561
R137 VSS.n770 VSS.n187 15.5561
R138 VSS.n770 VSS.n189 15.5561
R139 VSS.n761 VSS.n189 15.5561
R140 VSS.n761 VSS.n199 15.5561
R141 VSS.n204 VSS.n199 15.5561
R142 VSS.n754 VSS.n204 15.5561
R143 VSS.n754 VSS.n203 15.5561
R144 VSS.n740 VSS.n203 15.5561
R145 VSS.n740 VSS.n418 15.5561
R146 VSS.n734 VSS.n418 15.5561
R147 VSS.n734 VSS.n422 15.5561
R148 VSS.n725 VSS.n422 15.5561
R149 VSS.n725 VSS.n434 15.5561
R150 VSS.n719 VSS.n434 15.5561
R151 VSS.n719 VSS.n438 15.5561
R152 VSS.n709 VSS.n438 15.5561
R153 VSS.n709 VSS.n449 15.5561
R154 VSS.n703 VSS.n449 15.5561
R155 VSS.n703 VSS.n453 15.5561
R156 VSS.n693 VSS.n453 15.5561
R157 VSS.n693 VSS.n465 15.5561
R158 VSS.n687 VSS.n465 15.5561
R159 VSS.n687 VSS.n469 15.5561
R160 VSS.n677 VSS.n469 15.5561
R161 VSS.n677 VSS.n478 15.5561
R162 VSS.n671 VSS.n478 15.5561
R163 VSS.n671 VSS.n482 15.5561
R164 VSS.n662 VSS.n482 15.5561
R165 VSS.n662 VSS.n495 15.5561
R166 VSS.n656 VSS.n495 15.5561
R167 VSS.n656 VSS.n499 15.5561
R168 VSS.n646 VSS.n499 15.5561
R169 VSS.n646 VSS.n510 15.5561
R170 VSS.n640 VSS.n510 15.5561
R171 VSS.n640 VSS.n514 15.5561
R172 VSS.n630 VSS.n514 15.5561
R173 VSS.n630 VSS.n524 15.5561
R174 VSS.n624 VSS.n524 15.5561
R175 VSS.n624 VSS.n528 15.5561
R176 VSS.n545 VSS.n528 15.5561
R177 VSS.n545 VSS.n531 15.5561
R178 VSS.n539 VSS.n531 15.5561
R179 VSS.n539 VSS.n536 15.5561
R180 VSS.n536 VSS.n115 15.5561
R181 VSS.n283 VSS.n282 15.5561
R182 VSS.n287 VSS.n286 15.5561
R183 VSS.n291 VSS.n290 15.5561
R184 VSS.n295 VSS.n294 15.5561
R185 VSS.n299 VSS.n298 15.5561
R186 VSS.n303 VSS.n302 15.5561
R187 VSS.n307 VSS.n306 15.5561
R188 VSS.n310 VSS.n222 15.5561
R189 VSS.n254 VSS.n246 15.5561
R190 VSS.n257 VSS.n256 15.5561
R191 VSS.n261 VSS.n238 15.5561
R192 VSS.n264 VSS.n263 15.5561
R193 VSS.n268 VSS.n231 15.5561
R194 VSS.n271 VSS.n270 15.5561
R195 VSS.n275 VSS.n225 15.5561
R196 VSS.n278 VSS.n277 15.5561
R197 VSS.n362 VSS.n361 15.5561
R198 VSS.n366 VSS.n365 15.5561
R199 VSS.n370 VSS.n369 15.5561
R200 VSS.n374 VSS.n373 15.5561
R201 VSS.n378 VSS.n377 15.5561
R202 VSS.n382 VSS.n381 15.5561
R203 VSS.n386 VSS.n385 15.5561
R204 VSS.n390 VSS.n389 15.5561
R205 VSS.n394 VSS.n393 15.5561
R206 VSS.n398 VSS.n397 15.5561
R207 VSS.n402 VSS.n401 15.5561
R208 VSS.n406 VSS.n405 15.5561
R209 VSS.n410 VSS.n409 15.5561
R210 VSS.n414 VSS.n327 15.5561
R211 VSS.n326 VSS.n55 15.5561
R212 VSS.n868 VSS.n106 15.5561
R213 VSS.n871 VSS.n870 15.5561
R214 VSS.n875 VSS.n99 15.5561
R215 VSS.n878 VSS.n877 15.5561
R216 VSS.n882 VSS.n92 15.5561
R217 VSS.n885 VSS.n884 15.5561
R218 VSS.n889 VSS.n85 15.5561
R219 VSS.n892 VSS.n891 15.5561
R220 VSS.n896 VSS.n78 15.5561
R221 VSS.n899 VSS.n898 15.5561
R222 VSS.n903 VSS.n71 15.5561
R223 VSS.n906 VSS.n905 15.5561
R224 VSS.n910 VSS.n64 15.5561
R225 VSS.n913 VSS.n912 15.5561
R226 VSS.n59 VSS.n56 15.5561
R227 VSS.n569 VSS.n193 15.5561
R228 VSS.n571 VSS.n569 15.5561
R229 VSS.n571 VSS.n206 15.5561
R230 VSS.n574 VSS.n206 15.5561
R231 VSS.n574 VSS.n213 15.5561
R232 VSS.n577 VSS.n213 15.5561
R233 VSS.n577 VSS.n424 15.5561
R234 VSS.n580 VSS.n424 15.5561
R235 VSS.n580 VSS.n432 15.5561
R236 VSS.n583 VSS.n432 15.5561
R237 VSS.n583 VSS.n440 15.5561
R238 VSS.n586 VSS.n440 15.5561
R239 VSS.n586 VSS.n447 15.5561
R240 VSS.n589 VSS.n447 15.5561
R241 VSS.n589 VSS.n454 15.5561
R242 VSS.n592 VSS.n454 15.5561
R243 VSS.n592 VSS.n461 15.5561
R244 VSS.n595 VSS.n461 15.5561
R245 VSS.n595 VSS.n471 15.5561
R246 VSS.n598 VSS.n471 15.5561
R247 VSS.n598 VSS.n477 15.5561
R248 VSS.n601 VSS.n477 15.5561
R249 VSS.n601 VSS.n483 15.5561
R250 VSS.n604 VSS.n483 15.5561
R251 VSS.n604 VSS.n493 15.5561
R252 VSS.n607 VSS.n493 15.5561
R253 VSS.n607 VSS.n501 15.5561
R254 VSS.n610 VSS.n501 15.5561
R255 VSS.n610 VSS.n509 15.5561
R256 VSS.n613 VSS.n509 15.5561
R257 VSS.n613 VSS.n515 15.5561
R258 VSS.n617 VSS.n515 15.5561
R259 VSS.n617 VSS.n523 15.5561
R260 VSS.n548 VSS.n523 15.5561
R261 VSS.n763 VSS.n194 15.5561
R262 VSS.n208 VSS.n194 15.5561
R263 VSS.n752 VSS.n208 15.5561
R264 VSS.n752 VSS.n207 15.5561
R265 VSS.n742 VSS.n207 15.5561
R266 VSS.n742 VSS.n212 15.5561
R267 VSS.n732 VSS.n212 15.5561
R268 VSS.n732 VSS.n426 15.5561
R269 VSS.n726 VSS.n426 15.5561
R270 VSS.n726 VSS.n430 15.5561
R271 VSS.n717 VSS.n430 15.5561
R272 VSS.n717 VSS.n441 15.5561
R273 VSS.n711 VSS.n441 15.5561
R274 VSS.n711 VSS.n445 15.5561
R275 VSS.n701 VSS.n445 15.5561
R276 VSS.n701 VSS.n455 15.5561
R277 VSS.n695 VSS.n455 15.5561
R278 VSS.n695 VSS.n459 15.5561
R279 VSS.n685 VSS.n459 15.5561
R280 VSS.n685 VSS.n472 15.5561
R281 VSS.n679 VSS.n472 15.5561
R282 VSS.n679 VSS.n476 15.5561
R283 VSS.n669 VSS.n476 15.5561
R284 VSS.n669 VSS.n486 15.5561
R285 VSS.n663 VSS.n486 15.5561
R286 VSS.n663 VSS.n490 15.5561
R287 VSS.n654 VSS.n490 15.5561
R288 VSS.n654 VSS.n502 15.5561
R289 VSS.n648 VSS.n502 15.5561
R290 VSS.n648 VSS.n506 15.5561
R291 VSS.n638 VSS.n506 15.5561
R292 VSS.n638 VSS.n516 15.5561
R293 VSS.n632 VSS.n516 15.5561
R294 VSS.n632 VSS.n520 15.5561
R295 VSS.n771 VSS.n188 15.2141
R296 VSS.n425 VSS.t5 15.2141
R297 VSS.t13 VSS.n439 15.2141
R298 VSS.n485 VSS.t25 15.2141
R299 VSS.t33 VSS.n500 15.2141
R300 VSS.n622 VSS.n547 15.2141
R301 VSS.n47 VSS.n350 14.6381
R302 VSS.n36 VSS.n0 2.14504
R303 VSS.n35 VSS.n0 2.14504
R304 VSS.n558 VSS.n3 12.5005
R305 VSS.n5 VSS.n3 2.13792
R306 VSS.n10 VSS.n3 2.13448
R307 VSS.n32 VSS.n3 2.13792
R308 VSS.n31 VSS.n3 2.14504
R309 VSS.n6 VSS.n3 1.05778
R310 VSS.n8 VSS.n3 1.36777
R311 VSS.n7 VSS.n2 1.37569
R312 VSS.n13 VSS.n2 1.05778
R313 VSS.n13 VSS.t69 5.28449
R314 VSS.n21 VSS.n2 2.14504
R315 VSS.n20 VSS.n3 2.13792
R316 VSS.n3 VSS.n14 2.13448
R317 VSS.n3 VSS.n15 2.13792
R318 VSS.n3 VSS.n19 2.14504
R319 VSS.n3 VSS.n12 1.05778
R320 VSS.n0 VSS.t38 12.1268
R321 VSS.n3 VSS.t3 12.1268
R322 VSS.n2 VSS.t44 12.0353
R323 VSS.n3 VSS.t40 12.0353
R324 VSS.n12 VSS.t54 5.28449
R325 VSS.n21 VSS.t69 10.7223
R326 VSS.n3 VSS.t49 12.1169
R327 VSS.n2 VSS.t77 12.1169
R328 VSS.t48 VSS.n9 5.28558
R329 VSS.n20 VSS.t66 9.4683
R330 VSS.n2 VSS.n563 8.63568
R331 VSS.n2 VSS.n564 8.63568
R332 VSS.n3 VSS.n561 8.63568
R333 VSS.n3 VSS.n559 8.63568
R334 VSS.n3 VSS.n567 8.63568
R335 VSS.n0 VSS.n549 8.63568
R336 VSS.n0 VSS.n551 8.63568
R337 VSS.n3 VSS.n553 8.63568
R338 VSS.n3 VSS.n555 8.63568
R339 VSS.n3 VSS.n557 8.63568
R340 VSS.n2 VSS.n562 8.59884
R341 VSS.n3 VSS.n565 8.59884
R342 VSS.n3 VSS.n560 8.59884
R343 VSS.n3 VSS.n566 8.59884
R344 VSS.n0 VSS.n550 8.59884
R345 VSS.n3 VSS.n552 8.59884
R346 VSS.n3 VSS.n554 8.59884
R347 VSS.n3 VSS.n556 8.59884
R348 VSS.t60 VSS.n14 8.14966
R349 VSS.n862 VSS.n52 7.60729
R350 VSS.t72 VSS.n7 10.0489
R351 VSS.n859 VSS.n858 7.2529
R352 VSS.n859 VSS.n117 7.2529
R353 VSS.n786 VSS.n178 7.16339
R354 VSS.n787 VSS.n786 7.16339
R355 VSS.n918 VSS.n57 7.03823
R356 VSS.n918 VSS.n917 7.03823
R357 VSS.n113 VSS.n110 7.03823
R358 VSS.n358 VSS.n113 7.03823
R359 VSS.t0 VSS.n8 4.35461
R360 VSS.t20 VSS.n5 6.80683
R361 VSS.n620 VSS.n0 6.1873
R362 VSS.n620 VSS.n518 6.1873
R363 VSS.n765 VSS.n192 6.1873
R364 VSS.n3 VSS.n765 6.1693
R365 VSS.n281 VSS.n280 5.97353
R366 VSS.n250 VSS.n51 5.97353
R367 VSS.n4 VSS.n281 5.85293
R368 VSS.n51 VSS.n4 5.85293
R369 VSS.n766 VSS.n191 5.6183
R370 VSS.n19 VSS.t54 10.7223
R371 VSS.n13 VSS.t72 6.40824
R372 VSS.t4 VSS.n6 6.40756
R373 VSS.n6 VSS.t8 5.28517
R374 VSS.t8 VSS.n31 10.7223
R375 VSS.n558 VSS.n35 10.7223
R376 VSS.n35 VSS.t28 4.37821
R377 VSS.t28 VSS.n36 10.7223
R378 VSS.n766 VSS.n3 5.4941
R379 VSS.n116 VSS.n114 5.2005
R380 VSS.n857 VSS.n116 5.2005
R381 VSS.n537 VSS.n119 5.2005
R382 VSS.n856 VSS.n119 5.2005
R383 VSS.n538 VSS.n120 5.2005
R384 VSS.n855 VSS.n120 5.2005
R385 VSS.n530 VSS.n529 5.2005
R386 VSS.n529 VSS.n121 5.2005
R387 VSS.n546 VSS.n123 5.2005
R388 VSS.n851 VSS.n123 5.2005
R389 VSS.n547 VSS.n124 5.2005
R390 VSS.n850 VSS.n124 5.2005
R391 VSS.n623 VSS.n125 5.2005
R392 VSS.n849 VSS.n125 5.2005
R393 VSS.n522 VSS.n521 5.2005
R394 VSS.n521 VSS.n126 5.2005
R395 VSS.n631 VSS.n128 5.2005
R396 VSS.n845 VSS.n128 5.2005
R397 VSS.n616 VSS.n129 5.2005
R398 VSS.n844 VSS.n129 5.2005
R399 VSS.n639 VSS.n130 5.2005
R400 VSS.n843 VSS.n130 5.2005
R401 VSS.n508 VSS.n507 5.2005
R402 VSS.n507 VSS.n131 5.2005
R403 VSS.n647 VSS.n133 5.2005
R404 VSS.n839 VSS.n133 5.2005
R405 VSS.n500 VSS.n134 5.2005
R406 VSS.n838 VSS.n134 5.2005
R407 VSS.n655 VSS.n135 5.2005
R408 VSS.n837 VSS.n135 5.2005
R409 VSS.n492 VSS.n491 5.2005
R410 VSS.n491 VSS.n136 5.2005
R411 VSS.t29 VSS.n138 5.2005
R412 VSS.n833 VSS.n138 5.2005
R413 VSS.n494 VSS.n139 5.2005
R414 VSS.n832 VSS.n139 5.2005
R415 VSS.n670 VSS.n140 5.2005
R416 VSS.n831 VSS.n140 5.2005
R417 VSS.n485 VSS.n484 5.2005
R418 VSS.n484 VSS.n141 5.2005
R419 VSS.n678 VSS.n143 5.2005
R420 VSS.n827 VSS.n143 5.2005
R421 VSS.n470 VSS.n144 5.2005
R422 VSS.n826 VSS.n144 5.2005
R423 VSS.n686 VSS.n145 5.2005
R424 VSS.n825 VSS.n145 5.2005
R425 VSS.n462 VSS.n460 5.2005
R426 VSS.n462 VSS.n146 5.2005
R427 VSS.n694 VSS.n463 5.2005
R428 VSS.n463 VSS.n147 5.2005
R429 VSS.n464 VSS.n149 5.2005
R430 VSS.n821 VSS.n149 5.2005
R431 VSS.n702 VSS.n150 5.2005
R432 VSS.n820 VSS.n150 5.2005
R433 VSS.n446 VSS.n151 5.2005
R434 VSS.n819 VSS.n151 5.2005
R435 VSS.n710 VSS.n448 5.2005
R436 VSS.n448 VSS.n152 5.2005
R437 VSS.n439 VSS.n154 5.2005
R438 VSS.n815 VSS.n154 5.2005
R439 VSS.n718 VSS.n155 5.2005
R440 VSS.n814 VSS.n155 5.2005
R441 VSS.n431 VSS.n156 5.2005
R442 VSS.n813 VSS.n156 5.2005
R443 VSS.t9 VSS.n433 5.2005
R444 VSS.n433 VSS.n157 5.2005
R445 VSS.n423 VSS.n159 5.2005
R446 VSS.n809 VSS.n159 5.2005
R447 VSS.n733 VSS.n160 5.2005
R448 VSS.n808 VSS.n160 5.2005
R449 VSS.n425 VSS.n161 5.2005
R450 VSS.n807 VSS.n161 5.2005
R451 VSS.n741 VSS.n214 5.2005
R452 VSS.n214 VSS.n162 5.2005
R453 VSS.n205 VSS.n164 5.2005
R454 VSS.n803 VSS.n164 5.2005
R455 VSS.n753 VSS.n165 5.2005
R456 VSS.n802 VSS.n165 5.2005
R457 VSS.n570 VSS.n166 5.2005
R458 VSS.n801 VSS.n166 5.2005
R459 VSS.n197 VSS.n196 5.2005
R460 VSS.n196 VSS.n167 5.2005
R461 VSS.n762 VSS.n169 5.2005
R462 VSS.n797 VSS.n169 5.2005
R463 VSS.n198 VSS.n170 5.2005
R464 VSS.n796 VSS.n170 5.2005
R465 VSS.n771 VSS.n171 5.2005
R466 VSS.n795 VSS.n171 5.2005
R467 VSS.n773 VSS.n772 5.2005
R468 VSS.n772 VSS.n172 5.2005
R469 VSS.n774 VSS.n174 5.2005
R470 VSS.n791 VSS.n174 5.2005
R471 VSS.n181 VSS.n175 5.2005
R472 VSS.n790 VSS.n175 5.2005
R473 VSS.n782 VSS.n176 5.2005
R474 VSS.n789 VSS.n176 5.2005
R475 VSS.n180 VSS.n177 5.2005
R476 VSS.n783 VSS.n179 5.2005
R477 VSS.n184 VSS.n179 5.2005
R478 VSS.n782 VSS.n781 5.2005
R479 VSS.n781 VSS.n780 5.2005
R480 VSS.n182 VSS.n181 5.2005
R481 VSS.n183 VSS.n182 5.2005
R482 VSS.n775 VSS.n774 5.2005
R483 VSS.n776 VSS.n775 5.2005
R484 VSS.n773 VSS.n187 5.2005
R485 VSS.n187 VSS.n186 5.2005
R486 VSS.n771 VSS.n770 5.2005
R487 VSS.n770 VSS.n769 5.2005
R488 VSS.n198 VSS.n189 5.2005
R489 VSS.n190 VSS.n189 5.2005
R490 VSS.n762 VSS.n761 5.2005
R491 VSS.n761 VSS.n760 5.2005
R492 VSS.n199 VSS.n197 5.2005
R493 VSS.n759 VSS.n199 5.2005
R494 VSS.n570 VSS.n204 5.2005
R495 VSS.n204 VSS.n200 5.2005
R496 VSS.n754 VSS.n753 5.2005
R497 VSS.n755 VSS.n754 5.2005
R498 VSS.n205 VSS.n203 5.2005
R499 VSS.n203 VSS.n202 5.2005
R500 VSS.n741 VSS.n740 5.2005
R501 VSS.n740 VSS.n739 5.2005
R502 VSS.n425 VSS.n418 5.2005
R503 VSS.n419 VSS.n418 5.2005
R504 VSS.n734 VSS.n733 5.2005
R505 VSS.n735 VSS.n734 5.2005
R506 VSS.n423 VSS.n422 5.2005
R507 VSS.n422 VSS.n421 5.2005
R508 VSS.t9 VSS.n725 5.2005
R509 VSS.n725 VSS.n724 5.2005
R510 VSS.n434 VSS.n431 5.2005
R511 VSS.n435 VSS.n434 5.2005
R512 VSS.n719 VSS.n718 5.2005
R513 VSS.n720 VSS.n719 5.2005
R514 VSS.n439 VSS.n438 5.2005
R515 VSS.n438 VSS.n437 5.2005
R516 VSS.n710 VSS.n709 5.2005
R517 VSS.n709 VSS.n708 5.2005
R518 VSS.n449 VSS.n446 5.2005
R519 VSS.n450 VSS.n449 5.2005
R520 VSS.n703 VSS.n702 5.2005
R521 VSS.n704 VSS.n703 5.2005
R522 VSS.n464 VSS.n453 5.2005
R523 VSS.n453 VSS.n452 5.2005
R524 VSS.n694 VSS.n693 5.2005
R525 VSS.n693 VSS.n692 5.2005
R526 VSS.n465 VSS.n460 5.2005
R527 VSS.n466 VSS.n465 5.2005
R528 VSS.n687 VSS.n686 5.2005
R529 VSS.n688 VSS.n687 5.2005
R530 VSS.n470 VSS.n469 5.2005
R531 VSS.n469 VSS.n468 5.2005
R532 VSS.n678 VSS.n677 5.2005
R533 VSS.n677 VSS.n676 5.2005
R534 VSS.n485 VSS.n478 5.2005
R535 VSS.n479 VSS.n478 5.2005
R536 VSS.n671 VSS.n670 5.2005
R537 VSS.n672 VSS.n671 5.2005
R538 VSS.n494 VSS.n482 5.2005
R539 VSS.n482 VSS.n481 5.2005
R540 VSS.t29 VSS.n662 5.2005
R541 VSS.n662 VSS.n661 5.2005
R542 VSS.n495 VSS.n492 5.2005
R543 VSS.n496 VSS.n495 5.2005
R544 VSS.n656 VSS.n655 5.2005
R545 VSS.n657 VSS.n656 5.2005
R546 VSS.n500 VSS.n499 5.2005
R547 VSS.n499 VSS.n498 5.2005
R548 VSS.n647 VSS.n646 5.2005
R549 VSS.n646 VSS.n645 5.2005
R550 VSS.n510 VSS.n508 5.2005
R551 VSS.n511 VSS.n510 5.2005
R552 VSS.n640 VSS.n639 5.2005
R553 VSS.n641 VSS.n640 5.2005
R554 VSS.n616 VSS.n514 5.2005
R555 VSS.n514 VSS.n513 5.2005
R556 VSS.n631 VSS.n630 5.2005
R557 VSS.n630 VSS.n629 5.2005
R558 VSS.n524 VSS.n522 5.2005
R559 VSS.n525 VSS.n524 5.2005
R560 VSS.n624 VSS.n623 5.2005
R561 VSS.n625 VSS.n624 5.2005
R562 VSS.n547 VSS.n528 5.2005
R563 VSS.n528 VSS.n527 5.2005
R564 VSS.n546 VSS.n545 5.2005
R565 VSS.n545 VSS.n544 5.2005
R566 VSS.n531 VSS.n530 5.2005
R567 VSS.n532 VSS.n531 5.2005
R568 VSS.n539 VSS.n538 5.2005
R569 VSS.n540 VSS.n539 5.2005
R570 VSS.n537 VSS.n536 5.2005
R571 VSS.n536 VSS.n535 5.2005
R572 VSS.n115 VSS.n114 5.2005
R573 VSS.n534 VSS.n115 5.2005
R574 VSS.n522 VSS.n520 5.2005
R575 VSS.n520 VSS.n519 5.2005
R576 VSS.n632 VSS.n631 5.2005
R577 VSS.n633 VSS.n632 5.2005
R578 VSS.n616 VSS.n516 5.2005
R579 VSS.n517 VSS.n516 5.2005
R580 VSS.n639 VSS.n638 5.2005
R581 VSS.n638 VSS.n637 5.2005
R582 VSS.n508 VSS.n506 5.2005
R583 VSS.n506 VSS.n505 5.2005
R584 VSS.n648 VSS.n647 5.2005
R585 VSS.n649 VSS.n648 5.2005
R586 VSS.n502 VSS.n500 5.2005
R587 VSS.n503 VSS.n502 5.2005
R588 VSS.n655 VSS.n654 5.2005
R589 VSS.n654 VSS.n653 5.2005
R590 VSS.n492 VSS.n490 5.2005
R591 VSS.n490 VSS.n489 5.2005
R592 VSS.n663 VSS.t29 5.2005
R593 VSS.n664 VSS.n663 5.2005
R594 VSS.n494 VSS.n486 5.2005
R595 VSS.n487 VSS.n486 5.2005
R596 VSS.n670 VSS.n669 5.2005
R597 VSS.n669 VSS.n668 5.2005
R598 VSS.n485 VSS.n476 5.2005
R599 VSS.n476 VSS.n475 5.2005
R600 VSS.n679 VSS.n678 5.2005
R601 VSS.n680 VSS.n679 5.2005
R602 VSS.n472 VSS.n470 5.2005
R603 VSS.n473 VSS.n472 5.2005
R604 VSS.n686 VSS.n685 5.2005
R605 VSS.n685 VSS.n684 5.2005
R606 VSS.n460 VSS.n459 5.2005
R607 VSS.n459 VSS.n458 5.2005
R608 VSS.n695 VSS.n694 5.2005
R609 VSS.n696 VSS.n695 5.2005
R610 VSS.n464 VSS.n455 5.2005
R611 VSS.n456 VSS.n455 5.2005
R612 VSS.n702 VSS.n701 5.2005
R613 VSS.n701 VSS.n700 5.2005
R614 VSS.n446 VSS.n445 5.2005
R615 VSS.n445 VSS.n444 5.2005
R616 VSS.n711 VSS.n710 5.2005
R617 VSS.n712 VSS.n711 5.2005
R618 VSS.n441 VSS.n439 5.2005
R619 VSS.n442 VSS.n441 5.2005
R620 VSS.n718 VSS.n717 5.2005
R621 VSS.n717 VSS.n716 5.2005
R622 VSS.n431 VSS.n430 5.2005
R623 VSS.n430 VSS.n429 5.2005
R624 VSS.n726 VSS.t9 5.2005
R625 VSS.n727 VSS.n726 5.2005
R626 VSS.n426 VSS.n423 5.2005
R627 VSS.n427 VSS.n426 5.2005
R628 VSS.n733 VSS.n732 5.2005
R629 VSS.n732 VSS.n731 5.2005
R630 VSS.n425 VSS.n212 5.2005
R631 VSS.n212 VSS.n211 5.2005
R632 VSS.n742 VSS.n741 5.2005
R633 VSS.n743 VSS.n742 5.2005
R634 VSS.n207 VSS.n205 5.2005
R635 VSS.n209 VSS.n207 5.2005
R636 VSS.n753 VSS.n752 5.2005
R637 VSS.n752 VSS.n751 5.2005
R638 VSS.n570 VSS.n208 5.2005
R639 VSS.n750 VSS.n208 5.2005
R640 VSS.n197 VSS.n194 5.2005
R641 VSS.n749 VSS.n194 5.2005
R642 VSS.n763 VSS.n762 5.2005
R643 VSS.n763 VSS.n195 5.2005
R644 VSS.n548 VSS.n522 5.2005
R645 VSS.n18 VSS.n548 5.27187
R646 VSS.n631 VSS.n523 5.2005
R647 VSS.n619 VSS.n523 5.2005
R648 VSS.n617 VSS.n616 5.2005
R649 VSS.n618 VSS.n617 5.2005
R650 VSS.n639 VSS.n515 5.2005
R651 VSS.n615 VSS.n515 5.2005
R652 VSS.n613 VSS.n508 5.2005
R653 VSS.n614 VSS.n613 5.2005
R654 VSS.n647 VSS.n509 5.2005
R655 VSS.n612 VSS.n509 5.2005
R656 VSS.n610 VSS.n500 5.2005
R657 VSS.n611 VSS.n610 5.2005
R658 VSS.n655 VSS.n501 5.2005
R659 VSS.n609 VSS.n501 5.2005
R660 VSS.n607 VSS.n492 5.2005
R661 VSS.n608 VSS.n607 5.2005
R662 VSS.t29 VSS.n493 5.2005
R663 VSS.n606 VSS.n493 5.2005
R664 VSS.n604 VSS.n494 5.2005
R665 VSS.n605 VSS.n604 5.2005
R666 VSS.n670 VSS.n483 5.2005
R667 VSS.n603 VSS.n483 5.2005
R668 VSS.n601 VSS.n485 5.2005
R669 VSS.n602 VSS.n601 5.2005
R670 VSS.n678 VSS.n477 5.2005
R671 VSS.n600 VSS.n477 5.2005
R672 VSS.n598 VSS.n470 5.2005
R673 VSS.n599 VSS.n598 5.2005
R674 VSS.n686 VSS.n471 5.2005
R675 VSS.n597 VSS.n471 5.2005
R676 VSS.n595 VSS.n460 5.2005
R677 VSS.n596 VSS.n595 5.2005
R678 VSS.n694 VSS.n461 5.2005
R679 VSS.n594 VSS.n461 5.2005
R680 VSS.n592 VSS.n464 5.2005
R681 VSS.n593 VSS.n592 5.2005
R682 VSS.n702 VSS.n454 5.2005
R683 VSS.n591 VSS.n454 5.2005
R684 VSS.n589 VSS.n446 5.2005
R685 VSS.n590 VSS.n589 5.2005
R686 VSS.n710 VSS.n447 5.2005
R687 VSS.n588 VSS.n447 5.2005
R688 VSS.n586 VSS.n439 5.2005
R689 VSS.n587 VSS.n586 5.2005
R690 VSS.n718 VSS.n440 5.2005
R691 VSS.n585 VSS.n440 5.2005
R692 VSS.n583 VSS.n431 5.2005
R693 VSS.n584 VSS.n583 5.2005
R694 VSS.t9 VSS.n432 5.2005
R695 VSS.n582 VSS.n432 5.2005
R696 VSS.n580 VSS.n423 5.2005
R697 VSS.n581 VSS.n580 5.2005
R698 VSS.n733 VSS.n424 5.2005
R699 VSS.n579 VSS.n424 5.2005
R700 VSS.n577 VSS.n425 5.2005
R701 VSS.n578 VSS.n577 5.2005
R702 VSS.n741 VSS.n213 5.2005
R703 VSS.n576 VSS.n213 5.2005
R704 VSS.n574 VSS.n205 5.2005
R705 VSS.n575 VSS.n574 5.2005
R706 VSS.n753 VSS.n206 5.2005
R707 VSS.n573 VSS.n206 5.2005
R708 VSS.n571 VSS.n570 5.2005
R709 VSS.n572 VSS.n571 5.2005
R710 VSS.n569 VSS.n197 5.2005
R711 VSS.n569 VSS.n568 5.2005
R712 VSS.n762 VSS.n193 5.2005
R713 VSS.n63 VSS.n56 5.2005
R714 VSS.n916 VSS.n56 5.2005
R715 VSS.n915 VSS.n59 5.2005
R716 VSS.n914 VSS.n913 5.2005
R717 VSS.n912 VSS.n61 5.2005
R718 VSS.n910 VSS.n909 5.2005
R719 VSS.n908 VSS.n64 5.2005
R720 VSS.n907 VSS.n906 5.2005
R721 VSS.n905 VSS.n69 5.2005
R722 VSS.n903 VSS.n902 5.2005
R723 VSS.n901 VSS.n71 5.2005
R724 VSS.n900 VSS.n899 5.2005
R725 VSS.n898 VSS.n76 5.2005
R726 VSS.n896 VSS.n895 5.2005
R727 VSS.n894 VSS.n78 5.2005
R728 VSS.n893 VSS.n892 5.2005
R729 VSS.n891 VSS.n83 5.2005
R730 VSS.n889 VSS.n888 5.2005
R731 VSS.n887 VSS.n85 5.2005
R732 VSS.n886 VSS.n885 5.2005
R733 VSS.n884 VSS.n90 5.2005
R734 VSS.n882 VSS.n881 5.2005
R735 VSS.n880 VSS.n92 5.2005
R736 VSS.n879 VSS.n878 5.2005
R737 VSS.n877 VSS.n97 5.2005
R738 VSS.n875 VSS.n874 5.2005
R739 VSS.n873 VSS.n99 5.2005
R740 VSS.n872 VSS.n871 5.2005
R741 VSS.n870 VSS.n104 5.2005
R742 VSS.n868 VSS.n867 5.2005
R743 VSS.n866 VSS.n106 5.2005
R744 VSS.n865 VSS.n864 5.2005
R745 VSS.n416 VSS.n55 5.2005
R746 VSS.n328 VSS.n55 5.2005
R747 VSS.n329 VSS.n326 5.2005
R748 VSS.n414 VSS.n413 5.2005
R749 VSS.n412 VSS.n327 5.2005
R750 VSS.n411 VSS.n410 5.2005
R751 VSS.n409 VSS.n408 5.2005
R752 VSS.n407 VSS.n406 5.2005
R753 VSS.n405 VSS.n404 5.2005
R754 VSS.n403 VSS.n402 5.2005
R755 VSS.n401 VSS.n400 5.2005
R756 VSS.n399 VSS.n398 5.2005
R757 VSS.n397 VSS.n396 5.2005
R758 VSS.n395 VSS.n394 5.2005
R759 VSS.n393 VSS.n392 5.2005
R760 VSS.n391 VSS.n390 5.2005
R761 VSS.n389 VSS.n388 5.2005
R762 VSS.n387 VSS.n386 5.2005
R763 VSS.n385 VSS.n384 5.2005
R764 VSS.n383 VSS.n382 5.2005
R765 VSS.n381 VSS.n380 5.2005
R766 VSS.n379 VSS.n378 5.2005
R767 VSS.n377 VSS.n376 5.2005
R768 VSS.n375 VSS.n374 5.2005
R769 VSS.n373 VSS.n372 5.2005
R770 VSS.n371 VSS.n370 5.2005
R771 VSS.n369 VSS.n368 5.2005
R772 VSS.n367 VSS.n366 5.2005
R773 VSS.n365 VSS.n364 5.2005
R774 VSS.n363 VSS.n362 5.2005
R775 VSS.n361 VSS.n360 5.2005
R776 VSS.n359 VSS.n112 5.2005
R777 VSS.n278 VSS.n53 5.2005
R778 VSS.n279 VSS.n278 5.2005
R779 VSS.n277 VSS.n224 5.2005
R780 VSS.n275 VSS.n274 5.2005
R781 VSS.n273 VSS.n225 5.2005
R782 VSS.n272 VSS.n271 5.2005
R783 VSS.n270 VSS.n229 5.2005
R784 VSS.n268 VSS.n267 5.2005
R785 VSS.n266 VSS.n231 5.2005
R786 VSS.n265 VSS.n264 5.2005
R787 VSS.n263 VSS.n236 5.2005
R788 VSS.n261 VSS.n260 5.2005
R789 VSS.n259 VSS.n238 5.2005
R790 VSS.n258 VSS.n257 5.2005
R791 VSS.n256 VSS.n243 5.2005
R792 VSS.n254 VSS.n253 5.2005
R793 VSS.n252 VSS.n246 5.2005
R794 VSS.n251 VSS.n50 5.2005
R795 VSS.n311 VSS.n310 5.2005
R796 VSS.n309 VSS.n222 5.2005
R797 VSS.n308 VSS.n307 5.2005
R798 VSS.n306 VSS.n305 5.2005
R799 VSS.n304 VSS.n303 5.2005
R800 VSS.n302 VSS.n301 5.2005
R801 VSS.n300 VSS.n299 5.2005
R802 VSS.n298 VSS.n297 5.2005
R803 VSS.n296 VSS.n295 5.2005
R804 VSS.n294 VSS.n293 5.2005
R805 VSS.n292 VSS.n291 5.2005
R806 VSS.n290 VSS.n289 5.2005
R807 VSS.n288 VSS.n287 5.2005
R808 VSS.n286 VSS.n285 5.2005
R809 VSS.n284 VSS.n283 5.2005
R810 VSS.n282 VSS.n48 5.2005
R811 VSS.n923 VSS.n922 5.2005
R812 VSS.n858 VSS.n857 4.5005
R813 VSS.n787 VSS.n177 4.5005
R814 VSS.n789 VSS.n788 4.5005
R815 VSS.n790 VSS.n173 4.5005
R816 VSS.n792 VSS.n791 4.5005
R817 VSS.n793 VSS.n172 4.5005
R818 VSS.n795 VSS.n794 4.5005
R819 VSS.n796 VSS.n168 4.5005
R820 VSS.n798 VSS.n797 4.5005
R821 VSS.n799 VSS.n167 4.5005
R822 VSS.n801 VSS.n800 4.5005
R823 VSS.n802 VSS.n163 4.5005
R824 VSS.n804 VSS.n803 4.5005
R825 VSS.n805 VSS.n162 4.5005
R826 VSS.n807 VSS.n806 4.5005
R827 VSS.n808 VSS.n158 4.5005
R828 VSS.n810 VSS.n809 4.5005
R829 VSS.n811 VSS.n157 4.5005
R830 VSS.n813 VSS.n812 4.5005
R831 VSS.n814 VSS.n153 4.5005
R832 VSS.n816 VSS.n815 4.5005
R833 VSS.n817 VSS.n152 4.5005
R834 VSS.n819 VSS.n818 4.5005
R835 VSS.n820 VSS.n148 4.5005
R836 VSS.n822 VSS.n821 4.5005
R837 VSS VSS.n147 4.5005
R838 VSS.n823 VSS.n146 4.5005
R839 VSS.n825 VSS.n824 4.5005
R840 VSS.n826 VSS.n142 4.5005
R841 VSS.n828 VSS.n827 4.5005
R842 VSS.n829 VSS.n141 4.5005
R843 VSS.n831 VSS.n830 4.5005
R844 VSS.n832 VSS.n137 4.5005
R845 VSS.n834 VSS.n833 4.5005
R846 VSS.n835 VSS.n136 4.5005
R847 VSS.n837 VSS.n836 4.5005
R848 VSS.n838 VSS.n132 4.5005
R849 VSS.n840 VSS.n839 4.5005
R850 VSS.n841 VSS.n131 4.5005
R851 VSS.n843 VSS.n842 4.5005
R852 VSS.n844 VSS.n127 4.5005
R853 VSS.n846 VSS.n845 4.5005
R854 VSS.n847 VSS.n126 4.5005
R855 VSS.n849 VSS.n848 4.5005
R856 VSS.n850 VSS.n122 4.5005
R857 VSS.n852 VSS.n851 4.5005
R858 VSS.n853 VSS.n121 4.5005
R859 VSS.n855 VSS.n854 4.5005
R860 VSS.n856 VSS.n118 4.5005
R861 VSS.n184 VSS.n178 4.5005
R862 VSS.n780 VSS.n779 4.5005
R863 VSS.n778 VSS.n183 4.5005
R864 VSS.n777 VSS.n776 4.5005
R865 VSS.n186 VSS.n185 4.5005
R866 VSS.n769 VSS.n768 4.5005
R867 VSS.n767 VSS.n190 4.5005
R868 VSS.n760 VSS.n22 4.5005
R869 VSS.n22 VSS.n766 4.5005
R870 VSS.n759 VSS.n758 4.5005
R871 VSS.n757 VSS.n200 4.5005
R872 VSS.n756 VSS.n755 4.5005
R873 VSS.n202 VSS.n201 4.5005
R874 VSS.n739 VSS.n738 4.5005
R875 VSS.n737 VSS.n419 4.5005
R876 VSS.n736 VSS.n735 4.5005
R877 VSS.n421 VSS.n420 4.5005
R878 VSS.n724 VSS.n723 4.5005
R879 VSS.n722 VSS.n435 4.5005
R880 VSS.n721 VSS.n720 4.5005
R881 VSS.n437 VSS.n436 4.5005
R882 VSS.n708 VSS.n707 4.5005
R883 VSS.n706 VSS.n450 4.5005
R884 VSS.n705 VSS.n704 4.5005
R885 VSS.n452 VSS.n451 4.5005
R886 VSS.n692 VSS.n691 4.5005
R887 VSS.n690 VSS.n466 4.5005
R888 VSS.n689 VSS.n688 4.5005
R889 VSS.n468 VSS.n467 4.5005
R890 VSS.n676 VSS.n675 4.5005
R891 VSS.n674 VSS.n479 4.5005
R892 VSS.n673 VSS.n672 4.5005
R893 VSS.n481 VSS.n480 4.5005
R894 VSS.n661 VSS.n660 4.5005
R895 VSS.n659 VSS.n496 4.5005
R896 VSS.n658 VSS.n657 4.5005
R897 VSS.n498 VSS.n497 4.5005
R898 VSS.n645 VSS.n644 4.5005
R899 VSS.n643 VSS.n511 4.5005
R900 VSS.n642 VSS.n641 4.5005
R901 VSS.n513 VSS.n512 4.5005
R902 VSS.n629 VSS.n628 4.5005
R903 VSS.n627 VSS.n525 4.5005
R904 VSS.n626 VSS.n625 4.5005
R905 VSS.n527 VSS.n526 4.5005
R906 VSS.n544 VSS.n543 4.5005
R907 VSS.n542 VSS.n532 4.5005
R908 VSS.n541 VSS.n540 4.5005
R909 VSS.n535 VSS.n533 4.5005
R910 VSS.n534 VSS.n117 4.5005
R911 VSS.n17 VSS.n4 2.21557
R912 VSS.n4 VSS.n923 4.5005
R913 VSS.n48 VSS.n23 0.0718661
R914 VSS.n23 VSS.n4 2.21557
R915 VSS.n285 VSS.n24 0.0718661
R916 VSS.n24 VSS.n4 2.21557
R917 VSS.n289 VSS.n25 0.0718661
R918 VSS.n25 VSS.n4 2.21557
R919 VSS.n293 VSS.n26 0.0718661
R920 VSS.n26 VSS.n4 2.21557
R921 VSS.n297 VSS.n27 0.0718661
R922 VSS.n301 VSS.n28 0.0718661
R923 VSS.n28 VSS.n4 2.21557
R924 VSS.n305 VSS.n29 0.0718661
R925 VSS.n29 VSS.n4 2.21557
R926 VSS.n309 VSS.n17 0.0718661
R927 VSS.n280 VSS.n279 4.5005
R928 VSS.n251 VSS.n250 4.5005
R929 VSS.n252 VSS.n249 4.5005
R930 VSS.n253 VSS.n248 4.5005
R931 VSS.n247 VSS.n243 4.5005
R932 VSS.n258 VSS.n242 4.5005
R933 VSS.n259 VSS.n241 4.5005
R934 VSS.n260 VSS.n240 4.5005
R935 VSS.n239 VSS.n236 4.5005
R936 VSS.n265 VSS.n235 4.5005
R937 VSS.n266 VSS.n234 4.5005
R938 VSS.n267 VSS.n233 4.5005
R939 VSS.n232 VSS.n229 4.5005
R940 VSS.n272 VSS.n228 4.5005
R941 VSS.n273 VSS.n227 4.5005
R942 VSS.n274 VSS.n226 4.5005
R943 VSS.n224 VSS.n223 4.5005
R944 VSS.n328 VSS.n57 4.5005
R945 VSS.n359 VSS.n358 4.5005
R946 VSS.n360 VSS.n357 4.5005
R947 VSS.n363 VSS.n356 4.5005
R948 VSS.n364 VSS.n355 4.5005
R949 VSS.n367 VSS.n354 4.5005
R950 VSS.n368 VSS.n353 4.5005
R951 VSS.n371 VSS.n352 4.5005
R952 VSS.n372 VSS.n351 4.5005
R953 VSS.n375 VSS.n47 4.5005
R954 VSS.n376 VSS.n46 4.5005
R955 VSS.n379 VSS.n349 4.5005
R956 VSS.n380 VSS.n348 4.5005
R957 VSS.n383 VSS.n347 4.5005
R958 VSS.n384 VSS.n346 4.5005
R959 VSS.n387 VSS.n345 4.5005
R960 VSS.n388 VSS.n344 4.5005
R961 VSS.n391 VSS.n343 4.5005
R962 VSS.n392 VSS.n342 4.5005
R963 VSS.n395 VSS.n341 4.5005
R964 VSS.n396 VSS.n340 4.5005
R965 VSS.n399 VSS.n339 4.5005
R966 VSS.n400 VSS.n338 4.5005
R967 VSS.n403 VSS.n337 4.5005
R968 VSS.n404 VSS.n336 4.5005
R969 VSS.n407 VSS.n335 4.5005
R970 VSS.n408 VSS.n334 4.5005
R971 VSS.n411 VSS.n333 4.5005
R972 VSS.n412 VSS.n332 4.5005
R973 VSS.n413 VSS.n331 4.5005
R974 VSS.n330 VSS.n329 4.5005
R975 VSS.n11 VSS.n3 2.21557
R976 VSS.n568 VSS.n11 0.0718661
R977 VSS.n572 VSS.n30 0.0718661
R978 VSS.n30 VSS.n3 2.21557
R979 VSS.n575 VSS.n41 0.0718661
R980 VSS.n41 VSS.n3 2.21557
R981 VSS.n578 VSS.n3 4.5005
R982 VSS.n579 VSS.n45 0.0718661
R983 VSS.n45 VSS.n3 2.21557
R984 VSS.n582 VSS.n3 4.5005
R985 VSS.n584 VSS.n44 0.0718661
R986 VSS.n44 VSS.n3 2.21557
R987 VSS.n587 VSS.n3 4.5005
R988 VSS.n588 VSS.n40 0.0718661
R989 VSS.n40 VSS.n3 2.21557
R990 VSS.n591 VSS.n3 4.5005
R991 VSS.n593 VSS.n33 0.0718661
R992 VSS.n33 VSS.n3 2.21557
R993 VSS.n596 VSS.n34 0.0718661
R994 VSS.n34 VSS.n3 2.21557
R995 VSS.n599 VSS.n39 0.0718661
R996 VSS.n39 VSS.n3 2.21557
R997 VSS.n602 VSS.n3 4.5005
R998 VSS.n603 VSS.n43 0.0718661
R999 VSS.n43 VSS.n0 2.21557
R1000 VSS.n606 VSS.n0 4.5005
R1001 VSS.n608 VSS.n42 0.0718661
R1002 VSS.n42 VSS.n0 2.21557
R1003 VSS.n611 VSS.n0 4.5005
R1004 VSS.n612 VSS.n38 0.0718661
R1005 VSS.n38 VSS.n0 2.21557
R1006 VSS.n615 VSS.n37 0.0718661
R1007 VSS.n37 VSS.n0 2.21557
R1008 VSS.n619 VSS.n18 0.0718661
R1009 VSS.n0 VSS.n18 2.21557
R1010 VSS.n519 VSS.n518 4.5005
R1011 VSS.n195 VSS.n192 4.5005
R1012 VSS.n749 VSS.n748 4.5005
R1013 VSS.n750 VSS.n747 4.5005
R1014 VSS.n751 VSS.n746 4.5005
R1015 VSS.n745 VSS.n209 4.5005
R1016 VSS.n744 VSS.n743 4.5005
R1017 VSS.n211 VSS.n210 4.5005
R1018 VSS.n731 VSS.n730 4.5005
R1019 VSS.n729 VSS.n427 4.5005
R1020 VSS.n728 VSS.n727 4.5005
R1021 VSS.n429 VSS.n428 4.5005
R1022 VSS.n716 VSS.n715 4.5005
R1023 VSS.n714 VSS.n442 4.5005
R1024 VSS.n713 VSS.n712 4.5005
R1025 VSS.n444 VSS.n443 4.5005
R1026 VSS.n700 VSS.n699 4.5005
R1027 VSS.n698 VSS.n456 4.5005
R1028 VSS.n697 VSS.n696 4.5005
R1029 VSS.n458 VSS.n457 4.5005
R1030 VSS.n684 VSS.n683 4.5005
R1031 VSS.n682 VSS.n473 4.5005
R1032 VSS.n681 VSS.n680 4.5005
R1033 VSS.n475 VSS.n474 4.5005
R1034 VSS.n668 VSS.n667 4.5005
R1035 VSS.n666 VSS.n487 4.5005
R1036 VSS.n665 VSS.n664 4.5005
R1037 VSS.n489 VSS.n488 4.5005
R1038 VSS.n653 VSS.n652 4.5005
R1039 VSS.n651 VSS.n503 4.5005
R1040 VSS.n650 VSS.n649 4.5005
R1041 VSS.n505 VSS.n504 4.5005
R1042 VSS.n637 VSS.n636 4.5005
R1043 VSS.n635 VSS.n517 4.5005
R1044 VSS.n634 VSS.n633 4.5005
R1045 VSS.n917 VSS.n916 4.5005
R1046 VSS.n865 VSS.n110 4.5005
R1047 VSS.n866 VSS.n109 4.5005
R1048 VSS.n867 VSS.n108 4.5005
R1049 VSS.n107 VSS.n104 4.5005
R1050 VSS.n872 VSS.n103 4.5005
R1051 VSS.n873 VSS.n102 4.5005
R1052 VSS.n874 VSS.n101 4.5005
R1053 VSS.n100 VSS.n97 4.5005
R1054 VSS.n879 VSS.n96 4.5005
R1055 VSS.n880 VSS.n95 4.5005
R1056 VSS.n881 VSS.n94 4.5005
R1057 VSS.n93 VSS.n90 4.5005
R1058 VSS.n886 VSS.n89 4.5005
R1059 VSS.n887 VSS.n88 4.5005
R1060 VSS.n888 VSS.n87 4.5005
R1061 VSS.n86 VSS.n83 4.5005
R1062 VSS.n893 VSS.n82 4.5005
R1063 VSS.n894 VSS.n81 4.5005
R1064 VSS.n895 VSS.n80 4.5005
R1065 VSS.n79 VSS.n76 4.5005
R1066 VSS.n900 VSS.n75 4.5005
R1067 VSS.n901 VSS.n74 4.5005
R1068 VSS.n902 VSS.n73 4.5005
R1069 VSS.n72 VSS.n69 4.5005
R1070 VSS.n907 VSS.n68 4.5005
R1071 VSS.n908 VSS.n67 4.5005
R1072 VSS.n909 VSS.n66 4.5005
R1073 VSS.n65 VSS.n61 4.5005
R1074 VSS.n914 VSS.n60 4.5005
R1075 VSS.n915 VSS.n58 4.5005
R1076 VSS.t51 VSS.n9 10.0489
R1077 VSS.n15 VSS.t57 9.4683
R1078 VSS.n8 VSS.t4 10.0545
R1079 VSS.t12 VSS.n32 9.4683
R1080 VSS.n5 VSS.t24 9.4683
R1081 VSS.t32 VSS.n16 10.0545
R1082 VSS.n563 VSS.t73 3.5285
R1083 VSS.n563 VSS.t76 3.5285
R1084 VSS.n562 VSS.t70 3.5285
R1085 VSS.n562 VSS.t74 3.5285
R1086 VSS.n564 VSS.t67 3.5285
R1087 VSS.n564 VSS.t71 3.5285
R1088 VSS.n565 VSS.t64 3.5285
R1089 VSS.n565 VSS.t68 3.5285
R1090 VSS.n561 VSS.t61 3.5285
R1091 VSS.n561 VSS.t65 3.5285
R1092 VSS.n560 VSS.t58 3.5285
R1093 VSS.n560 VSS.t62 3.5285
R1094 VSS.n559 VSS.t55 3.5285
R1095 VSS.n559 VSS.t59 3.5285
R1096 VSS.n566 VSS.t52 3.5285
R1097 VSS.n566 VSS.t56 3.5285
R1098 VSS.n567 VSS.t50 3.5285
R1099 VSS.n567 VSS.t53 3.5285
R1100 VSS.n549 VSS.t34 3.5285
R1101 VSS.n549 VSS.t39 3.5285
R1102 VSS.n550 VSS.t30 3.5285
R1103 VSS.n550 VSS.t35 3.5285
R1104 VSS.n551 VSS.t26 3.5285
R1105 VSS.n551 VSS.t31 3.5285
R1106 VSS.n552 VSS.t22 3.5285
R1107 VSS.n552 VSS.t27 3.5285
R1108 VSS.n553 VSS.t18 3.5285
R1109 VSS.n553 VSS.t23 3.5285
R1110 VSS.n554 VSS.t14 3.5285
R1111 VSS.n554 VSS.t19 3.5285
R1112 VSS.n555 VSS.t10 3.5285
R1113 VSS.n555 VSS.t15 3.5285
R1114 VSS.n556 VSS.t6 3.5285
R1115 VSS.n556 VSS.t11 3.5285
R1116 VSS.n557 VSS.t2 3.5285
R1117 VSS.n557 VSS.t7 3.5285
R1118 VSS.n784 VSS.n180 3.48328
R1119 VSS.n14 VSS.t63 8.15032
R1120 VSS.t16 VSS.n10 8.15032
R1121 VSS.n10 VSS.t20 8.14966
R1122 VSS.n62 VSS.n59 3.11744
R1123 VSS.n912 VSS.n911 3.11744
R1124 VSS.n70 VSS.n64 3.11744
R1125 VSS.n905 VSS.n904 3.11744
R1126 VSS.n77 VSS.n71 3.11744
R1127 VSS.n898 VSS.n897 3.11744
R1128 VSS.n84 VSS.n78 3.11744
R1129 VSS.n891 VSS.n890 3.11744
R1130 VSS.n91 VSS.n85 3.11744
R1131 VSS.n884 VSS.n883 3.11744
R1132 VSS.n98 VSS.n92 3.11744
R1133 VSS.n877 VSS.n876 3.11744
R1134 VSS.n105 VSS.n99 3.11744
R1135 VSS.n870 VSS.n869 3.11744
R1136 VSS.n111 VSS.n106 3.11744
R1137 VSS.n415 VSS.n326 3.11744
R1138 VSS.n327 VSS.n325 3.11744
R1139 VSS.n409 VSS.n324 3.11744
R1140 VSS.n405 VSS.n323 3.11744
R1141 VSS.n401 VSS.n322 3.11744
R1142 VSS.n397 VSS.n321 3.11744
R1143 VSS.n393 VSS.n320 3.11744
R1144 VSS.n389 VSS.n319 3.11744
R1145 VSS.n385 VSS.n318 3.11744
R1146 VSS.n381 VSS.n317 3.11744
R1147 VSS.n377 VSS.n316 3.11744
R1148 VSS.n373 VSS.n315 3.11744
R1149 VSS.n369 VSS.n314 3.11744
R1150 VSS.n365 VSS.n313 3.11744
R1151 VSS.n361 VSS.n312 3.11744
R1152 VSS.n277 VSS.n276 3.11744
R1153 VSS.n230 VSS.n225 3.11744
R1154 VSS.n270 VSS.n269 3.11744
R1155 VSS.n237 VSS.n231 3.11744
R1156 VSS.n263 VSS.n262 3.11744
R1157 VSS.n244 VSS.n238 3.11744
R1158 VSS.n256 VSS.n255 3.11744
R1159 VSS.n246 VSS.n245 3.11744
R1160 VSS.n222 VSS.n221 3.11744
R1161 VSS.n306 VSS.n220 3.11744
R1162 VSS.n302 VSS.n219 3.11744
R1163 VSS.n298 VSS.n218 3.11744
R1164 VSS.n294 VSS.n217 3.11744
R1165 VSS.n290 VSS.n216 3.11744
R1166 VSS.n286 VSS.n215 3.11744
R1167 VSS.n282 VSS.n49 3.11744
R1168 VSS.n922 VSS.n49 3.11744
R1169 VSS.n283 VSS.n215 3.11744
R1170 VSS.n287 VSS.n216 3.11744
R1171 VSS.n291 VSS.n217 3.11744
R1172 VSS.n295 VSS.n218 3.11744
R1173 VSS.n299 VSS.n219 3.11744
R1174 VSS.n303 VSS.n220 3.11744
R1175 VSS.n307 VSS.n221 3.11744
R1176 VSS.n245 VSS.n50 3.11744
R1177 VSS.n255 VSS.n254 3.11744
R1178 VSS.n257 VSS.n244 3.11744
R1179 VSS.n262 VSS.n261 3.11744
R1180 VSS.n264 VSS.n237 3.11744
R1181 VSS.n269 VSS.n268 3.11744
R1182 VSS.n271 VSS.n230 3.11744
R1183 VSS.n276 VSS.n275 3.11744
R1184 VSS.n312 VSS.n112 3.11744
R1185 VSS.n362 VSS.n313 3.11744
R1186 VSS.n366 VSS.n314 3.11744
R1187 VSS.n370 VSS.n315 3.11744
R1188 VSS.n374 VSS.n316 3.11744
R1189 VSS.n378 VSS.n317 3.11744
R1190 VSS.n382 VSS.n318 3.11744
R1191 VSS.n386 VSS.n319 3.11744
R1192 VSS.n390 VSS.n320 3.11744
R1193 VSS.n394 VSS.n321 3.11744
R1194 VSS.n398 VSS.n322 3.11744
R1195 VSS.n402 VSS.n323 3.11744
R1196 VSS.n406 VSS.n324 3.11744
R1197 VSS.n410 VSS.n325 3.11744
R1198 VSS.n415 VSS.n414 3.11744
R1199 VSS.n864 VSS.n111 3.11744
R1200 VSS.n869 VSS.n868 3.11744
R1201 VSS.n871 VSS.n105 3.11744
R1202 VSS.n876 VSS.n875 3.11744
R1203 VSS.n878 VSS.n98 3.11744
R1204 VSS.n883 VSS.n882 3.11744
R1205 VSS.n885 VSS.n91 3.11744
R1206 VSS.n890 VSS.n889 3.11744
R1207 VSS.n892 VSS.n84 3.11744
R1208 VSS.n897 VSS.n896 3.11744
R1209 VSS.n899 VSS.n77 3.11744
R1210 VSS.n904 VSS.n903 3.11744
R1211 VSS.n906 VSS.n70 3.11744
R1212 VSS.n911 VSS.n910 3.11744
R1213 VSS.n913 VSS.n62 3.11744
R1214 VSS.t43 VSS.n3 4.40201
R1215 VSS.t47 VSS.n2 4.39175
R1216 VSS.t60 VSS.n15 6.80683
R1217 VSS.n20 VSS.t63 6.80683
R1218 VSS.n32 VSS.t16 6.80683
R1219 VSS.n16 VSS.t36 4.35461
R1220 VSS.n350 VSS.n191 1.8905
R1221 VSS.n784 VSS.n783 1.65236
R1222 VSS.n12 VSS.t51 6.40824
R1223 VSS.t57 VSS.n19 5.50129
R1224 VSS.n21 VSS.t66 5.50129
R1225 VSS.n31 VSS.t12 5.50129
R1226 VSS.t24 VSS.n558 1.12358
R1227 VSS.n36 VSS.t32 5.50129
R1228 VSS.n63 VSS.n62 1.04278
R1229 VSS.n911 VSS.n63 1.04278
R1230 VSS.n70 VSS.n63 1.04278
R1231 VSS.n904 VSS.n63 1.04278
R1232 VSS.n77 VSS.n63 1.04278
R1233 VSS.n897 VSS.n63 1.04278
R1234 VSS.n84 VSS.n63 1.04278
R1235 VSS.n890 VSS.n63 1.04278
R1236 VSS.n91 VSS.n63 1.04278
R1237 VSS.n883 VSS.n63 1.04278
R1238 VSS.n98 VSS.n63 1.04278
R1239 VSS.n876 VSS.n63 1.04278
R1240 VSS.n105 VSS.n63 1.04278
R1241 VSS.n869 VSS.n63 1.04278
R1242 VSS.n111 VSS.n63 1.04278
R1243 VSS.n416 VSS.n415 1.04278
R1244 VSS.n416 VSS.n325 1.04278
R1245 VSS.n416 VSS.n324 1.04278
R1246 VSS.n416 VSS.n323 1.04278
R1247 VSS.n416 VSS.n322 1.04278
R1248 VSS.n416 VSS.n321 1.04278
R1249 VSS.n416 VSS.n320 1.04278
R1250 VSS.n416 VSS.n319 1.04278
R1251 VSS.n416 VSS.n318 1.04278
R1252 VSS.n416 VSS.n317 1.04278
R1253 VSS.n416 VSS.n316 1.04278
R1254 VSS.n416 VSS.n315 1.04278
R1255 VSS.n416 VSS.n314 1.04278
R1256 VSS.n416 VSS.n313 1.04278
R1257 VSS.n416 VSS.n312 1.04278
R1258 VSS.n276 VSS.n53 1.04278
R1259 VSS.n230 VSS.n53 1.04278
R1260 VSS.n269 VSS.n53 1.04278
R1261 VSS.n237 VSS.n53 1.04278
R1262 VSS.n262 VSS.n53 1.04278
R1263 VSS.n244 VSS.n53 1.04278
R1264 VSS.n255 VSS.n53 1.04278
R1265 VSS.n245 VSS.n53 1.04278
R1266 VSS.n311 VSS.n221 1.04278
R1267 VSS.n311 VSS.n220 1.04278
R1268 VSS.n311 VSS.n219 1.04278
R1269 VSS.n311 VSS.n218 1.04278
R1270 VSS.n311 VSS.n217 1.04278
R1271 VSS.n311 VSS.n216 1.04278
R1272 VSS.n311 VSS.n215 1.04278
R1273 VSS.n311 VSS.n49 1.04278
R1274 VSS.n3 VSS.t42 4.47906
R1275 VSS.n1 VSS.n0 0.0321528
R1276 VSS.n921 VSS.n920 0.217167
R1277 VSS.n921 VSS.n51 0.217167
R1278 VSS.n920 VSS.n54 0.217167
R1279 VSS.n281 VSS.n54 0.217167
R1280 VSS.n764 VSS.n188 0.186214
R1281 VSS.n765 VSS.n764 0.186214
R1282 VSS.n622 VSS.n621 0.186214
R1283 VSS.n621 VSS.n620 0.186214
R1284 VSS.n788 VSS.n787 0.1445
R1285 VSS.n788 VSS.n173 0.1445
R1286 VSS.n792 VSS.n173 0.1445
R1287 VSS.n793 VSS.n792 0.1445
R1288 VSS.n794 VSS.n793 0.1445
R1289 VSS.n794 VSS.n168 0.1445
R1290 VSS.n798 VSS.n168 0.1445
R1291 VSS.n799 VSS.n798 0.1445
R1292 VSS.n800 VSS.n799 0.1445
R1293 VSS.n800 VSS.n163 0.1445
R1294 VSS.n804 VSS.n163 0.1445
R1295 VSS.n805 VSS.n804 0.1445
R1296 VSS.n806 VSS.n805 0.1445
R1297 VSS.n806 VSS.n158 0.1445
R1298 VSS.n810 VSS.n158 0.1445
R1299 VSS.n811 VSS.n810 0.1445
R1300 VSS.n812 VSS.n811 0.1445
R1301 VSS.n812 VSS.n153 0.1445
R1302 VSS.n816 VSS.n153 0.1445
R1303 VSS.n817 VSS.n816 0.1445
R1304 VSS.n818 VSS.n817 0.1445
R1305 VSS.n818 VSS.n148 0.1445
R1306 VSS.n822 VSS.n148 0.1445
R1307 VSS VSS.n822 0.1445
R1308 VSS.n823 VSS 0.1445
R1309 VSS.n824 VSS.n823 0.1445
R1310 VSS.n824 VSS.n142 0.1445
R1311 VSS.n828 VSS.n142 0.1445
R1312 VSS.n829 VSS.n828 0.1445
R1313 VSS.n830 VSS.n829 0.1445
R1314 VSS.n830 VSS.n137 0.1445
R1315 VSS.n834 VSS.n137 0.1445
R1316 VSS.n835 VSS.n834 0.1445
R1317 VSS.n836 VSS.n835 0.1445
R1318 VSS.n836 VSS.n132 0.1445
R1319 VSS.n840 VSS.n132 0.1445
R1320 VSS.n841 VSS.n840 0.1445
R1321 VSS.n842 VSS.n841 0.1445
R1322 VSS.n842 VSS.n127 0.1445
R1323 VSS.n846 VSS.n127 0.1445
R1324 VSS.n847 VSS.n846 0.1445
R1325 VSS.n848 VSS.n847 0.1445
R1326 VSS.n848 VSS.n122 0.1445
R1327 VSS.n852 VSS.n122 0.1445
R1328 VSS.n853 VSS.n852 0.1445
R1329 VSS.n854 VSS.n853 0.1445
R1330 VSS.n854 VSS.n118 0.1445
R1331 VSS.n858 VSS.n118 0.1445
R1332 VSS.n779 VSS.n178 0.1445
R1333 VSS.n779 VSS.n778 0.1445
R1334 VSS.n778 VSS.n777 0.1445
R1335 VSS.n777 VSS.n185 0.1445
R1336 VSS.n768 VSS.n185 0.1445
R1337 VSS.n768 VSS.n767 0.1445
R1338 VSS.n758 VSS.n22 0.1445
R1339 VSS.n758 VSS.n757 0.1445
R1340 VSS.n757 VSS.n756 0.1445
R1341 VSS.n756 VSS.n201 0.1445
R1342 VSS.n738 VSS.n201 0.1445
R1343 VSS.n738 VSS.n737 0.1445
R1344 VSS.n737 VSS.n736 0.1445
R1345 VSS.n736 VSS.n420 0.1445
R1346 VSS.n723 VSS.n420 0.1445
R1347 VSS.n723 VSS.n722 0.1445
R1348 VSS.n722 VSS.n721 0.1445
R1349 VSS.n721 VSS.n436 0.1445
R1350 VSS.n707 VSS.n436 0.1445
R1351 VSS.n707 VSS.n706 0.1445
R1352 VSS.n706 VSS.n705 0.1445
R1353 VSS.n705 VSS.n451 0.1445
R1354 VSS.n691 VSS.n451 0.1445
R1355 VSS.n691 VSS.n690 0.1445
R1356 VSS.n690 VSS.n689 0.1445
R1357 VSS.n689 VSS.n467 0.1445
R1358 VSS.n675 VSS.n467 0.1445
R1359 VSS.n675 VSS.n674 0.1445
R1360 VSS.n674 VSS.n673 0.1445
R1361 VSS.n673 VSS.n480 0.1445
R1362 VSS.n660 VSS.n480 0.1445
R1363 VSS.n660 VSS.n659 0.1445
R1364 VSS.n659 VSS.n658 0.1445
R1365 VSS.n658 VSS.n497 0.1445
R1366 VSS.n644 VSS.n497 0.1445
R1367 VSS.n644 VSS.n643 0.1445
R1368 VSS.n643 VSS.n642 0.1445
R1369 VSS.n642 VSS.n512 0.1445
R1370 VSS.n628 VSS.n512 0.1445
R1371 VSS.n628 VSS.n627 0.1445
R1372 VSS.n627 VSS.n626 0.1445
R1373 VSS.n626 VSS.n526 0.1445
R1374 VSS.n543 VSS.n526 0.1445
R1375 VSS.n543 VSS.n542 0.1445
R1376 VSS.n542 VSS.n541 0.1445
R1377 VSS.n541 VSS.n533 0.1445
R1378 VSS.n533 VSS.n117 0.1445
R1379 VSS.n780 VSS.n184 0.1445
R1380 VSS.n780 VSS.n183 0.1445
R1381 VSS.n776 VSS.n183 0.1445
R1382 VSS.n776 VSS.n186 0.1445
R1383 VSS.n769 VSS.n186 0.1445
R1384 VSS.n769 VSS.n190 0.1445
R1385 VSS.n760 VSS.n190 0.1445
R1386 VSS.n760 VSS.n759 0.1445
R1387 VSS.n759 VSS.n200 0.1445
R1388 VSS.n755 VSS.n200 0.1445
R1389 VSS.n755 VSS.n202 0.1445
R1390 VSS.n739 VSS.n202 0.1445
R1391 VSS.n739 VSS.n419 0.1445
R1392 VSS.n735 VSS.n419 0.1445
R1393 VSS.n735 VSS.n421 0.1445
R1394 VSS.n724 VSS.n421 0.1445
R1395 VSS.n724 VSS.n435 0.1445
R1396 VSS.n720 VSS.n435 0.1445
R1397 VSS.n720 VSS.n437 0.1445
R1398 VSS.n708 VSS.n437 0.1445
R1399 VSS.n708 VSS.n450 0.1445
R1400 VSS.n704 VSS.n450 0.1445
R1401 VSS.n704 VSS.n452 0.1445
R1402 VSS.n692 VSS.n452 0.1445
R1403 VSS.n692 VSS.n466 0.1445
R1404 VSS.n688 VSS.n466 0.1445
R1405 VSS.n688 VSS.n468 0.1445
R1406 VSS.n676 VSS.n468 0.1445
R1407 VSS.n676 VSS.n479 0.1445
R1408 VSS.n672 VSS.n479 0.1445
R1409 VSS.n672 VSS.n481 0.1445
R1410 VSS.n661 VSS.n481 0.1445
R1411 VSS.n661 VSS.n496 0.1445
R1412 VSS.n657 VSS.n496 0.1445
R1413 VSS.n657 VSS.n498 0.1445
R1414 VSS.n645 VSS.n498 0.1445
R1415 VSS.n645 VSS.n511 0.1445
R1416 VSS.n641 VSS.n511 0.1445
R1417 VSS.n641 VSS.n513 0.1445
R1418 VSS.n629 VSS.n513 0.1445
R1419 VSS.n629 VSS.n525 0.1445
R1420 VSS.n625 VSS.n525 0.1445
R1421 VSS.n625 VSS.n527 0.1445
R1422 VSS.n544 VSS.n527 0.1445
R1423 VSS.n544 VSS.n532 0.1445
R1424 VSS.n540 VSS.n532 0.1445
R1425 VSS.n540 VSS.n535 0.1445
R1426 VSS.n535 VSS.n534 0.1445
R1427 VSS.n923 VSS.n48 0.1445
R1428 VSS.n284 VSS.n23 0.0718661
R1429 VSS.n285 VSS.n284 0.1445
R1430 VSS.n288 VSS.n24 0.0718661
R1431 VSS.n289 VSS.n288 0.1445
R1432 VSS.n292 VSS.n25 0.0718661
R1433 VSS.n293 VSS.n292 0.1445
R1434 VSS.n296 VSS.n26 0.0718661
R1435 VSS.n297 VSS.n296 0.1445
R1436 VSS.n300 VSS.n27 0.0718661
R1437 VSS.n301 VSS.n300 0.1445
R1438 VSS.n304 VSS.n28 0.0718661
R1439 VSS.n305 VSS.n304 0.1445
R1440 VSS.n308 VSS.n29 0.0718661
R1441 VSS.n309 VSS.n308 0.1445
R1442 VSS.n310 VSS.n17 5.27187
R1443 VSS.n250 VSS.n249 0.1445
R1444 VSS.n249 VSS.n248 0.1445
R1445 VSS.n248 VSS.n247 0.1445
R1446 VSS.n247 VSS.n242 0.1445
R1447 VSS.n242 VSS.n241 0.1445
R1448 VSS.n241 VSS.n240 0.1445
R1449 VSS.n240 VSS.n239 0.1445
R1450 VSS.n239 VSS.n235 0.1445
R1451 VSS.n235 VSS.n234 0.1445
R1452 VSS.n234 VSS.n233 0.1445
R1453 VSS.n233 VSS.n232 0.1445
R1454 VSS.n232 VSS.n228 0.1445
R1455 VSS.n228 VSS.n227 0.1445
R1456 VSS.n227 VSS.n226 0.1445
R1457 VSS.n226 VSS.n223 0.1445
R1458 VSS.n280 VSS.n223 0.1445
R1459 VSS.n252 VSS.n251 0.1445
R1460 VSS.n253 VSS.n252 0.1445
R1461 VSS.n253 VSS.n243 0.1445
R1462 VSS.n258 VSS.n243 0.1445
R1463 VSS.n259 VSS.n258 0.1445
R1464 VSS.n260 VSS.n259 0.1445
R1465 VSS.n260 VSS.n236 0.1445
R1466 VSS.n265 VSS.n236 0.1445
R1467 VSS.n266 VSS.n265 0.1445
R1468 VSS.n267 VSS.n266 0.1445
R1469 VSS.n267 VSS.n229 0.1445
R1470 VSS.n272 VSS.n229 0.1445
R1471 VSS.n273 VSS.n272 0.1445
R1472 VSS.n274 VSS.n273 0.1445
R1473 VSS.n274 VSS.n224 0.1445
R1474 VSS.n279 VSS.n224 0.1445
R1475 VSS.n360 VSS.n359 0.1445
R1476 VSS.n363 VSS.n360 0.1445
R1477 VSS.n364 VSS.n363 0.1445
R1478 VSS.n367 VSS.n364 0.1445
R1479 VSS.n368 VSS.n367 0.1445
R1480 VSS.n371 VSS.n368 0.1445
R1481 VSS.n372 VSS.n371 0.1445
R1482 VSS.n375 VSS.n372 0.1445
R1483 VSS.n376 VSS.n375 0.1445
R1484 VSS.n379 VSS.n376 0.1445
R1485 VSS.n380 VSS.n379 0.1445
R1486 VSS.n383 VSS.n380 0.1445
R1487 VSS.n384 VSS.n383 0.1445
R1488 VSS.n387 VSS.n384 0.1445
R1489 VSS.n388 VSS.n387 0.1445
R1490 VSS.n391 VSS.n388 0.1445
R1491 VSS.n392 VSS.n391 0.1445
R1492 VSS.n395 VSS.n392 0.1445
R1493 VSS.n396 VSS.n395 0.1445
R1494 VSS.n399 VSS.n396 0.1445
R1495 VSS.n400 VSS.n399 0.1445
R1496 VSS.n403 VSS.n400 0.1445
R1497 VSS.n404 VSS.n403 0.1445
R1498 VSS.n407 VSS.n404 0.1445
R1499 VSS.n408 VSS.n407 0.1445
R1500 VSS.n411 VSS.n408 0.1445
R1501 VSS.n412 VSS.n411 0.1445
R1502 VSS.n413 VSS.n412 0.1445
R1503 VSS.n413 VSS.n329 0.1445
R1504 VSS.n329 VSS.n328 0.1445
R1505 VSS.n358 VSS.n357 0.1445
R1506 VSS.n357 VSS.n356 0.1445
R1507 VSS.n356 VSS.n355 0.1445
R1508 VSS.n355 VSS.n354 0.1445
R1509 VSS.n354 VSS.n353 0.1445
R1510 VSS.n353 VSS.n352 0.1445
R1511 VSS.n352 VSS.n351 0.1445
R1512 VSS.n351 VSS.n47 0.1445
R1513 VSS.n46 VSS.n349 0.1445
R1514 VSS.n349 VSS.n348 0.1445
R1515 VSS.n348 VSS.n347 0.1445
R1516 VSS.n347 VSS.n346 0.1445
R1517 VSS.n346 VSS.n345 0.1445
R1518 VSS.n345 VSS.n344 0.1445
R1519 VSS.n344 VSS.n343 0.1445
R1520 VSS.n343 VSS.n342 0.1445
R1521 VSS.n342 VSS.n341 0.1445
R1522 VSS.n341 VSS.n340 0.1445
R1523 VSS.n340 VSS.n339 0.1445
R1524 VSS.n339 VSS.n338 0.1445
R1525 VSS.n338 VSS.n337 0.1445
R1526 VSS.n337 VSS.n336 0.1445
R1527 VSS.n336 VSS.n335 0.1445
R1528 VSS.n335 VSS.n334 0.1445
R1529 VSS.n334 VSS.n333 0.1445
R1530 VSS.n333 VSS.n332 0.1445
R1531 VSS.n332 VSS.n331 0.1445
R1532 VSS.n331 VSS.n330 0.1445
R1533 VSS.n330 VSS.n57 0.1445
R1534 VSS.n748 VSS.n192 0.1445
R1535 VSS.n748 VSS.n747 0.1445
R1536 VSS.n747 VSS.n746 0.1445
R1537 VSS.n746 VSS.n745 0.1445
R1538 VSS.n745 VSS.n744 0.1445
R1539 VSS.n744 VSS.n210 0.1445
R1540 VSS.n730 VSS.n210 0.1445
R1541 VSS.n730 VSS.n729 0.1445
R1542 VSS.n729 VSS.n728 0.1445
R1543 VSS.n728 VSS.n428 0.1445
R1544 VSS.n715 VSS.n428 0.1445
R1545 VSS.n715 VSS.n714 0.1445
R1546 VSS.n714 VSS.n713 0.1445
R1547 VSS.n713 VSS.n443 0.1445
R1548 VSS.n699 VSS.n443 0.1445
R1549 VSS.n699 VSS.n698 0.1445
R1550 VSS.n698 VSS.n697 0.1445
R1551 VSS.n697 VSS.n457 0.1445
R1552 VSS.n683 VSS.n457 0.1445
R1553 VSS.n683 VSS.n682 0.1445
R1554 VSS.n682 VSS.n681 0.1445
R1555 VSS.n681 VSS.n474 0.1445
R1556 VSS.n667 VSS.n474 0.1445
R1557 VSS.n667 VSS.n666 0.1445
R1558 VSS.n666 VSS.n665 0.1445
R1559 VSS.n665 VSS.n488 0.1445
R1560 VSS.n652 VSS.n488 0.1445
R1561 VSS.n652 VSS.n651 0.1445
R1562 VSS.n651 VSS.n650 0.1445
R1563 VSS.n650 VSS.n504 0.1445
R1564 VSS.n636 VSS.n504 0.1445
R1565 VSS.n636 VSS.n635 0.1445
R1566 VSS.n635 VSS.n634 0.1445
R1567 VSS.n634 VSS.n518 0.1445
R1568 VSS.n749 VSS.n195 0.1445
R1569 VSS.n750 VSS.n749 0.1445
R1570 VSS.n751 VSS.n750 0.1445
R1571 VSS.n751 VSS.n209 0.1445
R1572 VSS.n743 VSS.n209 0.1445
R1573 VSS.n743 VSS.n211 0.1445
R1574 VSS.n731 VSS.n211 0.1445
R1575 VSS.n731 VSS.n427 0.1445
R1576 VSS.n727 VSS.n427 0.1445
R1577 VSS.n727 VSS.n429 0.1445
R1578 VSS.n716 VSS.n429 0.1445
R1579 VSS.n716 VSS.n442 0.1445
R1580 VSS.n712 VSS.n442 0.1445
R1581 VSS.n712 VSS.n444 0.1445
R1582 VSS.n700 VSS.n444 0.1445
R1583 VSS.n700 VSS.n456 0.1445
R1584 VSS.n696 VSS.n456 0.1445
R1585 VSS.n696 VSS.n458 0.1445
R1586 VSS.n684 VSS.n458 0.1445
R1587 VSS.n684 VSS.n473 0.1445
R1588 VSS.n680 VSS.n473 0.1445
R1589 VSS.n680 VSS.n475 0.1445
R1590 VSS.n668 VSS.n475 0.1445
R1591 VSS.n668 VSS.n487 0.1445
R1592 VSS.n664 VSS.n487 0.1445
R1593 VSS.n664 VSS.n489 0.1445
R1594 VSS.n653 VSS.n489 0.1445
R1595 VSS.n653 VSS.n503 0.1445
R1596 VSS.n649 VSS.n503 0.1445
R1597 VSS.n649 VSS.n505 0.1445
R1598 VSS.n637 VSS.n505 0.1445
R1599 VSS.n637 VSS.n517 0.1445
R1600 VSS.n633 VSS.n517 0.1445
R1601 VSS.n633 VSS.n519 0.1445
R1602 VSS.n11 VSS.n193 5.27187
R1603 VSS.n572 VSS.n568 0.1445
R1604 VSS.n573 VSS.n30 0.0718661
R1605 VSS.n575 VSS.n573 0.1445
R1606 VSS.n576 VSS.n41 0.0718661
R1607 VSS.n578 VSS.n576 0.1445
R1608 VSS.n579 VSS.n578 0.1445
R1609 VSS.n581 VSS.n45 0.0718661
R1610 VSS.n582 VSS.n581 0.1445
R1611 VSS.n584 VSS.n582 0.1445
R1612 VSS.n585 VSS.n44 0.0718661
R1613 VSS.n587 VSS.n585 0.1445
R1614 VSS.n588 VSS.n587 0.1445
R1615 VSS.n590 VSS.n40 0.0718661
R1616 VSS.n591 VSS.n590 0.1445
R1617 VSS.n593 VSS.n591 0.1445
R1618 VSS.n594 VSS.n33 0.0718661
R1619 VSS.n596 VSS.n594 0.1445
R1620 VSS.n597 VSS.n34 0.0718661
R1621 VSS.n599 VSS.n597 0.1445
R1622 VSS.n600 VSS.n39 0.0718661
R1623 VSS.n602 VSS.n600 0.1445
R1624 VSS.n603 VSS.n602 0.1445
R1625 VSS.n605 VSS.n43 0.0718661
R1626 VSS.n606 VSS.n605 0.1445
R1627 VSS.n608 VSS.n606 0.1445
R1628 VSS.n609 VSS.n42 0.0718661
R1629 VSS.n611 VSS.n609 0.1445
R1630 VSS.n612 VSS.n611 0.1445
R1631 VSS.n614 VSS.n38 0.0718661
R1632 VSS.n615 VSS.n614 0.1445
R1633 VSS.n618 VSS.n37 0.0718661
R1634 VSS.n619 VSS.n618 0.1445
R1635 VSS.n110 VSS.n109 0.1445
R1636 VSS.n109 VSS.n108 0.1445
R1637 VSS.n108 VSS.n107 0.1445
R1638 VSS.n107 VSS.n103 0.1445
R1639 VSS.n103 VSS.n102 0.1445
R1640 VSS.n102 VSS.n101 0.1445
R1641 VSS.n101 VSS.n100 0.1445
R1642 VSS.n100 VSS.n96 0.1445
R1643 VSS.n96 VSS.n95 0.1445
R1644 VSS.n95 VSS.n94 0.1445
R1645 VSS.n94 VSS.n93 0.1445
R1646 VSS.n93 VSS.n89 0.1445
R1647 VSS.n89 VSS.n88 0.1445
R1648 VSS.n88 VSS.n87 0.1445
R1649 VSS.n87 VSS.n86 0.1445
R1650 VSS.n86 VSS.n82 0.1445
R1651 VSS.n82 VSS.n81 0.1445
R1652 VSS.n81 VSS.n80 0.1445
R1653 VSS.n80 VSS.n79 0.1445
R1654 VSS.n79 VSS.n75 0.1445
R1655 VSS.n75 VSS.n74 0.1445
R1656 VSS.n74 VSS.n73 0.1445
R1657 VSS.n73 VSS.n72 0.1445
R1658 VSS.n72 VSS.n68 0.1445
R1659 VSS.n68 VSS.n67 0.1445
R1660 VSS.n67 VSS.n66 0.1445
R1661 VSS.n66 VSS.n65 0.1445
R1662 VSS.n65 VSS.n60 0.1445
R1663 VSS.n60 VSS.n58 0.1445
R1664 VSS.n917 VSS.n58 0.1445
R1665 VSS.n866 VSS.n865 0.1445
R1666 VSS.n867 VSS.n866 0.1445
R1667 VSS.n867 VSS.n104 0.1445
R1668 VSS.n872 VSS.n104 0.1445
R1669 VSS.n873 VSS.n872 0.1445
R1670 VSS.n874 VSS.n873 0.1445
R1671 VSS.n874 VSS.n97 0.1445
R1672 VSS.n879 VSS.n97 0.1445
R1673 VSS.n880 VSS.n879 0.1445
R1674 VSS.n881 VSS.n880 0.1445
R1675 VSS.n881 VSS.n90 0.1445
R1676 VSS.n886 VSS.n90 0.1445
R1677 VSS.n887 VSS.n886 0.1445
R1678 VSS.n888 VSS.n887 0.1445
R1679 VSS.n888 VSS.n83 0.1445
R1680 VSS.n893 VSS.n83 0.1445
R1681 VSS.n894 VSS.n893 0.1445
R1682 VSS.n895 VSS.n894 0.1445
R1683 VSS.n895 VSS.n76 0.1445
R1684 VSS.n900 VSS.n76 0.1445
R1685 VSS.n901 VSS.n900 0.1445
R1686 VSS.n902 VSS.n901 0.1445
R1687 VSS.n902 VSS.n69 0.1445
R1688 VSS.n907 VSS.n69 0.1445
R1689 VSS.n908 VSS.n907 0.1445
R1690 VSS.n909 VSS.n908 0.1445
R1691 VSS.n909 VSS.n61 0.1445
R1692 VSS.n914 VSS.n61 0.1445
R1693 VSS.n915 VSS.n914 0.1445
R1694 VSS.n916 VSS.n915 0.1445
R1695 VSS.n789 VSS.n177 0.1445
R1696 VSS.n790 VSS.n789 0.1445
R1697 VSS.n791 VSS.n790 0.1445
R1698 VSS.n791 VSS.n172 0.1445
R1699 VSS.n795 VSS.n172 0.1445
R1700 VSS.n796 VSS.n795 0.1445
R1701 VSS.n797 VSS.n796 0.1445
R1702 VSS.n797 VSS.n167 0.1445
R1703 VSS.n801 VSS.n167 0.1445
R1704 VSS.n802 VSS.n801 0.1445
R1705 VSS.n803 VSS.n802 0.1445
R1706 VSS.n803 VSS.n162 0.1445
R1707 VSS.n807 VSS.n162 0.1445
R1708 VSS.n808 VSS.n807 0.1445
R1709 VSS.n809 VSS.n808 0.1445
R1710 VSS.n809 VSS.n157 0.1445
R1711 VSS.n813 VSS.n157 0.1445
R1712 VSS.n814 VSS.n813 0.1445
R1713 VSS.n815 VSS.n814 0.1445
R1714 VSS.n815 VSS.n152 0.1445
R1715 VSS.n819 VSS.n152 0.1445
R1716 VSS.n820 VSS.n819 0.1445
R1717 VSS.n821 VSS.n820 0.1445
R1718 VSS.n821 VSS.n147 0.1445
R1719 VSS.n147 VSS.n146 0.1445
R1720 VSS.n825 VSS.n146 0.1445
R1721 VSS.n826 VSS.n825 0.1445
R1722 VSS.n827 VSS.n826 0.1445
R1723 VSS.n827 VSS.n141 0.1445
R1724 VSS.n831 VSS.n141 0.1445
R1725 VSS.n832 VSS.n831 0.1445
R1726 VSS.n833 VSS.n832 0.1445
R1727 VSS.n833 VSS.n136 0.1445
R1728 VSS.n837 VSS.n136 0.1445
R1729 VSS.n838 VSS.n837 0.1445
R1730 VSS.n839 VSS.n838 0.1445
R1731 VSS.n839 VSS.n131 0.1445
R1732 VSS.n843 VSS.n131 0.1445
R1733 VSS.n844 VSS.n843 0.1445
R1734 VSS.n845 VSS.n844 0.1445
R1735 VSS.n845 VSS.n126 0.1445
R1736 VSS.n849 VSS.n126 0.1445
R1737 VSS.n850 VSS.n849 0.1445
R1738 VSS.n851 VSS.n850 0.1445
R1739 VSS.n851 VSS.n121 0.1445
R1740 VSS.n855 VSS.n121 0.1445
R1741 VSS.n856 VSS.n855 0.1445
R1742 VSS.n857 VSS.n856 0.1445
R1743 VSS.n47 VSS.n46 0.1445
R1744 VSS.n767 VSS.n22 0.1445
R1745 VSS.n863 VSS.n862 0.111138
R1746 VSS.n863 VSS.n113 0.111138
R1747 VSS.n920 VSS.n919 0.111138
R1748 VSS.n919 VSS.n918 0.111138
R1749 VSS.n861 VSS.n860 0.1005
R1750 VSS.n860 VSS.n859 0.1005
R1751 VSS.n786 VSS.n785 0.1005
R1752 VSS.n2 VSS.n1 0.0505905
R1753 VSS.n9 VSS.n3 1.37569
R1754 VSS.n7 VSS.t75 5.28558
R1755 VSS.n27 VSS.n4 2.46267
R1756 VSS.n3 VSS.n2 0.464387
R1757 VSS.n3 VSS.n0 0.428493
R1758 VSS.n1 VSS.t46 4.50832
C0 a_4290_5175# Isum 1.10822f
C1 a_190_n489# VDD 1.17197f
C2 VDD Vthr 1.35931f
C3 VT VDD 1.82314f
C4 Iout a_4290_5175# 2.51065f
C5 VDD Isum 4.30978f
C6 a_190_n489# a_4290_5175# 4.39172f
C7 VDD a_4290_5175# 2.31138f
C8 Iout VSS 12.59434f
C9 VDD VSS 1.56645f
C10 a_190_n489# VSS 1.56645f
C11 VSS.t79 VSS 7.46915f
.ends
