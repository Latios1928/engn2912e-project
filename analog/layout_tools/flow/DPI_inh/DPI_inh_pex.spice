* NGSPICE file created from DPI_inh_flat.ext - technology: gf180mcuD

.subckt DPI_inh_flat Vthr Isum Iout VT VSS VDD
X0 VSS.t20 VSS.t19 VSS.t20 VSS.t1 nfet_03v3 ad=0.14p pd=1.06u as=0 ps=0 w=0.5u l=2u
X1 VDD.t25 VDD.t23 VDD.t25 VDD.t24 pfet_03v3 ad=0.14p pd=1.06u as=0 ps=0 w=0.5u l=2u
X2 VSS.t4 VSS.t3 VSS.t4 VSS.t1 nfet_03v3 ad=0.14p pd=1.06u as=0 ps=0 w=0.5u l=2u
X3 VDD.t22 VDD.t20 VDD.t22 VDD.t21 pfet_03v3 ad=0.14p pd=1.06u as=0 ps=0 w=0.5u l=2u
X4 VSS.t16 VSS.t15 VSS.t16 VSS.t1 nfet_03v3 ad=0.14p pd=1.06u as=0 ps=0 w=0.5u l=2u
X5 Isum.t31 Isum.t29 Isum.t31 Isum.t30 nfet_03v3 ad=2.4p pd=9.2u as=0 ps=0 w=4u l=2u
X6 Isum.t35 Isum.t34 Isum.t35 Isum.t6 nfet_03v3 ad=0.14p pd=1.06u as=0 ps=0 w=0.5u l=2u
X7 VSS.t46 VSS.t45 VSS.t46 VSS.t27 nfet_03v3 ad=0.14p pd=1.06u as=0 ps=0 w=0.5u l=2u
X8 VSS.t2 VSS.t0 VSS.t2 VSS.t1 nfet_03v3 ad=0.3p pd=2.2u as=0 ps=0 w=0.5u l=2u
X9 VSS.t34 VSS.t33 VSS.t34 VSS.t27 nfet_03v3 ad=0.14p pd=1.06u as=0 ps=0 w=0.5u l=2u
X10 VDD.t42 VDD.t41 VDD.t42 VDD.t15 pfet_03v3 ad=0.14p pd=1.06u as=0 ps=0 w=0.5u l=2u
X11 VDD.t7 VDD.t5 VDD.t7 VDD.t6 pfet_03v3 ad=0.3p pd=2.2u as=0 ps=0 w=0.5u l=2u
X12 VDD.t13 VDD.t11 VDD.t13 VDD.t12 pfet_03v3 ad=0.14p pd=1.06u as=0 ps=0 w=0.5u l=2u
X13 VSS.t6 VSS.t5 VSS.t6 VSS.t1 nfet_03v3 ad=0.14p pd=1.06u as=0 ps=0 w=0.5u l=2u
X14 VSS.t25 VSS.t24 VSS.t25 VSS.t22 nfet_03v3 ad=1.44p pd=6u as=0 ps=0 w=2.4u l=2u
X15 Isum.t28 Isum.t26 Isum.t28 Isum.t27 nfet_03v3 ad=2.4p pd=9.2u as=0 ps=0 w=4u l=2u
X16 VDD.t10 VDD.t8 VDD.t10 VDD.t9 pfet_03v3 ad=0.14p pd=1.06u as=0 ps=0 w=0.5u l=2u
X17 Isum.t13 Isum.t11 Isum.t13 Isum.t12 nfet_03v3 ad=0.14p pd=1.06u as=0 ps=0 w=0.5u l=2u
X18 VDD.t2 VT.t0 a_4290_5335# VDD.t1 pfet_03v3 ad=2.4p pd=9.2u as=2.4p ps=9.2u w=4u l=5.12u
X19 Isum.t45 Isum.t44 Isum.t45 Isum.t21 nfet_03v3 ad=0.14p pd=1.06u as=0 ps=0 w=0.5u l=2u
X20 VDD.t28 VDD.t26 VDD.t28 VDD.t27 pfet_03v3 ad=0.14p pd=1.06u as=0 ps=0 w=0.5u l=2u
X21 VDD.t4 a_4290_5335# a_190_n489# VDD.t3 pfet_03v3 ad=2.4p pd=9.2u as=2.4p ps=9.2u w=4u l=5.12u
X22 VDD.t44 VDD.t43 VDD.t44 VDD.t18 pfet_03v3 ad=0.14p pd=1.06u as=0 ps=0 w=0.5u l=2u
X23 Isum.t39 Isum.t38 Isum.t39 Isum.t12 nfet_03v3 ad=0.14p pd=1.06u as=0 ps=0 w=0.5u l=2u
X24 VSS.t38 VSS.t37 VSS.t38 VSS.t27 nfet_03v3 ad=0.14p pd=1.06u as=0 ps=0 w=0.5u l=2u
X25 VDD.t51 a_4290_5335# cap_mim_2f0_m4m5_noshield c_width=22.18u c_length=22.18u
X26 Iout.t0 a_190_n489# VSS.t47 VSS.t22 nfet_03v3 ad=1.44p pd=6u as=1.44p ps=6u w=2.4u l=8u
X27 VSS.t40 VSS.t39 VSS.t40 VSS.t27 nfet_03v3 ad=0.14p pd=1.06u as=0 ps=0 w=0.5u l=2u
X28 Isum.t33 Isum.t32 Isum.t33 Isum.t3 nfet_03v3 ad=0.3p pd=2.2u as=0 ps=0 w=0.5u l=2u
X29 VSS.t10 VSS.t9 VSS.t10 VSS.t1 nfet_03v3 ad=0.14p pd=1.06u as=0 ps=0 w=0.5u l=2u
X30 VSS.t44 VSS.t43 VSS.t44 VSS.t27 nfet_03v3 ad=0.14p pd=1.06u as=0 ps=0 w=0.5u l=2u
X31 Isum.t16 Isum.t14 Isum.t16 Isum.t15 nfet_03v3 ad=0.14p pd=1.06u as=0 ps=0 w=0.5u l=2u
X32 VDD.t16 VDD.t14 VDD.t16 VDD.t15 pfet_03v3 ad=0.14p pd=1.06u as=0 ps=0 w=0.5u l=2u
X33 VSS.t23 VSS.t21 VSS.t23 VSS.t22 nfet_03v3 ad=1.44p pd=6u as=0 ps=0 w=2.4u l=2u
X34 VSS.t30 VSS.t29 VSS.t30 VSS.t27 nfet_03v3 ad=0.14p pd=1.06u as=0 ps=0 w=0.5u l=2u
X35 VDD.t0 Vthr.t0 Isum.t1 Isum.t0 nfet_03v3 ad=2.4p pd=9.2u as=2.4p ps=9.2u w=4u l=5.12u
X36 VSS.t32 VSS.t31 VSS.t32 VSS.t27 nfet_03v3 ad=0.14p pd=1.06u as=0 ps=0 w=0.5u l=2u
X37 Isum.t22 Isum.t20 Isum.t22 Isum.t21 nfet_03v3 ad=0.14p pd=1.06u as=0 ps=0 w=0.5u l=2u
X38 Isum.t43 Isum.t42 Isum.t43 Isum.t18 nfet_03v3 ad=0.14p pd=1.06u as=0 ps=0 w=0.5u l=2u
X39 Isum.t19 Isum.t17 Isum.t19 Isum.t18 nfet_03v3 ad=0.14p pd=1.06u as=0 ps=0 w=0.5u l=2u
X40 VDD.t31 VDD.t29 VDD.t31 VDD.t30 pfet_03v3 ad=2.4p pd=9.2u as=0 ps=0 w=4u l=2u
X41 VDD.t48 VDD.t47 VDD.t48 VDD.t24 pfet_03v3 ad=0.14p pd=1.06u as=0 ps=0 w=0.5u l=2u
X42 VSS.t18 VSS.t17 VSS.t18 VSS.t1 nfet_03v3 ad=0.14p pd=1.06u as=0 ps=0 w=0.5u l=2u
X43 Isum.t4 Isum.t2 Isum.t4 Isum.t3 nfet_03v3 ad=0.3p pd=2.2u as=0 ps=0 w=0.5u l=2u
X44 VDD.t34 VDD.t32 VDD.t34 VDD.t33 pfet_03v3 ad=2.4p pd=9.2u as=0 ps=0 w=4u l=2u
X45 VDD.t46 VDD.t45 VDD.t46 VDD.t21 pfet_03v3 ad=0.14p pd=1.06u as=0 ps=0 w=0.5u l=2u
X46 VSS.t14 VSS.t13 VSS.t14 VSS.t1 nfet_03v3 ad=0.14p pd=1.06u as=0 ps=0 w=0.5u l=2u
X47 a_190_n489# a_190_n489# VSS.t48 VSS.t22 nfet_03v3 ad=1.2p pd=5.2u as=1.2p ps=5.2u w=2u l=8u
X48 VDD.t19 VDD.t17 VDD.t19 VDD.t18 pfet_03v3 ad=0.14p pd=1.06u as=0 ps=0 w=0.5u l=2u
X49 VSS.t28 VSS.t26 VSS.t28 VSS.t27 nfet_03v3 ad=0.3p pd=2.2u as=0 ps=0 w=0.5u l=2u
X50 Isum.t37 Isum.t36 Isum.t37 Isum.t9 nfet_03v3 ad=0.14p pd=1.06u as=0 ps=0 w=0.5u l=2u
X51 VDD.t36 VDD.t35 VDD.t36 VDD.t6 pfet_03v3 ad=0.3p pd=2.2u as=0 ps=0 w=0.5u l=2u
X52 VSS.t36 VSS.t35 VSS.t36 VSS.t27 nfet_03v3 ad=0.14p pd=1.06u as=0 ps=0 w=0.5u l=2u
X53 VSS.t42 VSS.t41 VSS.t42 VSS.t27 nfet_03v3 ad=0.14p pd=1.06u as=0 ps=0 w=0.5u l=2u
X54 a_4290_5335# a_4290_5335# Isum.t49 Isum.t48 nfet_03v3 ad=2.4p pd=9.2u as=2.4p ps=9.2u w=4u l=5.12u
X55 Isum.t41 Isum.t40 Isum.t41 Isum.t15 nfet_03v3 ad=0.14p pd=1.06u as=0 ps=0 w=0.5u l=2u
X56 VDD.t40 VDD.t39 VDD.t40 VDD.t12 pfet_03v3 ad=0.14p pd=1.06u as=0 ps=0 w=0.5u l=2u
X57 VDD.t38 VDD.t37 VDD.t38 VDD.t9 pfet_03v3 ad=0.14p pd=1.06u as=0 ps=0 w=0.5u l=2u
X58 VSS.t12 VSS.t11 VSS.t12 VSS.t1 nfet_03v3 ad=0.14p pd=1.06u as=0 ps=0 w=0.5u l=2u
X59 VSS.t8 VSS.t7 VSS.t8 VSS.t1 nfet_03v3 ad=0.14p pd=1.06u as=0 ps=0 w=0.5u l=2u
X60 Isum.t25 Isum.t23 Isum.t25 Isum.t24 nfet_03v3 ad=0.14p pd=1.06u as=0 ps=0 w=0.5u l=2u
X61 Isum.t47 Isum.t46 Isum.t47 Isum.t24 nfet_03v3 ad=0.14p pd=1.06u as=0 ps=0 w=0.5u l=2u
X62 Isum.t10 Isum.t8 Isum.t10 Isum.t9 nfet_03v3 ad=0.14p pd=1.06u as=0 ps=0 w=0.5u l=2u
X63 VDD.t50 VDD.t49 VDD.t50 VDD.t27 pfet_03v3 ad=0.14p pd=1.06u as=0 ps=0 w=0.5u l=2u
X64 Isum.t7 Isum.t5 Isum.t7 Isum.t6 nfet_03v3 ad=0.14p pd=1.06u as=0 ps=0 w=0.5u l=2u
R0 Vthr Vthr.t0 18.625
R1 Iout Iout.t0 19.4257
R2 VT VT.t0 17.7754
R3 Isum.n119 Isum.n48 42920
R4 Isum.n61 Isum.t27 288.606
R5 Isum.n281 Isum.n278 286.904
R6 Isum.n684 Isum.n49 286.904
R7 Isum.n678 Isum.n49 286.904
R8 Isum.n1302 Isum.n1075 273.538
R9 Isum.n1401 Isum.n5 273.538
R10 Isum.n1410 Isum.n46 272.904
R11 Isum.n1411 Isum.n1410 272.904
R12 Isum.n1175 Isum.n52 272.904
R13 Isum.n1301 Isum.n52 272.904
R14 Isum.n364 Isum.n260 181.125
R15 Isum.n1408 Isum.n53 181.125
R16 Isum.n550 Isum.n364 181.125
R17 Isum.n1408 Isum.n54 181.125
R18 Isum.n1003 Isum.n51 167.125
R19 Isum.n1329 Isum.n51 167.125
R20 Isum.n1399 Isum.n50 167.125
R21 Isum.n1073 Isum.n50 167.125
R22 Isum.n1074 Isum.t3 113.588
R23 Isum.n1409 Isum.n48 112.719
R24 Isum.n1400 Isum.t3 66.6464
R25 Isum.n281 Isum.n280 59.3778
R26 Isum.n287 Isum.n277 47.5847
R27 Isum.n287 Isum.n270 47.5847
R28 Isum.n354 Isum.n270 47.5847
R29 Isum.n354 Isum.n263 47.5847
R30 Isum.n362 Isum.n263 47.5847
R31 Isum.n551 Isum.n259 47.5847
R32 Isum.n551 Isum.n262 47.5847
R33 Isum.n567 Isum.n243 47.5847
R34 Isum.n567 Isum.n246 47.5847
R35 Isum.n575 Isum.n228 47.5847
R36 Isum.n583 Isum.n228 47.5847
R37 Isum.n591 Isum.n219 47.5847
R38 Isum.n591 Isum.n222 47.5847
R39 Isum.n599 Isum.n203 47.5847
R40 Isum.n607 Isum.n203 47.5847
R41 Isum.n607 Isum.n206 47.5847
R42 Isum.n615 Isum.n188 47.5847
R43 Isum.n623 Isum.n188 47.5847
R44 Isum.n640 Isum.n177 47.5847
R45 Isum.n640 Isum.n180 47.5847
R46 Isum.n649 Isum.n134 47.5847
R47 Isum.n704 Isum.n134 47.5847
R48 Isum.n1302 Isum.n119 46.3628
R49 Isum.n1075 Isum.n1074 46.3628
R50 Isum.t3 Isum.n61 46.3628
R51 Isum.n1401 Isum.n1400 46.3628
R52 Isum.n676 Isum.n5 46.3628
R53 Isum.n222 Isum.t15 42.8263
R54 Isum.n615 Isum.t12 42.8263
R55 Isum.n363 Isum.n259 33.3094
R56 Isum.t24 Isum.n243 33.3094
R57 Isum.n583 Isum.t18 33.3094
R58 Isum.t9 Isum.n177 33.3094
R59 Isum.n60 Isum.n59 32.4435
R60 Isum.n559 Isum.t30 27.9562
R61 Isum.n246 Isum.t21 23.7926
R62 Isum.n575 Isum.t21 23.7926
R63 Isum.n180 Isum.t6 23.7926
R64 Isum.n649 Isum.t6 23.7926
R65 Isum.n1409 Isum.t27 23.4714
R66 Isum.n1325 Isum.n113 22.1189
R67 Isum.n262 Isum.t30 19.629
R68 Isum.n124 Isum.t49 18.979
R69 Isum.n124 Isum.t1 17.6074
R70 Isum.n837 Isum.n836 15.8697
R71 Isum.n936 Isum.n765 15.8697
R72 Isum.n851 Isum.n850 15.8697
R73 Isum.n924 Isum.n923 15.8697
R74 Isum.n1175 Isum.n1174 15.5561
R75 Isum.n1172 Isum.n1099 15.5561
R76 Isum.n1168 Isum.n1167 15.5561
R77 Isum.n1165 Isum.n1105 15.5561
R78 Isum.n1161 Isum.n1160 15.5561
R79 Isum.n1158 Isum.n1112 15.5561
R80 Isum.n1154 Isum.n1153 15.5561
R81 Isum.n1151 Isum.n1119 15.5561
R82 Isum.n1147 Isum.n1146 15.5561
R83 Isum.n1144 Isum.n1126 15.5561
R84 Isum.n1140 Isum.n1139 15.5561
R85 Isum.n1137 Isum.n1133 15.5561
R86 Isum.n1453 Isum.n1452 15.5561
R87 Isum.n1450 Isum.n6 15.5561
R88 Isum.n1446 Isum.n1445 15.5561
R89 Isum.n1443 Isum.n12 15.5561
R90 Isum.n1439 Isum.n1438 15.5561
R91 Isum.n1436 Isum.n19 15.5561
R92 Isum.n1432 Isum.n1431 15.5561
R93 Isum.n1429 Isum.n26 15.5561
R94 Isum.n1425 Isum.n1424 15.5561
R95 Isum.n1422 Isum.n33 15.5561
R96 Isum.n1418 Isum.n1417 15.5561
R97 Isum.n1415 Isum.n40 15.5561
R98 Isum.n1301 Isum.n1096 15.5561
R99 Isum.n1294 Isum.n1293 15.5561
R100 Isum.n1291 Isum.n1290 15.5561
R101 Isum.n1287 Isum.n1286 15.5561
R102 Isum.n1283 Isum.n1282 15.5561
R103 Isum.n1279 Isum.n1278 15.5561
R104 Isum.n1275 Isum.n1274 15.5561
R105 Isum.n1271 Isum.n1270 15.5561
R106 Isum.n1267 Isum.n1266 15.5561
R107 Isum.n1263 Isum.n1262 15.5561
R108 Isum.n1259 Isum.n1258 15.5561
R109 Isum.n1255 Isum.n1254 15.5561
R110 Isum.n1251 Isum.n1250 15.5561
R111 Isum.n1247 Isum.n1246 15.5561
R112 Isum.n1243 Isum.n1242 15.5561
R113 Isum.n1239 Isum.n1238 15.5561
R114 Isum.n1235 Isum.n1234 15.5561
R115 Isum.n1231 Isum.n1230 15.5561
R116 Isum.n1227 Isum.n1226 15.5561
R117 Isum.n1223 Isum.n1222 15.5561
R118 Isum.n1219 Isum.n1218 15.5561
R119 Isum.n1321 Isum.n1320 15.5561
R120 Isum.n1318 Isum.n1303 15.5561
R121 Isum.n1314 Isum.n1313 15.5561
R122 Isum.n1399 Isum.n79 15.5561
R123 Isum.n1392 Isum.n1391 15.5561
R124 Isum.n1389 Isum.n1388 15.5561
R125 Isum.n1385 Isum.n1384 15.5561
R126 Isum.n1381 Isum.n1380 15.5561
R127 Isum.n1377 Isum.n1376 15.5561
R128 Isum.n1373 Isum.n1372 15.5561
R129 Isum.n1369 Isum.n1368 15.5561
R130 Isum.n1365 Isum.n1364 15.5561
R131 Isum.n1361 Isum.n1360 15.5561
R132 Isum.n1357 Isum.n1356 15.5561
R133 Isum.n1353 Isum.n1352 15.5561
R134 Isum.n1349 Isum.n1348 15.5561
R135 Isum.n1345 Isum.n1344 15.5561
R136 Isum.n1341 Isum.n1340 15.5561
R137 Isum.n1337 Isum.n1336 15.5561
R138 Isum.n1333 Isum.n1332 15.5561
R139 Isum.n1073 Isum.n732 15.5561
R140 Isum.n1067 Isum.n1066 15.5561
R141 Isum.n1063 Isum.n1062 15.5561
R142 Isum.n1059 Isum.n1058 15.5561
R143 Isum.n1055 Isum.n1054 15.5561
R144 Isum.n1051 Isum.n1050 15.5561
R145 Isum.n1047 Isum.n1046 15.5561
R146 Isum.n1043 Isum.n1042 15.5561
R147 Isum.n1039 Isum.n1038 15.5561
R148 Isum.n1035 Isum.n1034 15.5561
R149 Isum.n1031 Isum.n1030 15.5561
R150 Isum.n1027 Isum.n1026 15.5561
R151 Isum.n1023 Isum.n1022 15.5561
R152 Isum.n1019 Isum.n1018 15.5561
R153 Isum.n1015 Isum.n1014 15.5561
R154 Isum.n1011 Isum.n1010 15.5561
R155 Isum.n1007 Isum.n1006 15.5561
R156 Isum.n286 Isum.n278 15.5561
R157 Isum.n286 Isum.n269 15.5561
R158 Isum.n355 Isum.n269 15.5561
R159 Isum.n355 Isum.n265 15.5561
R160 Isum.n361 Isum.n265 15.5561
R161 Isum.n361 Isum.n258 15.5561
R162 Isum.n552 Isum.n258 15.5561
R163 Isum.n552 Isum.n254 15.5561
R164 Isum.n558 Isum.n254 15.5561
R165 Isum.n558 Isum.n242 15.5561
R166 Isum.n568 Isum.n242 15.5561
R167 Isum.n568 Isum.n238 15.5561
R168 Isum.n574 Isum.n238 15.5561
R169 Isum.n574 Isum.n227 15.5561
R170 Isum.n584 Isum.n227 15.5561
R171 Isum.n584 Isum.n223 15.5561
R172 Isum.n590 Isum.n223 15.5561
R173 Isum.n590 Isum.n211 15.5561
R174 Isum.n600 Isum.n211 15.5561
R175 Isum.n600 Isum.n207 15.5561
R176 Isum.n606 Isum.n207 15.5561
R177 Isum.n606 Isum.n195 15.5561
R178 Isum.n616 Isum.n195 15.5561
R179 Isum.n616 Isum.n191 15.5561
R180 Isum.n622 Isum.n191 15.5561
R181 Isum.n622 Isum.n176 15.5561
R182 Isum.n641 Isum.n176 15.5561
R183 Isum.n641 Isum.n172 15.5561
R184 Isum.n648 Isum.n172 15.5561
R185 Isum.n648 Isum.n137 15.5561
R186 Isum.n703 Isum.n137 15.5561
R187 Isum.n703 Isum.n138 15.5561
R188 Isum.n699 Isum.n697 15.5561
R189 Isum.n697 Isum.n696 15.5561
R190 Isum.n693 Isum.n692 15.5561
R191 Isum.n690 Isum.n149 15.5561
R192 Isum.n686 Isum.n684 15.5561
R193 Isum.n288 Isum.n276 15.5561
R194 Isum.n288 Isum.n271 15.5561
R195 Isum.n353 Isum.n271 15.5561
R196 Isum.n353 Isum.n272 15.5561
R197 Isum.n272 Isum.n264 15.5561
R198 Isum.n348 Isum.n264 15.5561
R199 Isum.n348 Isum.n261 15.5561
R200 Isum.n345 Isum.n261 15.5561
R201 Isum.n345 Isum.n253 15.5561
R202 Isum.n342 Isum.n253 15.5561
R203 Isum.n342 Isum.n245 15.5561
R204 Isum.n339 Isum.n245 15.5561
R205 Isum.n339 Isum.n237 15.5561
R206 Isum.n336 Isum.n237 15.5561
R207 Isum.n336 Isum.n230 15.5561
R208 Isum.n333 Isum.n230 15.5561
R209 Isum.n333 Isum.n221 15.5561
R210 Isum.n330 Isum.n221 15.5561
R211 Isum.n330 Isum.n213 15.5561
R212 Isum.n327 Isum.n213 15.5561
R213 Isum.n327 Isum.n205 15.5561
R214 Isum.n324 Isum.n205 15.5561
R215 Isum.n324 Isum.n197 15.5561
R216 Isum.n321 Isum.n197 15.5561
R217 Isum.n321 Isum.n190 15.5561
R218 Isum.n318 Isum.n190 15.5561
R219 Isum.n318 Isum.n179 15.5561
R220 Isum.n179 Isum.n168 15.5561
R221 Isum.n650 Isum.n168 15.5561
R222 Isum.n650 Isum.n169 15.5561
R223 Isum.n169 Isum.n135 15.5561
R224 Isum.n656 Isum.n135 15.5561
R225 Isum.n659 Isum.n658 15.5561
R226 Isum.n666 Isum.n665 15.5561
R227 Isum.n668 Isum.n160 15.5561
R228 Isum.n674 Isum.n156 15.5561
R229 Isum.n367 Isum.n260 15.5561
R230 Isum.n367 Isum.n252 15.5561
R231 Isum.n453 Isum.n252 15.5561
R232 Isum.n453 Isum.n244 15.5561
R233 Isum.n454 Isum.n244 15.5561
R234 Isum.n454 Isum.n236 15.5561
R235 Isum.n461 Isum.n236 15.5561
R236 Isum.n461 Isum.n229 15.5561
R237 Isum.n462 Isum.n229 15.5561
R238 Isum.n462 Isum.n220 15.5561
R239 Isum.n471 Isum.n220 15.5561
R240 Isum.n471 Isum.n212 15.5561
R241 Isum.n478 Isum.n212 15.5561
R242 Isum.n478 Isum.n204 15.5561
R243 Isum.n479 Isum.n204 15.5561
R244 Isum.n479 Isum.n196 15.5561
R245 Isum.n486 Isum.n196 15.5561
R246 Isum.n486 Isum.n189 15.5561
R247 Isum.n499 Isum.n189 15.5561
R248 Isum.n499 Isum.n178 15.5561
R249 Isum.n500 Isum.n178 15.5561
R250 Isum.n500 Isum.n170 15.5561
R251 Isum.n170 Isum.n133 15.5561
R252 Isum.n705 Isum.n133 15.5561
R253 Isum.n705 Isum.n120 15.5561
R254 Isum.n713 Isum.n53 15.5561
R255 Isum.n550 Isum.n251 15.5561
R256 Isum.n560 Isum.n251 15.5561
R257 Isum.n560 Isum.n247 15.5561
R258 Isum.n566 Isum.n247 15.5561
R259 Isum.n566 Isum.n235 15.5561
R260 Isum.n576 Isum.n235 15.5561
R261 Isum.n576 Isum.n231 15.5561
R262 Isum.n582 Isum.n231 15.5561
R263 Isum.n582 Isum.n218 15.5561
R264 Isum.n592 Isum.n218 15.5561
R265 Isum.n592 Isum.n214 15.5561
R266 Isum.n598 Isum.n214 15.5561
R267 Isum.n598 Isum.n202 15.5561
R268 Isum.n608 Isum.n202 15.5561
R269 Isum.n608 Isum.n198 15.5561
R270 Isum.n614 Isum.n198 15.5561
R271 Isum.n614 Isum.n187 15.5561
R272 Isum.n624 Isum.n187 15.5561
R273 Isum.n624 Isum.n181 15.5561
R274 Isum.n639 Isum.n181 15.5561
R275 Isum.n639 Isum.n182 15.5561
R276 Isum.n182 Isum.n171 15.5561
R277 Isum.n629 Isum.n171 15.5561
R278 Isum.n629 Isum.n136 15.5561
R279 Isum.n136 Isum.n58 15.5561
R280 Isum.n1403 Isum.n58 15.5561
R281 Isum.n397 Isum.t26 14.9553
R282 Isum.n446 Isum.t29 14.9553
R283 Isum.n363 Isum.n362 14.2758
R284 Isum.n559 Isum.t24 14.2758
R285 Isum.n704 Isum.n48 14.2758
R286 Isum.n540 Isum.n450 14.1851
R287 Isum.n131 Isum.n130 14.1851
R288 Isum.n60 Isum.n48 13.32
R289 Isum.n925 Isum.n774 12.5005
R290 Isum.n927 Isum.n926 12.5005
R291 Isum.n920 Isum.n773 12.5005
R292 Isum.n918 Isum.n917 12.5005
R293 Isum.n916 Isum.n776 12.5005
R294 Isum.n905 Isum.n777 12.5005
R295 Isum.n906 Isum.n780 12.5005
R296 Isum.n908 Isum.n907 12.5005
R297 Isum.n903 Isum.n779 12.5005
R298 Isum.n902 Isum.n901 12.5005
R299 Isum.n900 Isum.n899 12.5005
R300 Isum.n898 Isum.n897 12.5005
R301 Isum.n896 Isum.n784 12.5005
R302 Isum.n895 Isum.n894 12.5005
R303 Isum.n891 Isum.n785 12.5005
R304 Isum.n890 Isum.n889 12.5005
R305 Isum.n888 Isum.n887 12.5005
R306 Isum.n886 Isum.n788 12.5005
R307 Isum.n885 Isum.n884 12.5005
R308 Isum.n871 Isum.n791 12.5005
R309 Isum.n873 Isum.n872 12.5005
R310 Isum.n870 Isum.n794 12.5005
R311 Isum.n869 Isum.n868 12.5005
R312 Isum.n867 Isum.n796 12.5005
R313 Isum.n856 Isum.n797 12.5005
R314 Isum.n857 Isum.n848 12.5005
R315 Isum.n860 Isum.n859 12.5005
R316 Isum.n854 Isum.n847 12.5005
R317 Isum.n853 Isum.n852 12.5005
R318 Isum.n938 Isum.n937 12.5005
R319 Isum.n939 Isum.n763 12.5005
R320 Isum.n941 Isum.n940 12.5005
R321 Isum.n943 Isum.n942 12.5005
R322 Isum.n944 Isum.n760 12.5005
R323 Isum.n946 Isum.n945 12.5005
R324 Isum.n947 Isum.n759 12.5005
R325 Isum.n949 Isum.n948 12.5005
R326 Isum.n950 Isum.n755 12.5005
R327 Isum.n952 Isum.n951 12.5005
R328 Isum.n953 Isum.n754 12.5005
R329 Isum.n955 Isum.n954 12.5005
R330 Isum.n956 Isum.n752 12.5005
R331 Isum.n959 Isum.n958 12.5005
R332 Isum.n960 Isum.n751 12.5005
R333 Isum.n814 Isum.n750 12.5005
R334 Isum.n817 Isum.n816 12.5005
R335 Isum.n818 Isum.n812 12.5005
R336 Isum.n820 Isum.n819 12.5005
R337 Isum.n822 Isum.n821 12.5005
R338 Isum.n823 Isum.n809 12.5005
R339 Isum.n825 Isum.n824 12.5005
R340 Isum.n826 Isum.n808 12.5005
R341 Isum.n828 Isum.n827 12.5005
R342 Isum.n829 Isum.n804 12.5005
R343 Isum.n831 Isum.n830 12.5005
R344 Isum.n832 Isum.n803 12.5005
R345 Isum.n834 Isum.n833 12.5005
R346 Isum.n835 Isum.n801 12.5005
R347 Isum.n410 Isum.n389 12.5005
R348 Isum.n412 Isum.n411 12.5005
R349 Isum.n413 Isum.n388 12.5005
R350 Isum.n415 Isum.n414 12.5005
R351 Isum.n417 Isum.n416 12.5005
R352 Isum.n418 Isum.n385 12.5005
R353 Isum.n420 Isum.n419 12.5005
R354 Isum.n422 Isum.n421 12.5005
R355 Isum.n423 Isum.n381 12.5005
R356 Isum.n425 Isum.n424 12.5005
R357 Isum.n426 Isum.n380 12.5005
R358 Isum.n428 Isum.n427 12.5005
R359 Isum.n430 Isum.n429 12.5005
R360 Isum.n431 Isum.n377 12.5005
R361 Isum.n433 Isum.n432 12.5005
R362 Isum.n435 Isum.n434 12.5005
R363 Isum.n436 Isum.n373 12.5005
R364 Isum.n438 Isum.n437 12.5005
R365 Isum.n439 Isum.n371 12.5005
R366 Isum.n441 Isum.n440 12.5005
R367 Isum.n707 Isum.n129 12.5005
R368 Isum.n505 Isum.n128 12.5005
R369 Isum.n508 Isum.n506 12.5005
R370 Isum.n509 Isum.n503 12.5005
R371 Isum.n510 Isum.n502 12.5005
R372 Isum.n513 Isum.n491 12.5005
R373 Isum.n514 Isum.n489 12.5005
R374 Isum.n515 Isum.n488 12.5005
R375 Isum.n518 Isum.n484 12.5005
R376 Isum.n519 Isum.n482 12.5005
R377 Isum.n520 Isum.n481 12.5005
R378 Isum.n523 Isum.n476 12.5005
R379 Isum.n524 Isum.n475 12.5005
R380 Isum.n525 Isum.n473 12.5005
R381 Isum.n528 Isum.n469 12.5005
R382 Isum.n529 Isum.n468 12.5005
R383 Isum.n530 Isum.n466 12.5005
R384 Isum.n465 Isum.n460 12.5005
R385 Isum.n534 Isum.n459 12.5005
R386 Isum.n535 Isum.n457 12.5005
R387 Isum.n536 Isum.n456 12.5005
R388 Isum.n539 Isum.n451 12.5005
R389 Isum.t48 Isum.n219 12.4913
R390 Isum.n623 Isum.t0 12.4913
R391 Isum.n923 Isum.n922 12.1498
R392 Isum.n851 Isum.n798 12.1498
R393 Isum.n710 Isum.t4 12.1268
R394 Isum.t25 Isum.n366 12.1268
R395 Isum.n1002 Isum.n1001 12.1268
R396 Isum.n1070 Isum.n735 12.1268
R397 Isum.n931 Isum.n770 12.0353
R398 Isum.n845 Isum.n844 12.0353
R399 Isum.n126 Isum.n125 10.2173
R400 Isum.n442 Isum.n441 9.95036
R401 Isum.n410 Isum.n409 9.95036
R402 Isum.n481 Isum.n476 9.86111
R403 Isum.n829 Isum.n828 9.86111
R404 Isum.n824 Isum.n823 9.86111
R405 Isum.n950 Isum.n949 9.86111
R406 Isum.n945 Isum.n944 9.86111
R407 Isum.n856 Isum.n796 9.86111
R408 Isum.n872 Isum.n870 9.86111
R409 Isum.n907 Isum.n903 9.86111
R410 Isum.n905 Isum.n776 9.86111
R411 Isum.n426 Isum.n425 9.86111
R412 Isum.n444 Isum.t47 9.8285
R413 Isum.n407 Isum.t33 9.8285
R414 Isum.n473 Isum.n469 9.55788
R415 Isum.n488 Isum.n484 9.55788
R416 Isum.n431 Isum.n430 9.55788
R417 Isum.n421 Isum.n420 9.55788
R418 Isum.n125 Isum 9.4505
R419 Isum.n834 Isum.n803 8.95142
R420 Isum.n819 Isum.n818 8.95142
R421 Isum.n955 Isum.n754 8.95142
R422 Isum.n940 Isum.n939 8.95142
R423 Isum.n859 Isum.n854 8.95142
R424 Isum.n886 Isum.n885 8.95142
R425 Isum.n899 Isum.n898 8.95142
R426 Isum.n926 Isum.n920 8.95142
R427 Isum.n880 Isum.n785 8.63668
R428 Isum.n709 Isum.n708 8.63568
R429 Isum.n496 Isum.n485 8.63568
R430 Isum.n494 Isum.n470 8.63568
R431 Isum.n492 Isum.n452 8.63568
R432 Isum.n1000 Isum.n999 8.63568
R433 Isum.n994 Isum.n993 8.63568
R434 Isum.n988 Isum.n960 8.63568
R435 Isum.n983 Isum.n982 8.63568
R436 Isum.n977 Isum.n976 8.63568
R437 Isum.n406 Isum.n405 8.63568
R438 Isum.n403 Isum.n383 8.63568
R439 Isum.n401 Isum.n379 8.63568
R440 Isum.n399 Isum.n372 8.63568
R441 Isum.n498 Isum.n497 8.59884
R442 Isum.n495 Isum.n477 8.59884
R443 Isum.n493 Isum.n464 8.59884
R444 Isum.n915 Isum.n914 8.59884
R445 Isum.n878 Isum.n783 8.59884
R446 Isum.n883 Isum.n882 8.59884
R447 Isum.n866 Isum.n865 8.59884
R448 Isum.n997 Isum.n996 8.59884
R449 Isum.n991 Isum.n990 8.59884
R450 Isum.n986 Isum.n985 8.59884
R451 Isum.n980 Isum.n979 8.59884
R452 Isum.n404 Isum.n386 8.59884
R453 Isum.n402 Isum.n382 8.59884
R454 Isum.n400 Isum.n376 8.59884
R455 Isum.n456 Isum.n451 8.34496
R456 Isum.n466 Isum.n465 8.34496
R457 Isum.n502 Isum.n491 8.34496
R458 Isum.n505 Isum.n129 8.34496
R459 Isum.n436 Isum.n435 8.34496
R460 Isum.n416 Isum.n415 8.34496
R461 Isum.n814 Isum.n751 7.7385
R462 Isum.n958 Isum.n751 7.7385
R463 Isum.n891 Isum.n890 7.7385
R464 Isum.n894 Isum.n891 7.7385
R465 Isum.n283 Isum.n282 7.39502
R466 Isum.n682 Isum.n681 7.39502
R467 Isum.n681 Isum.n680 7.39502
R468 Isum.n282 Isum.n274 7.39502
R469 Isum.n1178 Isum.n1177 7.2529
R470 Isum.n1179 Isum.n1178 7.2529
R471 Isum.n1308 Isum.n47 7.16339
R472 Isum.n47 Isum.n44 7.16339
R473 Isum.n457 Isum.n456 7.13204
R474 Isum.n465 Isum.n459 7.13204
R475 Isum.n503 Isum.n502 7.13204
R476 Isum.n506 Isum.n505 7.13204
R477 Isum.n441 Isum.n371 7.13204
R478 Isum.n437 Isum.n436 7.13204
R479 Isum.n415 Isum.n388 7.13204
R480 Isum.n411 Isum.n410 7.13204
R481 Isum.n835 Isum.n834 6.52558
R482 Isum.n818 Isum.n817 6.52558
R483 Isum.n956 Isum.n955 6.52558
R484 Isum.n939 Isum.n938 6.52558
R485 Isum.n854 Isum.n853 6.52558
R486 Isum.n887 Isum.n886 6.52558
R487 Isum.n898 Isum.n784 6.52558
R488 Isum.n926 Isum.n925 6.52558
R489 Isum.n1407 Isum.n1406 6.32942
R490 Isum.n548 Isum.n547 6.32942
R491 Isum.n1407 Isum.n55 6.30962
R492 Isum.n547 Isum.n546 6.30962
R493 Isum.n929 Isum.n772 6.3005
R494 Isum.n911 Isum.n910 6.3005
R495 Isum.n876 Isum.n875 6.3005
R496 Isum.n863 Isum.n862 6.3005
R497 Isum.n1328 Isum.n1327 6.1873
R498 Isum.n734 Isum.n80 6.1873
R499 Isum.n1071 Isum.n734 6.1873
R500 Isum.n1327 Isum.n1326 6.1693
R501 Isum.n469 Isum.n468 5.91912
R502 Isum.n489 Isum.n488 5.91912
R503 Isum.n432 Isum.n431 5.91912
R504 Isum.n420 Isum.n385 5.91912
R505 Isum.n409 Isum.n408 5.8218
R506 Isum.n443 Isum.n442 5.8218
R507 Isum.n476 Isum.n475 5.61588
R508 Isum.n482 Isum.n481 5.61588
R509 Isum.n830 Isum.n829 5.61588
R510 Isum.n828 Isum.n808 5.61588
R511 Isum.n824 Isum.n808 5.61588
R512 Isum.n823 Isum.n822 5.61588
R513 Isum.n951 Isum.n950 5.61588
R514 Isum.n949 Isum.n759 5.61588
R515 Isum.n945 Isum.n759 5.61588
R516 Isum.n944 Isum.n943 5.61588
R517 Isum.n857 Isum.n856 5.61588
R518 Isum.n869 Isum.n796 5.61588
R519 Isum.n870 Isum.n869 5.61588
R520 Isum.n872 Isum.n871 5.61588
R521 Isum.n903 Isum.n902 5.61588
R522 Isum.n907 Isum.n906 5.61588
R523 Isum.n906 Isum.n905 5.61588
R524 Isum.n918 Isum.n776 5.61588
R525 Isum.n427 Isum.n426 5.61588
R526 Isum.n425 Isum.n381 5.61588
R527 Isum.n1326 Isum.n1325 5.4941
R528 Isum.n655 Isum.n135 5.2005
R529 Isum.n704 Isum.n135 5.2005
R530 Isum.n169 Isum.n165 5.2005
R531 Isum.n169 Isum.n134 5.2005
R532 Isum.n651 Isum.n650 5.2005
R533 Isum.n650 Isum.n649 5.2005
R534 Isum.n168 Isum.n167 5.2005
R535 Isum.n180 Isum.n168 5.2005
R536 Isum.n317 Isum.n179 5.2005
R537 Isum.n640 Isum.n179 5.2005
R538 Isum.n319 Isum.n318 5.2005
R539 Isum.n318 Isum.n177 5.2005
R540 Isum.n320 Isum.n190 5.2005
R541 Isum.n623 Isum.n190 5.2005
R542 Isum.n322 Isum.n321 5.2005
R543 Isum.n321 Isum.n188 5.2005
R544 Isum.n323 Isum.n197 5.2005
R545 Isum.n615 Isum.n197 5.2005
R546 Isum.n325 Isum.n324 5.2005
R547 Isum.n324 Isum.n206 5.2005
R548 Isum.n326 Isum.n205 5.2005
R549 Isum.n607 Isum.n205 5.2005
R550 Isum.n328 Isum.n327 5.2005
R551 Isum.n327 Isum.n203 5.2005
R552 Isum.n329 Isum.n213 5.2005
R553 Isum.n599 Isum.n213 5.2005
R554 Isum.n331 Isum.n330 5.2005
R555 Isum.n330 Isum.n222 5.2005
R556 Isum.n332 Isum.n221 5.2005
R557 Isum.n591 Isum.n221 5.2005
R558 Isum.n334 Isum.n333 5.2005
R559 Isum.n333 Isum.n219 5.2005
R560 Isum.n335 Isum.n230 5.2005
R561 Isum.n583 Isum.n230 5.2005
R562 Isum.n337 Isum.n336 5.2005
R563 Isum.n336 Isum.n228 5.2005
R564 Isum.n338 Isum.n237 5.2005
R565 Isum.n575 Isum.n237 5.2005
R566 Isum.n340 Isum.n339 5.2005
R567 Isum.n339 Isum.n246 5.2005
R568 Isum.n341 Isum.n245 5.2005
R569 Isum.n567 Isum.n245 5.2005
R570 Isum.n343 Isum.n342 5.2005
R571 Isum.n342 Isum.n243 5.2005
R572 Isum.n344 Isum.n253 5.2005
R573 Isum.n559 Isum.n253 5.2005
R574 Isum.n346 Isum.n345 5.2005
R575 Isum.n345 Isum.n262 5.2005
R576 Isum.n347 Isum.n261 5.2005
R577 Isum.n551 Isum.n261 5.2005
R578 Isum.n349 Isum.n348 5.2005
R579 Isum.n348 Isum.n259 5.2005
R580 Isum.n350 Isum.n264 5.2005
R581 Isum.n362 Isum.n264 5.2005
R582 Isum.n351 Isum.n272 5.2005
R583 Isum.n272 Isum.n263 5.2005
R584 Isum.n353 Isum.n352 5.2005
R585 Isum.n354 Isum.n353 5.2005
R586 Isum.n273 Isum.n271 5.2005
R587 Isum.n271 Isum.n270 5.2005
R588 Isum.n289 Isum.n288 5.2005
R589 Isum.n288 Isum.n287 5.2005
R590 Isum.n276 Isum.n275 5.2005
R591 Isum.n279 Isum.n278 5.2005
R592 Isum.n278 Isum.n277 5.2005
R593 Isum.n286 Isum.n285 5.2005
R594 Isum.n287 Isum.n286 5.2005
R595 Isum.n269 Isum.n268 5.2005
R596 Isum.n270 Isum.n269 5.2005
R597 Isum.n356 Isum.n355 5.2005
R598 Isum.n355 Isum.n354 5.2005
R599 Isum.n266 Isum.n265 5.2005
R600 Isum.n265 Isum.n263 5.2005
R601 Isum.n361 Isum.n360 5.2005
R602 Isum.n362 Isum.n361 5.2005
R603 Isum.n258 Isum.n257 5.2005
R604 Isum.n259 Isum.n258 5.2005
R605 Isum.n553 Isum.n552 5.2005
R606 Isum.n552 Isum.n551 5.2005
R607 Isum.n255 Isum.n254 5.2005
R608 Isum.n262 Isum.n254 5.2005
R609 Isum.n558 Isum.n557 5.2005
R610 Isum.n559 Isum.n558 5.2005
R611 Isum.n242 Isum.n241 5.2005
R612 Isum.n243 Isum.n242 5.2005
R613 Isum.n569 Isum.n568 5.2005
R614 Isum.n568 Isum.n567 5.2005
R615 Isum.n239 Isum.n238 5.2005
R616 Isum.n246 Isum.n238 5.2005
R617 Isum.n574 Isum.n573 5.2005
R618 Isum.n575 Isum.n574 5.2005
R619 Isum.n227 Isum.n226 5.2005
R620 Isum.n228 Isum.n227 5.2005
R621 Isum.n585 Isum.n584 5.2005
R622 Isum.n584 Isum.n583 5.2005
R623 Isum.n224 Isum.n223 5.2005
R624 Isum.n223 Isum.n219 5.2005
R625 Isum.n590 Isum.n589 5.2005
R626 Isum.n591 Isum.n590 5.2005
R627 Isum.n211 Isum.n210 5.2005
R628 Isum.n222 Isum.n211 5.2005
R629 Isum.n601 Isum.n600 5.2005
R630 Isum.n600 Isum.n599 5.2005
R631 Isum.n208 Isum.n207 5.2005
R632 Isum.n207 Isum.n203 5.2005
R633 Isum.n606 Isum.n605 5.2005
R634 Isum.n607 Isum.n606 5.2005
R635 Isum.n195 Isum.n194 5.2005
R636 Isum.n206 Isum.n195 5.2005
R637 Isum.n617 Isum.n616 5.2005
R638 Isum.n616 Isum.n615 5.2005
R639 Isum.n192 Isum.n191 5.2005
R640 Isum.n191 Isum.n188 5.2005
R641 Isum.n622 Isum.n621 5.2005
R642 Isum.n623 Isum.n622 5.2005
R643 Isum.n176 Isum.n175 5.2005
R644 Isum.n177 Isum.n176 5.2005
R645 Isum.n642 Isum.n641 5.2005
R646 Isum.n641 Isum.n640 5.2005
R647 Isum.n173 Isum.n172 5.2005
R648 Isum.n180 Isum.n172 5.2005
R649 Isum.n648 Isum.n647 5.2005
R650 Isum.n649 Isum.n648 5.2005
R651 Isum.n139 Isum.n137 5.2005
R652 Isum.n137 Isum.n134 5.2005
R653 Isum.n703 Isum.n702 5.2005
R654 Isum.n704 Isum.n703 5.2005
R655 Isum.n1004 Isum.n1003 5.2005
R656 Isum.n1006 Isum.n1005 5.2005
R657 Isum.n1008 Isum.n1007 5.2005
R658 Isum.n1010 Isum.n1009 5.2005
R659 Isum.n1012 Isum.n1011 5.2005
R660 Isum.n1014 Isum.n1013 5.2005
R661 Isum.n1016 Isum.n1015 5.2005
R662 Isum.n1018 Isum.n1017 5.2005
R663 Isum.n1020 Isum.n1019 5.2005
R664 Isum.n1022 Isum.n1021 5.2005
R665 Isum.n1024 Isum.n1023 5.2005
R666 Isum.n1026 Isum.n1025 5.2005
R667 Isum.n1028 Isum.n1027 5.2005
R668 Isum.n1030 Isum.n1029 5.2005
R669 Isum.n1032 Isum.n1031 5.2005
R670 Isum.n1034 Isum.n1033 5.2005
R671 Isum.n1036 Isum.n1035 5.2005
R672 Isum.n1038 Isum.n1037 5.2005
R673 Isum.n1040 Isum.n1039 5.2005
R674 Isum.n1042 Isum.n1041 5.2005
R675 Isum.n1044 Isum.n1043 5.2005
R676 Isum.n1046 Isum.n1045 5.2005
R677 Isum.n1048 Isum.n1047 5.2005
R678 Isum.n1050 Isum.n1049 5.2005
R679 Isum.n1052 Isum.n1051 5.2005
R680 Isum.n1054 Isum.n1053 5.2005
R681 Isum.n1056 Isum.n1055 5.2005
R682 Isum.n1058 Isum.n1057 5.2005
R683 Isum.n1060 Isum.n1059 5.2005
R684 Isum.n1062 Isum.n1061 5.2005
R685 Isum.n1064 Isum.n1063 5.2005
R686 Isum.n1066 Isum.n1065 5.2005
R687 Isum.n1068 Isum.n1067 5.2005
R688 Isum.n733 Isum.n732 5.2005
R689 Isum.n1073 Isum.n1072 5.2005
R690 Isum.n1074 Isum.n1073 5.2005
R691 Isum.n1330 Isum.n1329 5.2005
R692 Isum.n1332 Isum.n1331 5.2005
R693 Isum.n1334 Isum.n1333 5.2005
R694 Isum.n1336 Isum.n1335 5.2005
R695 Isum.n1338 Isum.n1337 5.2005
R696 Isum.n1340 Isum.n1339 5.2005
R697 Isum.n1342 Isum.n1341 5.2005
R698 Isum.n1344 Isum.n1343 5.2005
R699 Isum.n1346 Isum.n1345 5.2005
R700 Isum.n1348 Isum.n1347 5.2005
R701 Isum.n1350 Isum.n1349 5.2005
R702 Isum.n1352 Isum.n1351 5.2005
R703 Isum.n1354 Isum.n1353 5.2005
R704 Isum.n1356 Isum.n1355 5.2005
R705 Isum.n1358 Isum.n1357 5.2005
R706 Isum.n1360 Isum.n1359 5.2005
R707 Isum.n1362 Isum.n1361 5.2005
R708 Isum.n1364 Isum.n1363 5.2005
R709 Isum.n1366 Isum.n1365 5.2005
R710 Isum.n1368 Isum.n1367 5.2005
R711 Isum.n1370 Isum.n1369 5.2005
R712 Isum.n1372 Isum.n1371 5.2005
R713 Isum.n1374 Isum.n1373 5.2005
R714 Isum.n1376 Isum.n1375 5.2005
R715 Isum.n1378 Isum.n1377 5.2005
R716 Isum.n1380 Isum.n1379 5.2005
R717 Isum.n1382 Isum.n1381 5.2005
R718 Isum.n1384 Isum.n1383 5.2005
R719 Isum.n1386 Isum.n1385 5.2005
R720 Isum.n1388 Isum.n1387 5.2005
R721 Isum.n1390 Isum.n1389 5.2005
R722 Isum.n1393 Isum.n1392 5.2005
R723 Isum.n1391 Isum.n81 5.2005
R724 Isum.n1397 Isum.n79 5.2005
R725 Isum.n1399 Isum.n1398 5.2005
R726 Isum.n1400 Isum.n1399 5.2005
R727 Isum.n1309 Isum.n46 5.2005
R728 Isum.n1313 Isum.n1310 5.2005
R729 Isum.n1315 Isum.n1314 5.2005
R730 Isum.n1316 Isum.n1303 5.2005
R731 Isum.n1318 Isum.n1317 5.2005
R732 Isum.n1320 Isum.n117 5.2005
R733 Isum.n1322 Isum.n1321 5.2005
R734 Isum.n1218 Isum.n116 5.2005
R735 Isum.n1220 Isum.n1219 5.2005
R736 Isum.n1222 Isum.n1221 5.2005
R737 Isum.n1224 Isum.n1223 5.2005
R738 Isum.n1226 Isum.n1225 5.2005
R739 Isum.n1228 Isum.n1227 5.2005
R740 Isum.n1230 Isum.n1229 5.2005
R741 Isum.n1232 Isum.n1231 5.2005
R742 Isum.n1234 Isum.n1233 5.2005
R743 Isum.n1236 Isum.n1235 5.2005
R744 Isum.n1238 Isum.n1237 5.2005
R745 Isum.n1240 Isum.n1239 5.2005
R746 Isum.n1242 Isum.n1241 5.2005
R747 Isum.n1244 Isum.n1243 5.2005
R748 Isum.n1246 Isum.n1245 5.2005
R749 Isum.n1248 Isum.n1247 5.2005
R750 Isum.n1250 Isum.n1249 5.2005
R751 Isum.n1252 Isum.n1251 5.2005
R752 Isum.n1254 Isum.n1253 5.2005
R753 Isum.n1256 Isum.n1255 5.2005
R754 Isum.n1258 Isum.n1257 5.2005
R755 Isum.n1260 Isum.n1259 5.2005
R756 Isum.n1262 Isum.n1261 5.2005
R757 Isum.n1264 Isum.n1263 5.2005
R758 Isum.n1266 Isum.n1265 5.2005
R759 Isum.n1268 Isum.n1267 5.2005
R760 Isum.n1270 Isum.n1269 5.2005
R761 Isum.n1272 Isum.n1271 5.2005
R762 Isum.n1274 Isum.n1273 5.2005
R763 Isum.n1276 Isum.n1275 5.2005
R764 Isum.n1278 Isum.n1277 5.2005
R765 Isum.n1280 Isum.n1279 5.2005
R766 Isum.n1282 Isum.n1281 5.2005
R767 Isum.n1284 Isum.n1283 5.2005
R768 Isum.n1286 Isum.n1285 5.2005
R769 Isum.n1288 Isum.n1287 5.2005
R770 Isum.n1290 Isum.n1289 5.2005
R771 Isum.n1292 Isum.n1291 5.2005
R772 Isum.n1295 Isum.n1294 5.2005
R773 Isum.n1293 Isum.n1180 5.2005
R774 Isum.n1299 Isum.n1096 5.2005
R775 Isum.n1301 Isum.n1300 5.2005
R776 Isum.n1302 Isum.n1301 5.2005
R777 Isum.n1412 Isum.n1411 5.2005
R778 Isum.n1413 Isum.n40 5.2005
R779 Isum.n1415 Isum.n1414 5.2005
R780 Isum.n1417 Isum.n38 5.2005
R781 Isum.n1419 Isum.n1418 5.2005
R782 Isum.n1420 Isum.n33 5.2005
R783 Isum.n1422 Isum.n1421 5.2005
R784 Isum.n1424 Isum.n31 5.2005
R785 Isum.n1426 Isum.n1425 5.2005
R786 Isum.n1427 Isum.n26 5.2005
R787 Isum.n1429 Isum.n1428 5.2005
R788 Isum.n1431 Isum.n24 5.2005
R789 Isum.n1433 Isum.n1432 5.2005
R790 Isum.n1434 Isum.n19 5.2005
R791 Isum.n1436 Isum.n1435 5.2005
R792 Isum.n1438 Isum.n17 5.2005
R793 Isum.n1440 Isum.n1439 5.2005
R794 Isum.n1441 Isum.n12 5.2005
R795 Isum.n1443 Isum.n1442 5.2005
R796 Isum.n1445 Isum.n10 5.2005
R797 Isum.n1447 Isum.n1446 5.2005
R798 Isum.n1448 Isum.n6 5.2005
R799 Isum.n1450 Isum.n1449 5.2005
R800 Isum.n1452 Isum.n3 5.2005
R801 Isum.n1454 Isum.n1453 5.2005
R802 Isum.n1133 Isum.n2 5.2005
R803 Isum.n1137 Isum.n1136 5.2005
R804 Isum.n1139 Isum.n1131 5.2005
R805 Isum.n1141 Isum.n1140 5.2005
R806 Isum.n1142 Isum.n1126 5.2005
R807 Isum.n1144 Isum.n1143 5.2005
R808 Isum.n1146 Isum.n1124 5.2005
R809 Isum.n1148 Isum.n1147 5.2005
R810 Isum.n1149 Isum.n1119 5.2005
R811 Isum.n1151 Isum.n1150 5.2005
R812 Isum.n1153 Isum.n1117 5.2005
R813 Isum.n1155 Isum.n1154 5.2005
R814 Isum.n1156 Isum.n1112 5.2005
R815 Isum.n1158 Isum.n1157 5.2005
R816 Isum.n1160 Isum.n1110 5.2005
R817 Isum.n1162 Isum.n1161 5.2005
R818 Isum.n1163 Isum.n1105 5.2005
R819 Isum.n1165 Isum.n1164 5.2005
R820 Isum.n1167 Isum.n1103 5.2005
R821 Isum.n1169 Isum.n1168 5.2005
R822 Isum.n1170 Isum.n1099 5.2005
R823 Isum.n1172 Isum.n1171 5.2005
R824 Isum.n1174 Isum.n1098 5.2005
R825 Isum.n1176 Isum.n1175 5.2005
R826 Isum.n1175 Isum.n5 5.2005
R827 Isum.n679 Isum.n678 5.2005
R828 Isum.n156 Isum.n155 5.2005
R829 Isum.n674 Isum.n673 5.2005
R830 Isum.n161 Isum.n160 5.2005
R831 Isum.n669 Isum.n668 5.2005
R832 Isum.n667 Isum.n666 5.2005
R833 Isum.n665 Isum.n664 5.2005
R834 Isum.n658 Isum.n163 5.2005
R835 Isum.n660 Isum.n659 5.2005
R836 Isum.n657 Isum.n656 5.2005
R837 Isum.n701 Isum.n138 5.2005
R838 Isum.n700 Isum.n699 5.2005
R839 Isum.n697 Isum.n143 5.2005
R840 Isum.n697 Isum.n119 5.2005
R841 Isum.n696 Isum.n695 5.2005
R842 Isum.n694 Isum.n693 5.2005
R843 Isum.n692 Isum.n148 5.2005
R844 Isum.n690 Isum.n689 5.2005
R845 Isum.n688 Isum.n149 5.2005
R846 Isum.n687 Isum.n686 5.2005
R847 Isum.n684 Isum.n683 5.2005
R848 Isum.n684 Isum.n119 5.2005
R849 Isum.n122 Isum.n53 5.2005
R850 Isum.n1075 Isum.n53 5.2005
R851 Isum.n713 Isum.n712 5.2005
R852 Isum.n121 Isum.n120 5.2005
R853 Isum.n706 Isum.n705 5.2005
R854 Isum.n705 Isum.n704 5.2005
R855 Isum.n133 Isum.n132 5.2005
R856 Isum.n134 Isum.n133 5.2005
R857 Isum.n507 Isum.n170 5.2005
R858 Isum.n649 Isum.n170 5.2005
R859 Isum.n501 Isum.n500 5.2005
R860 Isum.n500 Isum.n180 5.2005
R861 Isum.n511 Isum.n178 5.2005
R862 Isum.n640 Isum.n178 5.2005
R863 Isum.n512 Isum.n499 5.2005
R864 Isum.n499 Isum.n177 5.2005
R865 Isum.n487 Isum.n189 5.2005
R866 Isum.n623 Isum.n189 5.2005
R867 Isum.n516 Isum.n486 5.2005
R868 Isum.n486 Isum.n188 5.2005
R869 Isum.n517 Isum.n196 5.2005
R870 Isum.n615 Isum.n196 5.2005
R871 Isum.n480 Isum.n479 5.2005
R872 Isum.n479 Isum.n206 5.2005
R873 Isum.n521 Isum.n204 5.2005
R874 Isum.n607 Isum.n204 5.2005
R875 Isum.n522 Isum.n478 5.2005
R876 Isum.n478 Isum.n203 5.2005
R877 Isum.n472 Isum.n212 5.2005
R878 Isum.n599 Isum.n212 5.2005
R879 Isum.n526 Isum.n471 5.2005
R880 Isum.n471 Isum.n222 5.2005
R881 Isum.n527 Isum.n220 5.2005
R882 Isum.n591 Isum.n220 5.2005
R883 Isum.n463 Isum.n462 5.2005
R884 Isum.n462 Isum.n219 5.2005
R885 Isum.n531 Isum.n229 5.2005
R886 Isum.n583 Isum.n229 5.2005
R887 Isum.n532 Isum.n461 5.2005
R888 Isum.n461 Isum.n228 5.2005
R889 Isum.n533 Isum.n236 5.2005
R890 Isum.n575 Isum.n236 5.2005
R891 Isum.n455 Isum.n454 5.2005
R892 Isum.n454 Isum.n246 5.2005
R893 Isum.n537 Isum.n244 5.2005
R894 Isum.n567 Isum.n244 5.2005
R895 Isum.n538 Isum.n453 5.2005
R896 Isum.n453 Isum.n243 5.2005
R897 Isum.n368 Isum.n252 5.2005
R898 Isum.n559 Isum.n252 5.2005
R899 Isum.n543 Isum.n367 5.2005
R900 Isum.n367 Isum.n262 5.2005
R901 Isum.n544 Isum.n260 5.2005
R902 Isum.n551 Isum.n260 5.2005
R903 Isum.n1405 Isum.n54 5.2005
R904 Isum.n1404 Isum.n1403 5.2005
R905 Isum.n58 Isum.n57 5.2005
R906 Isum.n1401 Isum.n58 5.2005
R907 Isum.n632 Isum.n136 5.2005
R908 Isum.n704 Isum.n136 5.2005
R909 Isum.n633 Isum.n629 5.2005
R910 Isum.n629 Isum.n134 5.2005
R911 Isum.n634 Isum.n171 5.2005
R912 Isum.n649 Isum.n171 5.2005
R913 Isum.n184 Isum.n182 5.2005
R914 Isum.n182 Isum.n180 5.2005
R915 Isum.n639 Isum.n638 5.2005
R916 Isum.n640 Isum.n639 5.2005
R917 Isum.n183 Isum.n181 5.2005
R918 Isum.n181 Isum.n177 5.2005
R919 Isum.n625 Isum.n624 5.2005
R920 Isum.n624 Isum.n623 5.2005
R921 Isum.n187 Isum.n186 5.2005
R922 Isum.n188 Isum.n187 5.2005
R923 Isum.n614 Isum.n613 5.2005
R924 Isum.n615 Isum.n614 5.2005
R925 Isum.n199 Isum.n198 5.2005
R926 Isum.n206 Isum.n198 5.2005
R927 Isum.n609 Isum.n608 5.2005
R928 Isum.n608 Isum.n607 5.2005
R929 Isum.n202 Isum.n201 5.2005
R930 Isum.n203 Isum.n202 5.2005
R931 Isum.n598 Isum.n597 5.2005
R932 Isum.n599 Isum.n598 5.2005
R933 Isum.n215 Isum.n214 5.2005
R934 Isum.n222 Isum.n214 5.2005
R935 Isum.n593 Isum.n592 5.2005
R936 Isum.n592 Isum.n591 5.2005
R937 Isum.n218 Isum.n217 5.2005
R938 Isum.n219 Isum.n218 5.2005
R939 Isum.n582 Isum.n581 5.2005
R940 Isum.n583 Isum.n582 5.2005
R941 Isum.n232 Isum.n231 5.2005
R942 Isum.n231 Isum.n228 5.2005
R943 Isum.n577 Isum.n576 5.2005
R944 Isum.n576 Isum.n575 5.2005
R945 Isum.n235 Isum.n234 5.2005
R946 Isum.n246 Isum.n235 5.2005
R947 Isum.n566 Isum.n565 5.2005
R948 Isum.n567 Isum.n566 5.2005
R949 Isum.n248 Isum.n247 5.2005
R950 Isum.n247 Isum.n243 5.2005
R951 Isum.n561 Isum.n560 5.2005
R952 Isum.n560 Isum.n559 5.2005
R953 Isum.n251 Isum.n250 5.2005
R954 Isum.n262 Isum.n251 5.2005
R955 Isum.n550 Isum.n549 5.2005
R956 Isum.n551 Isum.n550 5.2005
R957 Isum.n474 Isum.n473 5.05435
R958 Isum.n484 Isum.n483 5.05435
R959 Isum.n430 Isum.n378 5.05435
R960 Isum.n421 Isum.n384 5.05435
R961 Isum.n840 Isum.n839 4.96224
R962 Isum.n935 Isum.n934 4.96224
R963 Isum.n930 Isum.n929 4.85463
R964 Isum.n910 Isum.n771 4.85463
R965 Isum.n875 Isum.n793 4.85463
R966 Isum.n862 Isum.n846 4.85463
R967 Isum.n599 Isum.t15 4.75892
R968 Isum.n206 Isum.t12 4.75892
R969 Isum.n445 Isum.n444 4.69811
R970 Isum.n407 Isum.n398 4.69811
R971 Isum.n843 Isum.n842 4.5725
R972 Isum.n843 Isum.n800 4.5725
R973 Isum.n932 Isum.n767 4.5725
R974 Isum.n932 Isum.n769 4.5725
R975 Isum.n1098 Isum.n1097 4.5005
R976 Isum.n1171 Isum.n1100 4.5005
R977 Isum.n1170 Isum.n1101 4.5005
R978 Isum.n1169 Isum.n1102 4.5005
R979 Isum.n1106 Isum.n1103 4.5005
R980 Isum.n1164 Isum.n1107 4.5005
R981 Isum.n1163 Isum.n1108 4.5005
R982 Isum.n1162 Isum.n1109 4.5005
R983 Isum.n1113 Isum.n1110 4.5005
R984 Isum.n1157 Isum.n1114 4.5005
R985 Isum.n1156 Isum.n1115 4.5005
R986 Isum.n1155 Isum.n1116 4.5005
R987 Isum.n1120 Isum.n1117 4.5005
R988 Isum.n1150 Isum.n1121 4.5005
R989 Isum.n1149 Isum.n1122 4.5005
R990 Isum.n1148 Isum.n1123 4.5005
R991 Isum.n1127 Isum.n1124 4.5005
R992 Isum.n1143 Isum.n1128 4.5005
R993 Isum.n1142 Isum.n1129 4.5005
R994 Isum.n1141 Isum.n1130 4.5005
R995 Isum.n1134 Isum.n1131 4.5005
R996 Isum.n1136 Isum.n1135 4.5005
R997 Isum.n2 Isum.n0 4.5005
R998 VSS Isum.n1454 4.5005
R999 Isum.n3 Isum.n1 4.5005
R1000 Isum.n1449 Isum.n7 4.5005
R1001 Isum.n1448 Isum.n8 4.5005
R1002 Isum.n1447 Isum.n9 4.5005
R1003 Isum.n13 Isum.n10 4.5005
R1004 Isum.n1442 Isum.n14 4.5005
R1005 Isum.n1441 Isum.n15 4.5005
R1006 Isum.n1440 Isum.n16 4.5005
R1007 Isum.n20 Isum.n17 4.5005
R1008 Isum.n1435 Isum.n21 4.5005
R1009 Isum.n1434 Isum.n22 4.5005
R1010 Isum.n1433 Isum.n23 4.5005
R1011 Isum.n27 Isum.n24 4.5005
R1012 Isum.n1428 Isum.n28 4.5005
R1013 Isum.n1427 Isum.n29 4.5005
R1014 Isum.n1426 Isum.n30 4.5005
R1015 Isum.n34 Isum.n31 4.5005
R1016 Isum.n1421 Isum.n35 4.5005
R1017 Isum.n1420 Isum.n36 4.5005
R1018 Isum.n1419 Isum.n37 4.5005
R1019 Isum.n41 Isum.n38 4.5005
R1020 Isum.n1414 Isum.n42 4.5005
R1021 Isum.n1413 Isum.n43 4.5005
R1022 Isum.n1412 Isum.n44 4.5005
R1023 Isum.n1177 Isum.n1176 4.5005
R1024 Isum.n1299 Isum.n1298 4.5005
R1025 Isum.n1297 Isum.n1180 4.5005
R1026 Isum.n1296 Isum.n1295 4.5005
R1027 Isum.n1292 Isum.n1181 4.5005
R1028 Isum.n1289 Isum.n1182 4.5005
R1029 Isum.n1288 Isum.n1183 4.5005
R1030 Isum.n1285 Isum.n1184 4.5005
R1031 Isum.n1284 Isum.n1185 4.5005
R1032 Isum.n1281 Isum.n1186 4.5005
R1033 Isum.n1280 Isum.n1187 4.5005
R1034 Isum.n1277 Isum.n1188 4.5005
R1035 Isum.n1276 Isum.n1189 4.5005
R1036 Isum.n1273 Isum.n1190 4.5005
R1037 Isum.n1272 Isum.n1191 4.5005
R1038 Isum.n1269 Isum.n1192 4.5005
R1039 Isum.n1268 Isum.n1193 4.5005
R1040 Isum.n1265 Isum.n1194 4.5005
R1041 Isum.n1264 Isum.n1195 4.5005
R1042 Isum.n1261 Isum.n1196 4.5005
R1043 Isum.n1260 Isum.n1197 4.5005
R1044 Isum.n1257 Isum.n1198 4.5005
R1045 Isum.n1256 Isum.n1199 4.5005
R1046 Isum.n1253 Isum.n1200 4.5005
R1047 Isum.n1252 Isum.n1201 4.5005
R1048 Isum.n1249 Isum.n1202 4.5005
R1049 Isum.n1248 Isum.n1203 4.5005
R1050 Isum.n1245 Isum.n1204 4.5005
R1051 Isum.n1244 Isum.n1205 4.5005
R1052 Isum.n1241 Isum.n1206 4.5005
R1053 Isum.n1240 Isum.n1207 4.5005
R1054 Isum.n1237 Isum.n1208 4.5005
R1055 Isum.n1236 Isum.n1209 4.5005
R1056 Isum.n1233 Isum.n1210 4.5005
R1057 Isum.n1232 Isum.n1211 4.5005
R1058 Isum.n1229 Isum.n1212 4.5005
R1059 Isum.n1228 Isum.n1213 4.5005
R1060 Isum.n1225 Isum.n1214 4.5005
R1061 Isum.n1224 Isum.n1215 4.5005
R1062 Isum.n1221 Isum.n1216 4.5005
R1063 Isum.n1220 Isum.n1217 4.5005
R1064 Isum.n116 Isum.n114 4.5005
R1065 Isum.n1323 Isum.n1322 4.5005
R1066 Isum.n117 Isum.n115 4.5005
R1067 Isum.n1317 Isum.n1304 4.5005
R1068 Isum.n1316 Isum.n1305 4.5005
R1069 Isum.n1315 Isum.n1306 4.5005
R1070 Isum.n1310 Isum.n1307 4.5005
R1071 Isum.n1309 Isum.n1308 4.5005
R1072 Isum.n1300 Isum.n1179 4.5005
R1073 Isum.n875 Isum.n874 4.5005
R1074 Isum.n910 Isum.n909 4.5005
R1075 Isum.n929 Isum.n928 4.5005
R1076 Isum.n862 Isum.n861 4.5005
R1077 Isum.n934 Isum.n933 4.5005
R1078 Isum.n840 Isum.n799 4.5005
R1079 Isum.n1397 Isum.n1396 4.5005
R1080 Isum.n1395 Isum.n81 4.5005
R1081 Isum.n1394 Isum.n1393 4.5005
R1082 Isum.n1390 Isum.n82 4.5005
R1083 Isum.n1387 Isum.n83 4.5005
R1084 Isum.n1386 Isum.n84 4.5005
R1085 Isum.n1383 Isum.n85 4.5005
R1086 Isum.n1382 Isum.n86 4.5005
R1087 Isum.n1379 Isum.n87 4.5005
R1088 Isum.n1378 Isum.n88 4.5005
R1089 Isum.n1375 Isum.n89 4.5005
R1090 Isum.n1374 Isum.n90 4.5005
R1091 Isum.n1371 Isum.n91 4.5005
R1092 Isum.n1370 Isum.n92 4.5005
R1093 Isum.n1367 Isum.n93 4.5005
R1094 Isum.n1366 Isum.n94 4.5005
R1095 Isum.n1363 Isum.n95 4.5005
R1096 Isum.n1362 Isum.n96 4.5005
R1097 Isum.n1359 Isum.n97 4.5005
R1098 Isum.n1358 Isum.n98 4.5005
R1099 Isum.n1355 Isum.n99 4.5005
R1100 Isum.n1354 Isum.n100 4.5005
R1101 Isum.n1351 Isum.n101 4.5005
R1102 Isum.n1350 Isum.n102 4.5005
R1103 Isum.n1347 Isum.n103 4.5005
R1104 Isum.n1346 Isum.n104 4.5005
R1105 Isum.n1343 Isum.n105 4.5005
R1106 Isum.n1342 Isum.n106 4.5005
R1107 Isum.n1339 Isum.n107 4.5005
R1108 Isum.n1338 Isum.n108 4.5005
R1109 Isum.n1335 Isum.n109 4.5005
R1110 Isum.n1334 Isum.n110 4.5005
R1111 Isum.n1331 Isum.n111 4.5005
R1112 Isum.n1330 Isum.n1328 4.5005
R1113 Isum.n1398 Isum.n80 4.5005
R1114 Isum.n1072 Isum.n1071 4.5005
R1115 Isum.n1070 Isum.n733 4.5005
R1116 Isum.n1069 Isum.n1068 4.5005
R1117 Isum.n1065 Isum.n736 4.5005
R1118 Isum.n1064 Isum.n737 4.5005
R1119 Isum.n1061 Isum.n738 4.5005
R1120 Isum.n1060 Isum.n739 4.5005
R1121 Isum.n1057 Isum.n740 4.5005
R1122 Isum.n1056 Isum.n741 4.5005
R1123 Isum.n1053 Isum.n742 4.5005
R1124 Isum.n1052 Isum.n743 4.5005
R1125 Isum.n1049 Isum.n744 4.5005
R1126 Isum.n1048 Isum.n745 4.5005
R1127 Isum.n1045 Isum.n746 4.5005
R1128 Isum.n1044 Isum.n747 4.5005
R1129 Isum.n1041 Isum.n748 4.5005
R1130 Isum.n1040 Isum.n749 4.5005
R1131 Isum.n1037 Isum.n960 4.5005
R1132 Isum.n1036 Isum.n961 4.5005
R1133 Isum.n1033 Isum.n962 4.5005
R1134 Isum.n1032 Isum.n963 4.5005
R1135 Isum.n1029 Isum.n964 4.5005
R1136 Isum.n1028 Isum.n965 4.5005
R1137 Isum.n1025 Isum.n966 4.5005
R1138 Isum.n1024 Isum.n967 4.5005
R1139 Isum.n1021 Isum.n968 4.5005
R1140 Isum.n1020 Isum.n969 4.5005
R1141 Isum.n1017 Isum.n970 4.5005
R1142 Isum.n1016 Isum.n971 4.5005
R1143 Isum.n1013 Isum.n972 4.5005
R1144 Isum.n1012 Isum.n973 4.5005
R1145 Isum.n1009 Isum.n974 4.5005
R1146 Isum.n1008 Isum.n975 4.5005
R1147 Isum.n1005 Isum.n1002 4.5005
R1148 Isum.n1004 Isum.n112 4.5005
R1149 Isum.n1325 Isum.n1324 4.5005
R1150 Isum.n283 Isum.n279 4.5005
R1151 Isum.n285 Isum.n284 4.5005
R1152 Isum.n268 Isum.n267 4.5005
R1153 Isum.n357 Isum.n356 4.5005
R1154 Isum.n358 Isum.n266 4.5005
R1155 Isum.n360 Isum.n359 4.5005
R1156 Isum.n257 Isum.n256 4.5005
R1157 Isum.n554 Isum.n553 4.5005
R1158 Isum.n555 Isum.n255 4.5005
R1159 Isum.n557 Isum.n556 4.5005
R1160 Isum.n241 Isum.n240 4.5005
R1161 Isum.n570 Isum.n569 4.5005
R1162 Isum.n571 Isum.n239 4.5005
R1163 Isum.n573 Isum.n572 4.5005
R1164 Isum.n226 Isum.n225 4.5005
R1165 Isum.n586 Isum.n585 4.5005
R1166 Isum.n587 Isum.n224 4.5005
R1167 Isum.n589 Isum.n588 4.5005
R1168 Isum.n210 Isum.n209 4.5005
R1169 Isum.n602 Isum.n601 4.5005
R1170 Isum.n603 Isum.n208 4.5005
R1171 Isum.n605 Isum.n604 4.5005
R1172 Isum.n194 Isum.n193 4.5005
R1173 Isum.n618 Isum.n617 4.5005
R1174 Isum.n619 Isum.n192 4.5005
R1175 Isum.n621 Isum.n620 4.5005
R1176 Isum.n175 Isum.n174 4.5005
R1177 Isum.n643 Isum.n642 4.5005
R1178 Isum.n644 Isum.n173 4.5005
R1179 Isum.n647 Isum.n646 4.5005
R1180 Isum.n645 Isum.n139 4.5005
R1181 Isum.n702 Isum.n140 4.5005
R1182 Isum.n701 Isum.n141 4.5005
R1183 Isum.n700 Isum.n142 4.5005
R1184 Isum.n145 Isum.n143 4.5005
R1185 Isum.n695 Isum.n146 4.5005
R1186 Isum.n694 Isum.n147 4.5005
R1187 Isum.n150 Isum.n148 4.5005
R1188 Isum.n689 Isum.n151 4.5005
R1189 Isum.n688 Isum.n152 4.5005
R1190 Isum.n687 Isum.n153 4.5005
R1191 Isum.n683 Isum.n682 4.5005
R1192 Isum.n290 Isum.n289 4.5005
R1193 Isum.n291 Isum.n273 4.5005
R1194 Isum.n352 Isum.n292 4.5005
R1195 Isum.n351 Isum.n293 4.5005
R1196 Isum.n350 Isum.n294 4.5005
R1197 Isum.n349 Isum.n295 4.5005
R1198 Isum.n347 Isum.n296 4.5005
R1199 Isum.n346 Isum.n297 4.5005
R1200 Isum.n344 Isum.n298 4.5005
R1201 Isum.n343 Isum.n299 4.5005
R1202 Isum.n341 Isum.n300 4.5005
R1203 Isum.n340 Isum.n301 4.5005
R1204 Isum.n338 Isum.n302 4.5005
R1205 Isum.n337 Isum.n303 4.5005
R1206 Isum.n335 Isum.n304 4.5005
R1207 Isum.n334 Isum.n305 4.5005
R1208 Isum.n332 Isum.n306 4.5005
R1209 Isum.n331 Isum.n307 4.5005
R1210 Isum.n329 Isum.n308 4.5005
R1211 Isum.n328 Isum.n309 4.5005
R1212 Isum.n326 Isum.n310 4.5005
R1213 Isum.n325 Isum.n311 4.5005
R1214 Isum.n323 Isum.n312 4.5005
R1215 Isum.n322 Isum.n313 4.5005
R1216 Isum.n320 Isum.n314 4.5005
R1217 Isum.n319 Isum.n315 4.5005
R1218 Isum.n317 Isum.n316 4.5005
R1219 Isum.n167 Isum.n166 4.5005
R1220 Isum.n652 Isum.n651 4.5005
R1221 Isum.n653 Isum.n165 4.5005
R1222 Isum.n655 Isum.n654 4.5005
R1223 Isum.n657 Isum.n164 4.5005
R1224 Isum.n661 Isum.n660 4.5005
R1225 Isum.n662 Isum.n163 4.5005
R1226 Isum.n664 Isum.n663 4.5005
R1227 Isum.n667 Isum.n162 4.5005
R1228 Isum.n670 Isum.n669 4.5005
R1229 Isum.n671 Isum.n161 4.5005
R1230 Isum.n673 Isum.n672 4.5005
R1231 Isum.n155 Isum.n154 4.5005
R1232 Isum.n680 Isum.n679 4.5005
R1233 Isum.n275 Isum.n274 4.5005
R1234 Isum.n250 Isum.n249 4.5005
R1235 Isum.n562 Isum.n561 4.5005
R1236 Isum.n563 Isum.n248 4.5005
R1237 Isum.n565 Isum.n564 4.5005
R1238 Isum.n234 Isum.n233 4.5005
R1239 Isum.n578 Isum.n577 4.5005
R1240 Isum.n579 Isum.n232 4.5005
R1241 Isum.n581 Isum.n580 4.5005
R1242 Isum.n217 Isum.n216 4.5005
R1243 Isum.n594 Isum.n593 4.5005
R1244 Isum.n595 Isum.n215 4.5005
R1245 Isum.n597 Isum.n596 4.5005
R1246 Isum.n201 Isum.n200 4.5005
R1247 Isum.n610 Isum.n609 4.5005
R1248 Isum.n611 Isum.n199 4.5005
R1249 Isum.n613 Isum.n612 4.5005
R1250 Isum.n186 Isum.n185 4.5005
R1251 Isum.n626 Isum.n625 4.5005
R1252 Isum.n627 Isum.n183 4.5005
R1253 Isum.n638 Isum.n637 4.5005
R1254 Isum.n636 Isum.n184 4.5005
R1255 Isum.n635 Isum.n634 4.5005
R1256 Isum.n633 Isum.n628 4.5005
R1257 Isum.n632 Isum.n631 4.5005
R1258 Isum.n630 Isum.n57 4.5005
R1259 Isum.n1404 Isum.n56 4.5005
R1260 Isum.n1406 Isum.n1405 4.5005
R1261 Isum.n549 Isum.n548 4.5005
R1262 Isum.n408 Isum.n407 4.5005
R1263 Isum.n444 Isum.n443 4.5005
R1264 Isum.n543 Isum.n542 4.5005
R1265 Isum.n540 Isum.n368 4.5005
R1266 Isum.n539 Isum.n538 4.5005
R1267 Isum.n537 Isum.n536 4.5005
R1268 Isum.n535 Isum.n455 4.5005
R1269 Isum.n534 Isum.n533 4.5005
R1270 Isum.n532 Isum.n460 4.5005
R1271 Isum.n531 Isum.n530 4.5005
R1272 Isum.n529 Isum.n463 4.5005
R1273 Isum.n528 Isum.n527 4.5005
R1274 Isum.n526 Isum.n525 4.5005
R1275 Isum.n524 Isum.n472 4.5005
R1276 Isum.n523 Isum.n522 4.5005
R1277 Isum.n521 Isum.n520 4.5005
R1278 Isum.n519 Isum.n480 4.5005
R1279 Isum.n518 Isum.n517 4.5005
R1280 Isum.n516 Isum.n515 4.5005
R1281 Isum.n514 Isum.n487 4.5005
R1282 Isum.n513 Isum.n512 4.5005
R1283 Isum.n511 Isum.n510 4.5005
R1284 Isum.n509 Isum.n501 4.5005
R1285 Isum.n508 Isum.n507 4.5005
R1286 Isum.n132 Isum.n128 4.5005
R1287 Isum.n707 Isum.n706 4.5005
R1288 Isum.n131 Isum.n121 4.5005
R1289 Isum.n712 Isum.n711 4.5005
R1290 Isum.n127 Isum.n122 4.5005
R1291 Isum.n545 Isum.n544 4.5005
R1292 Isum.n806 Isum.n803 4.49281
R1293 Isum.n819 Isum.n811 4.49281
R1294 Isum.n757 Isum.n754 4.49281
R1295 Isum.n940 Isum.n762 4.49281
R1296 Isum.n859 Isum.n858 4.49281
R1297 Isum.n885 Isum.n790 4.49281
R1298 Isum.n899 Isum.n782 4.49281
R1299 Isum.n920 Isum.n919 4.49281
R1300 Isum.t3 Isum.n60 4.05241
R1301 Isum.n280 Isum.n276 4.05141
R1302 Isum.n451 Isum.n450 3.93127
R1303 Isum.n467 Isum.n466 3.93127
R1304 Isum.n491 Isum.n490 3.93127
R1305 Isum.n130 Isum.n129 3.93127
R1306 Isum.n435 Isum.n375 3.93127
R1307 Isum.n416 Isum.n387 3.93127
R1308 Isum.n709 Isum.t7 3.5285
R1309 Isum.t4 Isum.n709 3.5285
R1310 Isum.n497 Isum.t10 3.5285
R1311 Isum.n497 Isum.t7 3.5285
R1312 Isum.n496 Isum.t13 3.5285
R1313 Isum.t10 Isum.n496 3.5285
R1314 Isum.n495 Isum.t16 3.5285
R1315 Isum.t13 Isum.n495 3.5285
R1316 Isum.n494 Isum.t19 3.5285
R1317 Isum.t16 Isum.n494 3.5285
R1318 Isum.n493 Isum.t22 3.5285
R1319 Isum.t19 Isum.n493 3.5285
R1320 Isum.n492 Isum.t25 3.5285
R1321 Isum.t22 Isum.n492 3.5285
R1322 Isum.n863 Isum.n798 3.5285
R1323 Isum.n864 Isum.n863 3.5285
R1324 Isum.n913 Isum.n772 3.5285
R1325 Isum.n922 Isum.n772 3.5285
R1326 Isum.n914 Isum.n912 3.5285
R1327 Isum.n914 Isum.n913 3.5285
R1328 Isum.n911 Isum.n778 3.5285
R1329 Isum.n912 Isum.n911 3.5285
R1330 Isum.n879 Isum.n878 3.5285
R1331 Isum.n878 Isum.n778 3.5285
R1332 Isum.n881 Isum.n880 3.5285
R1333 Isum.n880 Isum.n879 3.5285
R1334 Isum.n882 Isum.n877 3.5285
R1335 Isum.n882 Isum.n881 3.5285
R1336 Isum.n876 Isum.n792 3.5285
R1337 Isum.n877 Isum.n876 3.5285
R1338 Isum.n865 Isum.n864 3.5285
R1339 Isum.n865 Isum.n792 3.5285
R1340 Isum.n1000 Isum.n998 3.5285
R1341 Isum.n1001 Isum.n1000 3.5285
R1342 Isum.n997 Isum.n995 3.5285
R1343 Isum.n998 Isum.n997 3.5285
R1344 Isum.n994 Isum.n992 3.5285
R1345 Isum.n995 Isum.n994 3.5285
R1346 Isum.n991 Isum.n989 3.5285
R1347 Isum.n992 Isum.n991 3.5285
R1348 Isum.n988 Isum.n987 3.5285
R1349 Isum.n989 Isum.n988 3.5285
R1350 Isum.n986 Isum.n984 3.5285
R1351 Isum.n987 Isum.n986 3.5285
R1352 Isum.n983 Isum.n981 3.5285
R1353 Isum.n984 Isum.n983 3.5285
R1354 Isum.n980 Isum.n978 3.5285
R1355 Isum.n981 Isum.n980 3.5285
R1356 Isum.n977 Isum.n735 3.5285
R1357 Isum.n978 Isum.n977 3.5285
R1358 Isum.n406 Isum.t35 3.5285
R1359 Isum.t33 Isum.n406 3.5285
R1360 Isum.n404 Isum.t37 3.5285
R1361 Isum.t35 Isum.n404 3.5285
R1362 Isum.n403 Isum.t39 3.5285
R1363 Isum.t37 Isum.n403 3.5285
R1364 Isum.n402 Isum.t41 3.5285
R1365 Isum.t39 Isum.n402 3.5285
R1366 Isum.n401 Isum.t43 3.5285
R1367 Isum.t41 Isum.n401 3.5285
R1368 Isum.n400 Isum.t45 3.5285
R1369 Isum.t43 Isum.n400 3.5285
R1370 Isum.n399 Isum.t47 3.5285
R1371 Isum.t45 Isum.n399 3.5285
R1372 Isum.n815 Isum.n814 3.36973
R1373 Isum.n958 Isum.n957 3.36973
R1374 Isum.n890 Isum.n787 3.36973
R1375 Isum.n894 Isum.n893 3.36973
R1376 Isum.n1173 Isum.n1172 3.11744
R1377 Isum.n1168 Isum.n1104 3.11744
R1378 Isum.n1166 Isum.n1165 3.11744
R1379 Isum.n1161 Isum.n1111 3.11744
R1380 Isum.n1159 Isum.n1158 3.11744
R1381 Isum.n1154 Isum.n1118 3.11744
R1382 Isum.n1152 Isum.n1151 3.11744
R1383 Isum.n1147 Isum.n1125 3.11744
R1384 Isum.n1145 Isum.n1144 3.11744
R1385 Isum.n1140 Isum.n1132 3.11744
R1386 Isum.n1138 Isum.n1137 3.11744
R1387 Isum.n1453 Isum.n4 3.11744
R1388 Isum.n1451 Isum.n1450 3.11744
R1389 Isum.n1446 Isum.n11 3.11744
R1390 Isum.n1444 Isum.n1443 3.11744
R1391 Isum.n1439 Isum.n18 3.11744
R1392 Isum.n1437 Isum.n1436 3.11744
R1393 Isum.n1432 Isum.n25 3.11744
R1394 Isum.n1430 Isum.n1429 3.11744
R1395 Isum.n1425 Isum.n32 3.11744
R1396 Isum.n1423 Isum.n1422 3.11744
R1397 Isum.n1418 Isum.n39 3.11744
R1398 Isum.n1416 Isum.n1415 3.11744
R1399 Isum.n1411 Isum.n45 3.11744
R1400 Isum.n1293 Isum.n1095 3.11744
R1401 Isum.n1291 Isum.n1094 3.11744
R1402 Isum.n1287 Isum.n1093 3.11744
R1403 Isum.n1283 Isum.n1092 3.11744
R1404 Isum.n1279 Isum.n1091 3.11744
R1405 Isum.n1275 Isum.n1090 3.11744
R1406 Isum.n1271 Isum.n1089 3.11744
R1407 Isum.n1267 Isum.n1088 3.11744
R1408 Isum.n1263 Isum.n1087 3.11744
R1409 Isum.n1259 Isum.n1086 3.11744
R1410 Isum.n1255 Isum.n1085 3.11744
R1411 Isum.n1251 Isum.n1084 3.11744
R1412 Isum.n1247 Isum.n1083 3.11744
R1413 Isum.n1243 Isum.n1082 3.11744
R1414 Isum.n1239 Isum.n1081 3.11744
R1415 Isum.n1235 Isum.n1080 3.11744
R1416 Isum.n1231 Isum.n1079 3.11744
R1417 Isum.n1227 Isum.n1078 3.11744
R1418 Isum.n1223 Isum.n1077 3.11744
R1419 Isum.n1219 Isum.n1076 3.11744
R1420 Isum.n1321 Isum.n118 3.11744
R1421 Isum.n1319 Isum.n1318 3.11744
R1422 Isum.n1314 Isum.n1311 3.11744
R1423 Isum.n1312 Isum.n46 3.11744
R1424 Isum.n1391 Isum.n78 3.11744
R1425 Isum.n1389 Isum.n77 3.11744
R1426 Isum.n1385 Isum.n76 3.11744
R1427 Isum.n1381 Isum.n75 3.11744
R1428 Isum.n1377 Isum.n74 3.11744
R1429 Isum.n1373 Isum.n73 3.11744
R1430 Isum.n1369 Isum.n72 3.11744
R1431 Isum.n1365 Isum.n71 3.11744
R1432 Isum.n1361 Isum.n70 3.11744
R1433 Isum.n1357 Isum.n69 3.11744
R1434 Isum.n1353 Isum.n68 3.11744
R1435 Isum.n1349 Isum.n67 3.11744
R1436 Isum.n1345 Isum.n66 3.11744
R1437 Isum.n1341 Isum.n65 3.11744
R1438 Isum.n1337 Isum.n64 3.11744
R1439 Isum.n1333 Isum.n63 3.11744
R1440 Isum.n1329 Isum.n62 3.11744
R1441 Isum.n1067 Isum.n731 3.11744
R1442 Isum.n1063 Isum.n730 3.11744
R1443 Isum.n1059 Isum.n729 3.11744
R1444 Isum.n1055 Isum.n728 3.11744
R1445 Isum.n1051 Isum.n727 3.11744
R1446 Isum.n1047 Isum.n726 3.11744
R1447 Isum.n1043 Isum.n725 3.11744
R1448 Isum.n1039 Isum.n724 3.11744
R1449 Isum.n1035 Isum.n723 3.11744
R1450 Isum.n1031 Isum.n722 3.11744
R1451 Isum.n1027 Isum.n721 3.11744
R1452 Isum.n1023 Isum.n720 3.11744
R1453 Isum.n1019 Isum.n719 3.11744
R1454 Isum.n1015 Isum.n718 3.11744
R1455 Isum.n1011 Isum.n717 3.11744
R1456 Isum.n1007 Isum.n716 3.11744
R1457 Isum.n1003 Isum.n715 3.11744
R1458 Isum.n698 Isum.n138 3.11744
R1459 Isum.n696 Isum.n144 3.11744
R1460 Isum.n692 Isum.n691 3.11744
R1461 Isum.n685 Isum.n149 3.11744
R1462 Isum.n659 Isum.n157 3.11744
R1463 Isum.n665 Isum.n158 3.11744
R1464 Isum.n668 Isum.n159 3.11744
R1465 Isum.n675 Isum.n674 3.11744
R1466 Isum.n678 Isum.n677 3.11744
R1467 Isum.n1006 Isum.n715 3.11744
R1468 Isum.n1010 Isum.n716 3.11744
R1469 Isum.n1014 Isum.n717 3.11744
R1470 Isum.n1018 Isum.n718 3.11744
R1471 Isum.n1022 Isum.n719 3.11744
R1472 Isum.n1026 Isum.n720 3.11744
R1473 Isum.n1030 Isum.n721 3.11744
R1474 Isum.n1034 Isum.n722 3.11744
R1475 Isum.n1038 Isum.n723 3.11744
R1476 Isum.n1042 Isum.n724 3.11744
R1477 Isum.n1046 Isum.n725 3.11744
R1478 Isum.n1050 Isum.n726 3.11744
R1479 Isum.n1054 Isum.n727 3.11744
R1480 Isum.n1058 Isum.n728 3.11744
R1481 Isum.n1062 Isum.n729 3.11744
R1482 Isum.n1066 Isum.n730 3.11744
R1483 Isum.n732 Isum.n731 3.11744
R1484 Isum.n1332 Isum.n62 3.11744
R1485 Isum.n1336 Isum.n63 3.11744
R1486 Isum.n1340 Isum.n64 3.11744
R1487 Isum.n1344 Isum.n65 3.11744
R1488 Isum.n1348 Isum.n66 3.11744
R1489 Isum.n1352 Isum.n67 3.11744
R1490 Isum.n1356 Isum.n68 3.11744
R1491 Isum.n1360 Isum.n69 3.11744
R1492 Isum.n1364 Isum.n70 3.11744
R1493 Isum.n1368 Isum.n71 3.11744
R1494 Isum.n1372 Isum.n72 3.11744
R1495 Isum.n1376 Isum.n73 3.11744
R1496 Isum.n1380 Isum.n74 3.11744
R1497 Isum.n1384 Isum.n75 3.11744
R1498 Isum.n1388 Isum.n76 3.11744
R1499 Isum.n1392 Isum.n77 3.11744
R1500 Isum.n79 Isum.n78 3.11744
R1501 Isum.n1313 Isum.n1312 3.11744
R1502 Isum.n1311 Isum.n1303 3.11744
R1503 Isum.n1320 Isum.n1319 3.11744
R1504 Isum.n1218 Isum.n118 3.11744
R1505 Isum.n1222 Isum.n1076 3.11744
R1506 Isum.n1226 Isum.n1077 3.11744
R1507 Isum.n1230 Isum.n1078 3.11744
R1508 Isum.n1234 Isum.n1079 3.11744
R1509 Isum.n1238 Isum.n1080 3.11744
R1510 Isum.n1242 Isum.n1081 3.11744
R1511 Isum.n1246 Isum.n1082 3.11744
R1512 Isum.n1250 Isum.n1083 3.11744
R1513 Isum.n1254 Isum.n1084 3.11744
R1514 Isum.n1258 Isum.n1085 3.11744
R1515 Isum.n1262 Isum.n1086 3.11744
R1516 Isum.n1266 Isum.n1087 3.11744
R1517 Isum.n1270 Isum.n1088 3.11744
R1518 Isum.n1274 Isum.n1089 3.11744
R1519 Isum.n1278 Isum.n1090 3.11744
R1520 Isum.n1282 Isum.n1091 3.11744
R1521 Isum.n1286 Isum.n1092 3.11744
R1522 Isum.n1290 Isum.n1093 3.11744
R1523 Isum.n1294 Isum.n1094 3.11744
R1524 Isum.n1096 Isum.n1095 3.11744
R1525 Isum.n45 Isum.n40 3.11744
R1526 Isum.n1417 Isum.n1416 3.11744
R1527 Isum.n39 Isum.n33 3.11744
R1528 Isum.n1424 Isum.n1423 3.11744
R1529 Isum.n32 Isum.n26 3.11744
R1530 Isum.n1431 Isum.n1430 3.11744
R1531 Isum.n25 Isum.n19 3.11744
R1532 Isum.n1438 Isum.n1437 3.11744
R1533 Isum.n18 Isum.n12 3.11744
R1534 Isum.n1445 Isum.n1444 3.11744
R1535 Isum.n11 Isum.n6 3.11744
R1536 Isum.n1452 Isum.n1451 3.11744
R1537 Isum.n1133 Isum.n4 3.11744
R1538 Isum.n1139 Isum.n1138 3.11744
R1539 Isum.n1132 Isum.n1126 3.11744
R1540 Isum.n1146 Isum.n1145 3.11744
R1541 Isum.n1125 Isum.n1119 3.11744
R1542 Isum.n1153 Isum.n1152 3.11744
R1543 Isum.n1118 Isum.n1112 3.11744
R1544 Isum.n1160 Isum.n1159 3.11744
R1545 Isum.n1111 Isum.n1105 3.11744
R1546 Isum.n1167 Isum.n1166 3.11744
R1547 Isum.n1104 Isum.n1099 3.11744
R1548 Isum.n1174 Isum.n1173 3.11744
R1549 Isum.n677 Isum.n156 3.11744
R1550 Isum.n675 Isum.n160 3.11744
R1551 Isum.n666 Isum.n159 3.11744
R1552 Isum.n658 Isum.n158 3.11744
R1553 Isum.n656 Isum.n157 3.11744
R1554 Isum.n699 Isum.n698 3.11744
R1555 Isum.n693 Isum.n144 3.11744
R1556 Isum.n691 Isum.n690 3.11744
R1557 Isum.n686 Isum.n685 3.11744
R1558 Isum.n714 Isum.n120 3.11744
R1559 Isum.n714 Isum.n713 3.11744
R1560 Isum.n1402 Isum.n54 3.11744
R1561 Isum.n1403 Isum.n1402 3.11744
R1562 Isum.n842 Isum.n841 2.8355
R1563 Isum.n841 Isum.n800 2.8355
R1564 Isum.n768 Isum.n767 2.8355
R1565 Isum.n769 Isum.n768 2.8355
R1566 Isum.n458 Isum.n457 2.80819
R1567 Isum.n459 Isum.n458 2.80819
R1568 Isum.n504 Isum.n503 2.80819
R1569 Isum.n506 Isum.n504 2.80819
R1570 Isum.n374 Isum.n371 2.80819
R1571 Isum.n437 Isum.n374 2.80819
R1572 Isum.n390 Isum.n388 2.80819
R1573 Isum.n411 Isum.n390 2.80819
R1574 Isum.n442 Isum.t46 2.73469
R1575 Isum.n409 Isum.t32 2.73469
R1576 Isum.n838 Isum.n800 2.38762
R1577 Isum.n769 Isum.n766 2.38762
R1578 Isum.n447 Isum.n369 2.35281
R1579 Isum.n396 Isum.n395 2.35281
R1580 Isum.t28 Isum.n394 2.27503
R1581 Isum.t31 Isum.n365 2.26755
R1582 Isum.n836 Isum.n835 2.24665
R1583 Isum.n817 Isum.n815 2.24665
R1584 Isum.n957 Isum.n956 2.24665
R1585 Isum.n938 Isum.n765 2.24665
R1586 Isum.n853 Isum.n850 2.24665
R1587 Isum.n887 Isum.n787 2.24665
R1588 Isum.n893 Isum.n784 2.24665
R1589 Isum.n925 Isum.n924 2.24665
R1590 Isum.t18 Isum.t48 1.78491
R1591 Isum.t0 Isum.t9 1.78491
R1592 Isum.n468 Isum.n467 1.68512
R1593 Isum.n490 Isum.n489 1.68512
R1594 Isum.n432 Isum.n375 1.68512
R1595 Isum.n387 Isum.n385 1.68512
R1596 Isum.n395 Isum.n393 1.66246
R1597 Isum.n449 Isum.n369 1.65213
R1598 Isum.n369 Isum.t31 1.3415
R1599 Isum.n395 Isum.t28 1.3415
R1600 Isum.n830 Isum.n806 1.12358
R1601 Isum.n822 Isum.n811 1.12358
R1602 Isum.n951 Isum.n757 1.12358
R1603 Isum.n943 Isum.n762 1.12358
R1604 Isum.n858 Isum.n857 1.12358
R1605 Isum.n871 Isum.n790 1.12358
R1606 Isum.n902 Isum.n782 1.12358
R1607 Isum.n919 Isum.n918 1.12358
R1608 Isum.n280 Isum.n277 1.07718
R1609 Isum.n1074 Isum.n715 1.04278
R1610 Isum.n1074 Isum.n716 1.04278
R1611 Isum.n1074 Isum.n717 1.04278
R1612 Isum.n1074 Isum.n718 1.04278
R1613 Isum.n1074 Isum.n719 1.04278
R1614 Isum.n1074 Isum.n720 1.04278
R1615 Isum.n1074 Isum.n721 1.04278
R1616 Isum.n1074 Isum.n722 1.04278
R1617 Isum.n1074 Isum.n723 1.04278
R1618 Isum.n1074 Isum.n724 1.04278
R1619 Isum.n1074 Isum.n725 1.04278
R1620 Isum.n1074 Isum.n726 1.04278
R1621 Isum.n1074 Isum.n727 1.04278
R1622 Isum.n1074 Isum.n728 1.04278
R1623 Isum.n1074 Isum.n729 1.04278
R1624 Isum.n1074 Isum.n730 1.04278
R1625 Isum.n1074 Isum.n731 1.04278
R1626 Isum.n1400 Isum.n62 1.04278
R1627 Isum.n1400 Isum.n63 1.04278
R1628 Isum.n1400 Isum.n64 1.04278
R1629 Isum.n1400 Isum.n65 1.04278
R1630 Isum.n1400 Isum.n66 1.04278
R1631 Isum.n1400 Isum.n67 1.04278
R1632 Isum.n1400 Isum.n68 1.04278
R1633 Isum.n1400 Isum.n69 1.04278
R1634 Isum.n1400 Isum.n70 1.04278
R1635 Isum.n1400 Isum.n71 1.04278
R1636 Isum.n1400 Isum.n72 1.04278
R1637 Isum.n1400 Isum.n73 1.04278
R1638 Isum.n1400 Isum.n74 1.04278
R1639 Isum.n1400 Isum.n75 1.04278
R1640 Isum.n1400 Isum.n76 1.04278
R1641 Isum.n1400 Isum.n77 1.04278
R1642 Isum.n1400 Isum.n78 1.04278
R1643 Isum.n1312 Isum.n1302 1.04278
R1644 Isum.n1311 Isum.n1302 1.04278
R1645 Isum.n1319 Isum.n1302 1.04278
R1646 Isum.n1302 Isum.n118 1.04278
R1647 Isum.n1302 Isum.n1076 1.04278
R1648 Isum.n1302 Isum.n1077 1.04278
R1649 Isum.n1302 Isum.n1078 1.04278
R1650 Isum.n1302 Isum.n1079 1.04278
R1651 Isum.n1302 Isum.n1080 1.04278
R1652 Isum.n1302 Isum.n1081 1.04278
R1653 Isum.n1302 Isum.n1082 1.04278
R1654 Isum.n1302 Isum.n1083 1.04278
R1655 Isum.n1302 Isum.n1084 1.04278
R1656 Isum.n1302 Isum.n1085 1.04278
R1657 Isum.n1302 Isum.n1086 1.04278
R1658 Isum.n1302 Isum.n1087 1.04278
R1659 Isum.n1302 Isum.n1088 1.04278
R1660 Isum.n1302 Isum.n1089 1.04278
R1661 Isum.n1302 Isum.n1090 1.04278
R1662 Isum.n1302 Isum.n1091 1.04278
R1663 Isum.n1302 Isum.n1092 1.04278
R1664 Isum.n1302 Isum.n1093 1.04278
R1665 Isum.n1302 Isum.n1094 1.04278
R1666 Isum.n1302 Isum.n1095 1.04278
R1667 Isum.n45 Isum.n5 1.04278
R1668 Isum.n1416 Isum.n5 1.04278
R1669 Isum.n39 Isum.n5 1.04278
R1670 Isum.n1423 Isum.n5 1.04278
R1671 Isum.n32 Isum.n5 1.04278
R1672 Isum.n1430 Isum.n5 1.04278
R1673 Isum.n25 Isum.n5 1.04278
R1674 Isum.n1437 Isum.n5 1.04278
R1675 Isum.n18 Isum.n5 1.04278
R1676 Isum.n1444 Isum.n5 1.04278
R1677 Isum.n11 Isum.n5 1.04278
R1678 Isum.n1451 Isum.n5 1.04278
R1679 Isum.n5 Isum.n4 1.04278
R1680 Isum.n1138 Isum.n5 1.04278
R1681 Isum.n1132 Isum.n5 1.04278
R1682 Isum.n1145 Isum.n5 1.04278
R1683 Isum.n1125 Isum.n5 1.04278
R1684 Isum.n1152 Isum.n5 1.04278
R1685 Isum.n1118 Isum.n5 1.04278
R1686 Isum.n1159 Isum.n5 1.04278
R1687 Isum.n1111 Isum.n5 1.04278
R1688 Isum.n1166 Isum.n5 1.04278
R1689 Isum.n1104 Isum.n5 1.04278
R1690 Isum.n1173 Isum.n5 1.04278
R1691 Isum.n677 Isum.n676 1.04278
R1692 Isum.n676 Isum.n675 1.04278
R1693 Isum.n676 Isum.n159 1.04278
R1694 Isum.n676 Isum.n158 1.04278
R1695 Isum.n676 Isum.n157 1.04278
R1696 Isum.n698 Isum.n119 1.04278
R1697 Isum.n144 Isum.n119 1.04278
R1698 Isum.n691 Isum.n119 1.04278
R1699 Isum.n685 Isum.n119 1.04278
R1700 Isum.n1075 Isum.n714 1.04278
R1701 Isum.n1402 Isum.n1401 1.04278
R1702 Isum.n846 Isum.n793 0.9221
R1703 Isum.n793 Isum.n785 0.9221
R1704 Isum.n785 Isum.n771 0.9221
R1705 Isum.n930 Isum.n771 0.9221
R1706 Isum.n450 Isum.t23 0.913
R1707 Isum.n458 Isum.t20 0.913
R1708 Isum.n467 Isum.t17 0.913
R1709 Isum.n474 Isum.t14 0.913
R1710 Isum.n483 Isum.t11 0.913
R1711 Isum.n490 Isum.t8 0.913
R1712 Isum.n504 Isum.t5 0.913
R1713 Isum.n130 Isum.t2 0.913
R1714 Isum.n759 Isum.n758 0.913
R1715 Isum.n808 Isum.n807 0.913
R1716 Isum.n836 Isum.n802 0.913
R1717 Isum.n806 Isum.n805 0.913
R1718 Isum.n811 Isum.n810 0.913
R1719 Isum.n815 Isum.n813 0.913
R1720 Isum.n957 Isum.n753 0.913
R1721 Isum.n757 Isum.n756 0.913
R1722 Isum.n762 Isum.n761 0.913
R1723 Isum.n765 Isum.n764 0.913
R1724 Isum.n906 Isum.n904 0.913
R1725 Isum.n869 Isum.n795 0.913
R1726 Isum.n850 Isum.n849 0.913
R1727 Isum.n858 Isum.n855 0.913
R1728 Isum.n790 Isum.n789 0.913
R1729 Isum.n787 Isum.n786 0.913
R1730 Isum.n893 Isum.n892 0.913
R1731 Isum.n782 Isum.n781 0.913
R1732 Isum.n919 Isum.n775 0.913
R1733 Isum.n924 Isum.n921 0.913
R1734 Isum.n374 Isum.t44 0.913
R1735 Isum.n375 Isum.t42 0.913
R1736 Isum.n378 Isum.t40 0.913
R1737 Isum.n384 Isum.t38 0.913
R1738 Isum.n387 Isum.t36 0.913
R1739 Isum.n390 Isum.t34 0.913
R1740 Isum.n125 Isum.n124 0.7511
R1741 Isum.n475 Isum.n474 0.562038
R1742 Isum.n483 Isum.n482 0.562038
R1743 Isum.n427 Isum.n378 0.562038
R1744 Isum.n384 Isum.n381 0.562038
R1745 Isum.n394 Isum.n55 0.462063
R1746 Isum.n546 Isum.n365 0.437113
R1747 Isum.n931 Isum.n930 0.434069
R1748 Isum.n846 Isum.n845 0.434069
R1749 Isum.n734 Isum.n50 0.186214
R1750 Isum.n1409 Isum.n50 0.186214
R1751 Isum.n1327 Isum.n51 0.186214
R1752 Isum.n1409 Isum.n51 0.186214
R1753 Isum.n1408 Isum.n1407 0.168242
R1754 Isum.n1409 Isum.n1408 0.168242
R1755 Isum.n547 Isum.n364 0.168242
R1756 Isum.n364 Isum.n363 0.168242
R1757 Isum.n549 Isum.n250 0.1445
R1758 Isum.n561 Isum.n250 0.1445
R1759 Isum.n561 Isum.n248 0.1445
R1760 Isum.n565 Isum.n248 0.1445
R1761 Isum.n565 Isum.n234 0.1445
R1762 Isum.n577 Isum.n234 0.1445
R1763 Isum.n577 Isum.n232 0.1445
R1764 Isum.n581 Isum.n232 0.1445
R1765 Isum.n581 Isum.n217 0.1445
R1766 Isum.n593 Isum.n217 0.1445
R1767 Isum.n593 Isum.n215 0.1445
R1768 Isum.n597 Isum.n215 0.1445
R1769 Isum.n597 Isum.n201 0.1445
R1770 Isum.n609 Isum.n201 0.1445
R1771 Isum.n609 Isum.n199 0.1445
R1772 Isum.n613 Isum.n199 0.1445
R1773 Isum.n613 Isum.n186 0.1445
R1774 Isum.n625 Isum.n186 0.1445
R1775 Isum.n625 Isum.n183 0.1445
R1776 Isum.n638 Isum.n183 0.1445
R1777 Isum.n638 Isum.n184 0.1445
R1778 Isum.n634 Isum.n184 0.1445
R1779 Isum.n634 Isum.n633 0.1445
R1780 Isum.n633 Isum.n632 0.1445
R1781 Isum.n632 Isum.n57 0.1445
R1782 Isum.n1404 Isum.n57 0.1445
R1783 Isum.n1405 Isum.n1404 0.1445
R1784 Isum.n289 Isum.n275 0.1445
R1785 Isum.n289 Isum.n273 0.1445
R1786 Isum.n352 Isum.n273 0.1445
R1787 Isum.n352 Isum.n351 0.1445
R1788 Isum.n351 Isum.n350 0.1445
R1789 Isum.n350 Isum.n349 0.1445
R1790 Isum.n349 Isum.n347 0.1445
R1791 Isum.n347 Isum.n346 0.1445
R1792 Isum.n346 Isum.n344 0.1445
R1793 Isum.n344 Isum.n343 0.1445
R1794 Isum.n343 Isum.n341 0.1445
R1795 Isum.n341 Isum.n340 0.1445
R1796 Isum.n340 Isum.n338 0.1445
R1797 Isum.n338 Isum.n337 0.1445
R1798 Isum.n337 Isum.n335 0.1445
R1799 Isum.n335 Isum.n334 0.1445
R1800 Isum.n334 Isum.n332 0.1445
R1801 Isum.n332 Isum.n331 0.1445
R1802 Isum.n331 Isum.n329 0.1445
R1803 Isum.n329 Isum.n328 0.1445
R1804 Isum.n328 Isum.n326 0.1445
R1805 Isum.n326 Isum.n325 0.1445
R1806 Isum.n325 Isum.n323 0.1445
R1807 Isum.n323 Isum.n322 0.1445
R1808 Isum.n322 Isum.n320 0.1445
R1809 Isum.n320 Isum.n319 0.1445
R1810 Isum.n319 Isum.n317 0.1445
R1811 Isum.n317 Isum.n167 0.1445
R1812 Isum.n651 Isum.n167 0.1445
R1813 Isum.n651 Isum.n165 0.1445
R1814 Isum.n655 Isum.n165 0.1445
R1815 Isum.n657 Isum.n655 0.1445
R1816 Isum.n660 Isum.n657 0.1445
R1817 Isum.n660 Isum.n163 0.1445
R1818 Isum.n664 Isum.n163 0.1445
R1819 Isum.n667 Isum.n664 0.1445
R1820 Isum.n669 Isum.n667 0.1445
R1821 Isum.n669 Isum.n161 0.1445
R1822 Isum.n673 Isum.n161 0.1445
R1823 Isum.n673 Isum.n155 0.1445
R1824 Isum.n679 Isum.n155 0.1445
R1825 Isum.n1300 Isum.n1299 0.1445
R1826 Isum.n1299 Isum.n1180 0.1445
R1827 Isum.n1295 Isum.n1180 0.1445
R1828 Isum.n1295 Isum.n1292 0.1445
R1829 Isum.n1292 Isum.n1289 0.1445
R1830 Isum.n1289 Isum.n1288 0.1445
R1831 Isum.n1288 Isum.n1285 0.1445
R1832 Isum.n1285 Isum.n1284 0.1445
R1833 Isum.n1284 Isum.n1281 0.1445
R1834 Isum.n1281 Isum.n1280 0.1445
R1835 Isum.n1280 Isum.n1277 0.1445
R1836 Isum.n1277 Isum.n1276 0.1445
R1837 Isum.n1276 Isum.n1273 0.1445
R1838 Isum.n1273 Isum.n1272 0.1445
R1839 Isum.n1272 Isum.n1269 0.1445
R1840 Isum.n1269 Isum.n1268 0.1445
R1841 Isum.n1268 Isum.n1265 0.1445
R1842 Isum.n1265 Isum.n1264 0.1445
R1843 Isum.n1264 Isum.n1261 0.1445
R1844 Isum.n1261 Isum.n1260 0.1445
R1845 Isum.n1260 Isum.n1257 0.1445
R1846 Isum.n1257 Isum.n1256 0.1445
R1847 Isum.n1256 Isum.n1253 0.1445
R1848 Isum.n1253 Isum.n1252 0.1445
R1849 Isum.n1252 Isum.n1249 0.1445
R1850 Isum.n1249 Isum.n1248 0.1445
R1851 Isum.n1248 Isum.n1245 0.1445
R1852 Isum.n1245 Isum.n1244 0.1445
R1853 Isum.n1244 Isum.n1241 0.1445
R1854 Isum.n1241 Isum.n1240 0.1445
R1855 Isum.n1240 Isum.n1237 0.1445
R1856 Isum.n1237 Isum.n1236 0.1445
R1857 Isum.n1236 Isum.n1233 0.1445
R1858 Isum.n1233 Isum.n1232 0.1445
R1859 Isum.n1232 Isum.n1229 0.1445
R1860 Isum.n1229 Isum.n1228 0.1445
R1861 Isum.n1228 Isum.n1225 0.1445
R1862 Isum.n1225 Isum.n1224 0.1445
R1863 Isum.n1224 Isum.n1221 0.1445
R1864 Isum.n1221 Isum.n1220 0.1445
R1865 Isum.n1220 Isum.n116 0.1445
R1866 Isum.n1322 Isum.n116 0.1445
R1867 Isum.n1322 Isum.n117 0.1445
R1868 Isum.n1317 Isum.n117 0.1445
R1869 Isum.n1317 Isum.n1316 0.1445
R1870 Isum.n1316 Isum.n1315 0.1445
R1871 Isum.n1315 Isum.n1310 0.1445
R1872 Isum.n1310 Isum.n1309 0.1445
R1873 Isum.n1176 Isum.n1098 0.1445
R1874 Isum.n1171 Isum.n1098 0.1445
R1875 Isum.n1171 Isum.n1170 0.1445
R1876 Isum.n1170 Isum.n1169 0.1445
R1877 Isum.n1169 Isum.n1103 0.1445
R1878 Isum.n1164 Isum.n1103 0.1445
R1879 Isum.n1164 Isum.n1163 0.1445
R1880 Isum.n1163 Isum.n1162 0.1445
R1881 Isum.n1162 Isum.n1110 0.1445
R1882 Isum.n1157 Isum.n1110 0.1445
R1883 Isum.n1157 Isum.n1156 0.1445
R1884 Isum.n1156 Isum.n1155 0.1445
R1885 Isum.n1155 Isum.n1117 0.1445
R1886 Isum.n1150 Isum.n1117 0.1445
R1887 Isum.n1150 Isum.n1149 0.1445
R1888 Isum.n1149 Isum.n1148 0.1445
R1889 Isum.n1148 Isum.n1124 0.1445
R1890 Isum.n1143 Isum.n1124 0.1445
R1891 Isum.n1143 Isum.n1142 0.1445
R1892 Isum.n1142 Isum.n1141 0.1445
R1893 Isum.n1141 Isum.n1131 0.1445
R1894 Isum.n1136 Isum.n1131 0.1445
R1895 Isum.n1136 Isum.n2 0.1445
R1896 Isum.n1454 Isum.n2 0.1445
R1897 Isum.n1454 Isum.n3 0.1445
R1898 Isum.n1449 Isum.n3 0.1445
R1899 Isum.n1449 Isum.n1448 0.1445
R1900 Isum.n1448 Isum.n1447 0.1445
R1901 Isum.n1447 Isum.n10 0.1445
R1902 Isum.n1442 Isum.n10 0.1445
R1903 Isum.n1442 Isum.n1441 0.1445
R1904 Isum.n1441 Isum.n1440 0.1445
R1905 Isum.n1440 Isum.n17 0.1445
R1906 Isum.n1435 Isum.n17 0.1445
R1907 Isum.n1435 Isum.n1434 0.1445
R1908 Isum.n1434 Isum.n1433 0.1445
R1909 Isum.n1433 Isum.n24 0.1445
R1910 Isum.n1428 Isum.n24 0.1445
R1911 Isum.n1428 Isum.n1427 0.1445
R1912 Isum.n1427 Isum.n1426 0.1445
R1913 Isum.n1426 Isum.n31 0.1445
R1914 Isum.n1421 Isum.n31 0.1445
R1915 Isum.n1421 Isum.n1420 0.1445
R1916 Isum.n1420 Isum.n1419 0.1445
R1917 Isum.n1419 Isum.n38 0.1445
R1918 Isum.n1414 Isum.n38 0.1445
R1919 Isum.n1414 Isum.n1413 0.1445
R1920 Isum.n1413 Isum.n1412 0.1445
R1921 Isum.n1177 Isum.n1097 0.1445
R1922 Isum.n1100 Isum.n1097 0.1445
R1923 Isum.n1101 Isum.n1100 0.1445
R1924 Isum.n1102 Isum.n1101 0.1445
R1925 Isum.n1106 Isum.n1102 0.1445
R1926 Isum.n1107 Isum.n1106 0.1445
R1927 Isum.n1108 Isum.n1107 0.1445
R1928 Isum.n1109 Isum.n1108 0.1445
R1929 Isum.n1113 Isum.n1109 0.1445
R1930 Isum.n1114 Isum.n1113 0.1445
R1931 Isum.n1115 Isum.n1114 0.1445
R1932 Isum.n1116 Isum.n1115 0.1445
R1933 Isum.n1120 Isum.n1116 0.1445
R1934 Isum.n1121 Isum.n1120 0.1445
R1935 Isum.n1122 Isum.n1121 0.1445
R1936 Isum.n1123 Isum.n1122 0.1445
R1937 Isum.n1127 Isum.n1123 0.1445
R1938 Isum.n1128 Isum.n1127 0.1445
R1939 Isum.n1129 Isum.n1128 0.1445
R1940 Isum.n1130 Isum.n1129 0.1445
R1941 Isum.n1134 Isum.n1130 0.1445
R1942 Isum.n1135 Isum.n1134 0.1445
R1943 Isum.n1135 Isum.n0 0.1445
R1944 VSS Isum.n0 0.1445
R1945 VSS Isum.n1 0.1445
R1946 Isum.n7 Isum.n1 0.1445
R1947 Isum.n8 Isum.n7 0.1445
R1948 Isum.n9 Isum.n8 0.1445
R1949 Isum.n13 Isum.n9 0.1445
R1950 Isum.n14 Isum.n13 0.1445
R1951 Isum.n15 Isum.n14 0.1445
R1952 Isum.n16 Isum.n15 0.1445
R1953 Isum.n20 Isum.n16 0.1445
R1954 Isum.n21 Isum.n20 0.1445
R1955 Isum.n22 Isum.n21 0.1445
R1956 Isum.n23 Isum.n22 0.1445
R1957 Isum.n27 Isum.n23 0.1445
R1958 Isum.n28 Isum.n27 0.1445
R1959 Isum.n29 Isum.n28 0.1445
R1960 Isum.n30 Isum.n29 0.1445
R1961 Isum.n34 Isum.n30 0.1445
R1962 Isum.n35 Isum.n34 0.1445
R1963 Isum.n36 Isum.n35 0.1445
R1964 Isum.n37 Isum.n36 0.1445
R1965 Isum.n41 Isum.n37 0.1445
R1966 Isum.n42 Isum.n41 0.1445
R1967 Isum.n43 Isum.n42 0.1445
R1968 Isum.n44 Isum.n43 0.1445
R1969 Isum.n1298 Isum.n1179 0.1445
R1970 Isum.n1298 Isum.n1297 0.1445
R1971 Isum.n1297 Isum.n1296 0.1445
R1972 Isum.n1296 Isum.n1181 0.1445
R1973 Isum.n1182 Isum.n1181 0.1445
R1974 Isum.n1183 Isum.n1182 0.1445
R1975 Isum.n1184 Isum.n1183 0.1445
R1976 Isum.n1185 Isum.n1184 0.1445
R1977 Isum.n1186 Isum.n1185 0.1445
R1978 Isum.n1187 Isum.n1186 0.1445
R1979 Isum.n1188 Isum.n1187 0.1445
R1980 Isum.n1189 Isum.n1188 0.1445
R1981 Isum.n1190 Isum.n1189 0.1445
R1982 Isum.n1191 Isum.n1190 0.1445
R1983 Isum.n1192 Isum.n1191 0.1445
R1984 Isum.n1193 Isum.n1192 0.1445
R1985 Isum.n1194 Isum.n1193 0.1445
R1986 Isum.n1195 Isum.n1194 0.1445
R1987 Isum.n1196 Isum.n1195 0.1445
R1988 Isum.n1197 Isum.n1196 0.1445
R1989 Isum.n1198 Isum.n1197 0.1445
R1990 Isum.n1199 Isum.n1198 0.1445
R1991 Isum.n1200 Isum.n1199 0.1445
R1992 Isum.n1201 Isum.n1200 0.1445
R1993 Isum.n1202 Isum.n1201 0.1445
R1994 Isum.n1203 Isum.n1202 0.1445
R1995 Isum.n1204 Isum.n1203 0.1445
R1996 Isum.n1205 Isum.n1204 0.1445
R1997 Isum.n1206 Isum.n1205 0.1445
R1998 Isum.n1207 Isum.n1206 0.1445
R1999 Isum.n1208 Isum.n1207 0.1445
R2000 Isum.n1209 Isum.n1208 0.1445
R2001 Isum.n1210 Isum.n1209 0.1445
R2002 Isum.n1211 Isum.n1210 0.1445
R2003 Isum.n1212 Isum.n1211 0.1445
R2004 Isum.n1213 Isum.n1212 0.1445
R2005 Isum.n1214 Isum.n1213 0.1445
R2006 Isum.n1215 Isum.n1214 0.1445
R2007 Isum.n1216 Isum.n1215 0.1445
R2008 Isum.n1217 Isum.n1216 0.1445
R2009 Isum.n1217 Isum.n114 0.1445
R2010 Isum.n1323 Isum.n115 0.1445
R2011 Isum.n1304 Isum.n115 0.1445
R2012 Isum.n1305 Isum.n1304 0.1445
R2013 Isum.n1306 Isum.n1305 0.1445
R2014 Isum.n1307 Isum.n1306 0.1445
R2015 Isum.n1308 Isum.n1307 0.1445
R2016 Isum.n837 Isum.n801 0.1445
R2017 Isum.n833 Isum.n801 0.1445
R2018 Isum.n833 Isum.n832 0.1445
R2019 Isum.n832 Isum.n831 0.1445
R2020 Isum.n831 Isum.n804 0.1445
R2021 Isum.n827 Isum.n804 0.1445
R2022 Isum.n827 Isum.n826 0.1445
R2023 Isum.n826 Isum.n825 0.1445
R2024 Isum.n825 Isum.n809 0.1445
R2025 Isum.n821 Isum.n809 0.1445
R2026 Isum.n821 Isum.n820 0.1445
R2027 Isum.n820 Isum.n812 0.1445
R2028 Isum.n816 Isum.n812 0.1445
R2029 Isum.n816 Isum.n750 0.1445
R2030 Isum.n960 Isum.n750 0.1445
R2031 Isum.n960 Isum.n959 0.1445
R2032 Isum.n959 Isum.n752 0.1445
R2033 Isum.n954 Isum.n752 0.1445
R2034 Isum.n954 Isum.n953 0.1445
R2035 Isum.n953 Isum.n952 0.1445
R2036 Isum.n952 Isum.n755 0.1445
R2037 Isum.n948 Isum.n755 0.1445
R2038 Isum.n948 Isum.n947 0.1445
R2039 Isum.n947 Isum.n946 0.1445
R2040 Isum.n946 Isum.n760 0.1445
R2041 Isum.n942 Isum.n760 0.1445
R2042 Isum.n942 Isum.n941 0.1445
R2043 Isum.n941 Isum.n763 0.1445
R2044 Isum.n937 Isum.n763 0.1445
R2045 Isum.n937 Isum.n936 0.1445
R2046 Isum.n1072 Isum.n733 0.1445
R2047 Isum.n1068 Isum.n733 0.1445
R2048 Isum.n1068 Isum.n1065 0.1445
R2049 Isum.n1065 Isum.n1064 0.1445
R2050 Isum.n1064 Isum.n1061 0.1445
R2051 Isum.n1061 Isum.n1060 0.1445
R2052 Isum.n1060 Isum.n1057 0.1445
R2053 Isum.n1057 Isum.n1056 0.1445
R2054 Isum.n1056 Isum.n1053 0.1445
R2055 Isum.n1053 Isum.n1052 0.1445
R2056 Isum.n1052 Isum.n1049 0.1445
R2057 Isum.n1049 Isum.n1048 0.1445
R2058 Isum.n1048 Isum.n1045 0.1445
R2059 Isum.n1045 Isum.n1044 0.1445
R2060 Isum.n1044 Isum.n1041 0.1445
R2061 Isum.n1041 Isum.n1040 0.1445
R2062 Isum.n1040 Isum.n1037 0.1445
R2063 Isum.n1037 Isum.n1036 0.1445
R2064 Isum.n1036 Isum.n1033 0.1445
R2065 Isum.n1033 Isum.n1032 0.1445
R2066 Isum.n1032 Isum.n1029 0.1445
R2067 Isum.n1029 Isum.n1028 0.1445
R2068 Isum.n1028 Isum.n1025 0.1445
R2069 Isum.n1025 Isum.n1024 0.1445
R2070 Isum.n1024 Isum.n1021 0.1445
R2071 Isum.n1021 Isum.n1020 0.1445
R2072 Isum.n1020 Isum.n1017 0.1445
R2073 Isum.n1017 Isum.n1016 0.1445
R2074 Isum.n1016 Isum.n1013 0.1445
R2075 Isum.n1013 Isum.n1012 0.1445
R2076 Isum.n1012 Isum.n1009 0.1445
R2077 Isum.n1009 Isum.n1008 0.1445
R2078 Isum.n1008 Isum.n1005 0.1445
R2079 Isum.n1005 Isum.n1004 0.1445
R2080 Isum.n1398 Isum.n1397 0.1445
R2081 Isum.n1397 Isum.n81 0.1445
R2082 Isum.n1393 Isum.n81 0.1445
R2083 Isum.n1393 Isum.n1390 0.1445
R2084 Isum.n1390 Isum.n1387 0.1445
R2085 Isum.n1387 Isum.n1386 0.1445
R2086 Isum.n1386 Isum.n1383 0.1445
R2087 Isum.n1383 Isum.n1382 0.1445
R2088 Isum.n1382 Isum.n1379 0.1445
R2089 Isum.n1379 Isum.n1378 0.1445
R2090 Isum.n1378 Isum.n1375 0.1445
R2091 Isum.n1375 Isum.n1374 0.1445
R2092 Isum.n1374 Isum.n1371 0.1445
R2093 Isum.n1371 Isum.n1370 0.1445
R2094 Isum.n1370 Isum.n1367 0.1445
R2095 Isum.n1367 Isum.n1366 0.1445
R2096 Isum.n1366 Isum.n1363 0.1445
R2097 Isum.n1363 Isum.n1362 0.1445
R2098 Isum.n1362 Isum.n1359 0.1445
R2099 Isum.n1359 Isum.n1358 0.1445
R2100 Isum.n1358 Isum.n1355 0.1445
R2101 Isum.n1355 Isum.n1354 0.1445
R2102 Isum.n1354 Isum.n1351 0.1445
R2103 Isum.n1351 Isum.n1350 0.1445
R2104 Isum.n1350 Isum.n1347 0.1445
R2105 Isum.n1347 Isum.n1346 0.1445
R2106 Isum.n1346 Isum.n1343 0.1445
R2107 Isum.n1343 Isum.n1342 0.1445
R2108 Isum.n1342 Isum.n1339 0.1445
R2109 Isum.n1339 Isum.n1338 0.1445
R2110 Isum.n1338 Isum.n1335 0.1445
R2111 Isum.n1335 Isum.n1334 0.1445
R2112 Isum.n1334 Isum.n1331 0.1445
R2113 Isum.n1331 Isum.n1330 0.1445
R2114 Isum.n1396 Isum.n80 0.1445
R2115 Isum.n1396 Isum.n1395 0.1445
R2116 Isum.n1395 Isum.n1394 0.1445
R2117 Isum.n1394 Isum.n82 0.1445
R2118 Isum.n83 Isum.n82 0.1445
R2119 Isum.n84 Isum.n83 0.1445
R2120 Isum.n85 Isum.n84 0.1445
R2121 Isum.n86 Isum.n85 0.1445
R2122 Isum.n87 Isum.n86 0.1445
R2123 Isum.n88 Isum.n87 0.1445
R2124 Isum.n89 Isum.n88 0.1445
R2125 Isum.n90 Isum.n89 0.1445
R2126 Isum.n91 Isum.n90 0.1445
R2127 Isum.n92 Isum.n91 0.1445
R2128 Isum.n93 Isum.n92 0.1445
R2129 Isum.n94 Isum.n93 0.1445
R2130 Isum.n95 Isum.n94 0.1445
R2131 Isum.n96 Isum.n95 0.1445
R2132 Isum.n97 Isum.n96 0.1445
R2133 Isum.n98 Isum.n97 0.1445
R2134 Isum.n99 Isum.n98 0.1445
R2135 Isum.n100 Isum.n99 0.1445
R2136 Isum.n101 Isum.n100 0.1445
R2137 Isum.n102 Isum.n101 0.1445
R2138 Isum.n103 Isum.n102 0.1445
R2139 Isum.n104 Isum.n103 0.1445
R2140 Isum.n105 Isum.n104 0.1445
R2141 Isum.n106 Isum.n105 0.1445
R2142 Isum.n107 Isum.n106 0.1445
R2143 Isum.n108 Isum.n107 0.1445
R2144 Isum.n109 Isum.n108 0.1445
R2145 Isum.n110 Isum.n109 0.1445
R2146 Isum.n111 Isum.n110 0.1445
R2147 Isum.n1328 Isum.n111 0.1445
R2148 Isum.n285 Isum.n279 0.1445
R2149 Isum.n285 Isum.n268 0.1445
R2150 Isum.n356 Isum.n268 0.1445
R2151 Isum.n356 Isum.n266 0.1445
R2152 Isum.n360 Isum.n266 0.1445
R2153 Isum.n360 Isum.n257 0.1445
R2154 Isum.n553 Isum.n257 0.1445
R2155 Isum.n553 Isum.n255 0.1445
R2156 Isum.n557 Isum.n255 0.1445
R2157 Isum.n557 Isum.n241 0.1445
R2158 Isum.n569 Isum.n241 0.1445
R2159 Isum.n569 Isum.n239 0.1445
R2160 Isum.n573 Isum.n239 0.1445
R2161 Isum.n573 Isum.n226 0.1445
R2162 Isum.n585 Isum.n226 0.1445
R2163 Isum.n585 Isum.n224 0.1445
R2164 Isum.n589 Isum.n224 0.1445
R2165 Isum.n589 Isum.n210 0.1445
R2166 Isum.n601 Isum.n210 0.1445
R2167 Isum.n601 Isum.n208 0.1445
R2168 Isum.n605 Isum.n208 0.1445
R2169 Isum.n605 Isum.n194 0.1445
R2170 Isum.n617 Isum.n194 0.1445
R2171 Isum.n617 Isum.n192 0.1445
R2172 Isum.n621 Isum.n192 0.1445
R2173 Isum.n621 Isum.n175 0.1445
R2174 Isum.n642 Isum.n175 0.1445
R2175 Isum.n642 Isum.n173 0.1445
R2176 Isum.n647 Isum.n173 0.1445
R2177 Isum.n647 Isum.n139 0.1445
R2178 Isum.n702 Isum.n139 0.1445
R2179 Isum.n702 Isum.n701 0.1445
R2180 Isum.n701 Isum.n700 0.1445
R2181 Isum.n700 Isum.n143 0.1445
R2182 Isum.n695 Isum.n143 0.1445
R2183 Isum.n695 Isum.n694 0.1445
R2184 Isum.n694 Isum.n148 0.1445
R2185 Isum.n689 Isum.n148 0.1445
R2186 Isum.n689 Isum.n688 0.1445
R2187 Isum.n688 Isum.n687 0.1445
R2188 Isum.n687 Isum.n683 0.1445
R2189 Isum.n284 Isum.n283 0.1445
R2190 Isum.n284 Isum.n267 0.1445
R2191 Isum.n357 Isum.n267 0.1445
R2192 Isum.n358 Isum.n357 0.1445
R2193 Isum.n359 Isum.n358 0.1445
R2194 Isum.n359 Isum.n256 0.1445
R2195 Isum.n554 Isum.n256 0.1445
R2196 Isum.n555 Isum.n554 0.1445
R2197 Isum.n556 Isum.n555 0.1445
R2198 Isum.n556 Isum.n240 0.1445
R2199 Isum.n570 Isum.n240 0.1445
R2200 Isum.n571 Isum.n570 0.1445
R2201 Isum.n572 Isum.n571 0.1445
R2202 Isum.n572 Isum.n225 0.1445
R2203 Isum.n586 Isum.n225 0.1445
R2204 Isum.n587 Isum.n586 0.1445
R2205 Isum.n588 Isum.n587 0.1445
R2206 Isum.n588 Isum.n209 0.1445
R2207 Isum.n602 Isum.n209 0.1445
R2208 Isum.n603 Isum.n602 0.1445
R2209 Isum.n604 Isum.n603 0.1445
R2210 Isum.n604 Isum.n193 0.1445
R2211 Isum.n618 Isum.n193 0.1445
R2212 Isum.n619 Isum.n618 0.1445
R2213 Isum.n620 Isum.n619 0.1445
R2214 Isum.n620 Isum.n174 0.1445
R2215 Isum.n643 Isum.n174 0.1445
R2216 Isum.n644 Isum.n643 0.1445
R2217 Isum.n646 Isum.n644 0.1445
R2218 Isum.n646 Isum.n645 0.1445
R2219 Isum.n645 Isum.n140 0.1445
R2220 Isum.n141 Isum.n140 0.1445
R2221 Isum.n142 Isum.n141 0.1445
R2222 Isum.n146 Isum.n145 0.1445
R2223 Isum.n147 Isum.n146 0.1445
R2224 Isum.n150 Isum.n147 0.1445
R2225 Isum.n151 Isum.n150 0.1445
R2226 Isum.n152 Isum.n151 0.1445
R2227 Isum.n153 Isum.n152 0.1445
R2228 Isum.n682 Isum.n153 0.1445
R2229 Isum.n290 Isum.n274 0.1445
R2230 Isum.n291 Isum.n290 0.1445
R2231 Isum.n292 Isum.n291 0.1445
R2232 Isum.n293 Isum.n292 0.1445
R2233 Isum.n294 Isum.n293 0.1445
R2234 Isum.n295 Isum.n294 0.1445
R2235 Isum.n296 Isum.n295 0.1445
R2236 Isum.n297 Isum.n296 0.1445
R2237 Isum.n298 Isum.n297 0.1445
R2238 Isum.n299 Isum.n298 0.1445
R2239 Isum.n300 Isum.n299 0.1445
R2240 Isum.n301 Isum.n300 0.1445
R2241 Isum.n302 Isum.n301 0.1445
R2242 Isum.n303 Isum.n302 0.1445
R2243 Isum.n304 Isum.n303 0.1445
R2244 Isum.n305 Isum.n304 0.1445
R2245 Isum.n306 Isum.n305 0.1445
R2246 Isum.n307 Isum.n306 0.1445
R2247 Isum.n308 Isum.n307 0.1445
R2248 Isum.n309 Isum.n308 0.1445
R2249 Isum.n310 Isum.n309 0.1445
R2250 Isum.n311 Isum.n310 0.1445
R2251 Isum.n312 Isum.n311 0.1445
R2252 Isum.n313 Isum.n312 0.1445
R2253 Isum.n314 Isum.n313 0.1445
R2254 Isum.n315 Isum.n314 0.1445
R2255 Isum.n316 Isum.n315 0.1445
R2256 Isum.n316 Isum.n166 0.1445
R2257 Isum.n652 Isum.n166 0.1445
R2258 Isum.n653 Isum.n652 0.1445
R2259 Isum.n654 Isum.n653 0.1445
R2260 Isum.n654 Isum.n164 0.1445
R2261 Isum.n661 Isum.n164 0.1445
R2262 Isum.n662 Isum.n661 0.1445
R2263 Isum.n663 Isum.n662 0.1445
R2264 Isum.n663 Isum.n162 0.1445
R2265 Isum.n670 Isum.n162 0.1445
R2266 Isum.n671 Isum.n670 0.1445
R2267 Isum.n672 Isum.n671 0.1445
R2268 Isum.n672 Isum.n154 0.1445
R2269 Isum.n680 Isum.n154 0.1445
R2270 Isum.n544 Isum.n543 0.1445
R2271 Isum.n543 Isum.n368 0.1445
R2272 Isum.n538 Isum.n368 0.1445
R2273 Isum.n538 Isum.n537 0.1445
R2274 Isum.n537 Isum.n455 0.1445
R2275 Isum.n533 Isum.n455 0.1445
R2276 Isum.n533 Isum.n532 0.1445
R2277 Isum.n532 Isum.n531 0.1445
R2278 Isum.n531 Isum.n463 0.1445
R2279 Isum.n527 Isum.n463 0.1445
R2280 Isum.n527 Isum.n526 0.1445
R2281 Isum.n526 Isum.n472 0.1445
R2282 Isum.n522 Isum.n472 0.1445
R2283 Isum.n522 Isum.n521 0.1445
R2284 Isum.n521 Isum.n480 0.1445
R2285 Isum.n517 Isum.n480 0.1445
R2286 Isum.n517 Isum.n516 0.1445
R2287 Isum.n516 Isum.n487 0.1445
R2288 Isum.n512 Isum.n487 0.1445
R2289 Isum.n512 Isum.n511 0.1445
R2290 Isum.n511 Isum.n501 0.1445
R2291 Isum.n507 Isum.n501 0.1445
R2292 Isum.n507 Isum.n132 0.1445
R2293 Isum.n706 Isum.n132 0.1445
R2294 Isum.n706 Isum.n121 0.1445
R2295 Isum.n712 Isum.n121 0.1445
R2296 Isum.n712 Isum.n122 0.1445
R2297 Isum.n548 Isum.n249 0.1445
R2298 Isum.n562 Isum.n249 0.1445
R2299 Isum.n563 Isum.n562 0.1445
R2300 Isum.n564 Isum.n563 0.1445
R2301 Isum.n564 Isum.n233 0.1445
R2302 Isum.n578 Isum.n233 0.1445
R2303 Isum.n579 Isum.n578 0.1445
R2304 Isum.n580 Isum.n579 0.1445
R2305 Isum.n580 Isum.n216 0.1445
R2306 Isum.n594 Isum.n216 0.1445
R2307 Isum.n595 Isum.n594 0.1445
R2308 Isum.n596 Isum.n595 0.1445
R2309 Isum.n596 Isum.n200 0.1445
R2310 Isum.n610 Isum.n200 0.1445
R2311 Isum.n611 Isum.n610 0.1445
R2312 Isum.n612 Isum.n611 0.1445
R2313 Isum.n612 Isum.n185 0.1445
R2314 Isum.n626 Isum.n185 0.1445
R2315 Isum.n627 Isum.n626 0.1445
R2316 Isum.n637 Isum.n627 0.1445
R2317 Isum.n637 Isum.n636 0.1445
R2318 Isum.n636 Isum.n635 0.1445
R2319 Isum.n635 Isum.n628 0.1445
R2320 Isum.n631 Isum.n628 0.1445
R2321 Isum.n631 Isum.n630 0.1445
R2322 Isum.n630 Isum.n56 0.1445
R2323 Isum.n1406 Isum.n56 0.1445
R2324 Isum.n145 Isum.n113 0.1409
R2325 Isum.n1324 Isum.n1323 0.1265
R2326 Isum.n936 Isum.n935 0.117269
R2327 Isum.n839 Isum.n837 0.117269
R2328 Isum.n448 Isum.n365 0.107278
R2329 Isum.n1178 Isum.n52 0.1005
R2330 Isum.n1409 Isum.n52 0.1005
R2331 Isum.n1410 Isum.n47 0.1005
R2332 Isum.n1410 Isum.n1409 0.1005
R2333 Isum.n282 Isum.n281 0.0950455
R2334 Isum.n681 Isum.n49 0.0950455
R2335 Isum.n1409 Isum.n49 0.0950455
R2336 Isum.n394 Isum.n392 0.0922644
R2337 Isum.n541 Isum.n449 0.0847125
R2338 Isum.n393 Isum.n123 0.0779226
R2339 Isum.n842 Isum.n840 0.0725
R2340 Isum.n934 Isum.n767 0.0725
R2341 Isum.n397 Isum.n396 0.0572937
R2342 Isum.n447 Isum.n446 0.0572937
R2343 Isum.n398 Isum.n397 0.0552335
R2344 Isum.n446 Isum.n445 0.0552335
R2345 Isum.n393 Isum.n392 0.0430846
R2346 Isum.n1071 Isum.n1070 0.0392827
R2347 Isum.n1002 Isum.n112 0.0392827
R2348 Isum.n935 Isum.n766 0.0384533
R2349 Isum.n839 Isum.n838 0.0384533
R2350 Isum.n932 Isum.n931 0.0371923
R2351 Isum.n845 Isum.n843 0.0371923
R2352 Isum.n449 Isum.n448 0.0367015
R2353 Isum.n396 Isum.n392 0.0277385
R2354 Isum.n448 Isum.n447 0.0277385
R2355 Isum.n852 Isum.n851 0.0235032
R2356 Isum.n852 Isum.n847 0.0235032
R2357 Isum.n860 Isum.n848 0.0235032
R2358 Isum.n848 Isum.n797 0.0235032
R2359 Isum.n868 Isum.n867 0.0235032
R2360 Isum.n868 Isum.n794 0.0235032
R2361 Isum.n873 Isum.n791 0.0235032
R2362 Isum.n884 Isum.n791 0.0235032
R2363 Isum.n888 Isum.n788 0.0235032
R2364 Isum.n889 Isum.n888 0.0235032
R2365 Isum.n889 Isum.n785 0.0235032
R2366 Isum.n895 Isum.n785 0.0235032
R2367 Isum.n896 Isum.n895 0.0235032
R2368 Isum.n897 Isum.n896 0.0235032
R2369 Isum.n901 Isum.n900 0.0235032
R2370 Isum.n901 Isum.n779 0.0235032
R2371 Isum.n908 Isum.n780 0.0235032
R2372 Isum.n780 Isum.n777 0.0235032
R2373 Isum.n917 Isum.n916 0.0235032
R2374 Isum.n917 Isum.n773 0.0235032
R2375 Isum.n927 Isum.n774 0.0235032
R2376 Isum.n923 Isum.n774 0.0235032
R2377 Isum.n440 Isum.n439 0.0203347
R2378 Isum.n439 Isum.n438 0.0203347
R2379 Isum.n438 Isum.n373 0.0203347
R2380 Isum.n434 Isum.n433 0.0203347
R2381 Isum.n433 Isum.n377 0.0203347
R2382 Isum.n429 Isum.n428 0.0203347
R2383 Isum.n428 Isum.n380 0.0203347
R2384 Isum.n424 Isum.n423 0.0203347
R2385 Isum.n423 Isum.n422 0.0203347
R2386 Isum.n419 Isum.n418 0.0203347
R2387 Isum.n418 Isum.n417 0.0203347
R2388 Isum.n414 Isum.n413 0.0203347
R2389 Isum.n413 Isum.n412 0.0203347
R2390 Isum.n412 Isum.n389 0.0203347
R2391 Isum.n933 Isum.n932 0.0189615
R2392 Isum.n843 Isum.n799 0.0189615
R2393 Isum.n861 Isum.n860 0.0189026
R2394 Isum.n884 Isum.n883 0.0189026
R2395 Isum.n900 Isum.n783 0.0189026
R2396 Isum.n928 Isum.n773 0.0189026
R2397 Isum.n1070 Isum.n1069 0.0188673
R2398 Isum.n1069 Isum.n736 0.0188673
R2399 Isum.n737 Isum.n736 0.0188673
R2400 Isum.n739 Isum.n738 0.0188673
R2401 Isum.n740 Isum.n739 0.0188673
R2402 Isum.n742 Isum.n741 0.0188673
R2403 Isum.n743 Isum.n742 0.0188673
R2404 Isum.n745 Isum.n744 0.0188673
R2405 Isum.n746 Isum.n745 0.0188673
R2406 Isum.n748 Isum.n747 0.0188673
R2407 Isum.n749 Isum.n748 0.0188673
R2408 Isum.n960 Isum.n749 0.0188673
R2409 Isum.n961 Isum.n960 0.0188673
R2410 Isum.n962 Isum.n961 0.0188673
R2411 Isum.n963 Isum.n962 0.0188673
R2412 Isum.n965 Isum.n964 0.0188673
R2413 Isum.n966 Isum.n965 0.0188673
R2414 Isum.n968 Isum.n967 0.0188673
R2415 Isum.n969 Isum.n968 0.0188673
R2416 Isum.n971 Isum.n970 0.0188673
R2417 Isum.n972 Isum.n971 0.0188673
R2418 Isum.n974 Isum.n973 0.0188673
R2419 Isum.n975 Isum.n974 0.0188673
R2420 Isum.n1002 Isum.n975 0.0188673
R2421 Isum.n933 Isum.n766 0.0187854
R2422 Isum.n838 Isum.n799 0.0187854
R2423 Isum.n398 Isum.n391 0.0186975
R2424 Isum.n445 Isum.n370 0.0186975
R2425 Isum.n1324 Isum.n114 0.0185
R2426 Isum.n1326 Isum.n112 0.0185
R2427 Isum.n434 Isum.n376 0.0183512
R2428 Isum.n417 Isum.n386 0.0183512
R2429 Isum.n540 Isum.n539 0.0167896
R2430 Isum.n536 Isum.n535 0.0167896
R2431 Isum.n535 Isum.n534 0.0167896
R2432 Isum.n534 Isum.n460 0.0167896
R2433 Isum.n530 Isum.n529 0.0167896
R2434 Isum.n529 Isum.n528 0.0167896
R2435 Isum.n525 Isum.n524 0.0167896
R2436 Isum.n524 Isum.n523 0.0167896
R2437 Isum.n520 Isum.n519 0.0167896
R2438 Isum.n519 Isum.n518 0.0167896
R2439 Isum.n515 Isum.n514 0.0167896
R2440 Isum.n514 Isum.n513 0.0167896
R2441 Isum.n510 Isum.n509 0.0167896
R2442 Isum.n509 Isum.n508 0.0167896
R2443 Isum.n508 Isum.n128 0.0167896
R2444 Isum.n707 Isum.n131 0.0167896
R2445 Isum.n976 Isum.n738 0.0151939
R2446 Isum.n985 Isum.n746 0.0151939
R2447 Isum.n990 Isum.n964 0.0151939
R2448 Isum.n999 Isum.n972 0.0151939
R2449 Isum.n539 Isum.n452 0.0151606
R2450 Isum.n530 Isum.n464 0.0151606
R2451 Isum.n513 Isum.n498 0.0151606
R2452 Isum.n708 Isum.n707 0.0151606
R2453 Isum.n542 Isum.n541 0.014448
R2454 Isum.n711 Isum.n123 0.014448
R2455 Isum.n429 Isum.n379 0.0143843
R2456 Isum.n422 Isum.n383 0.0143843
R2457 Isum.n867 Isum.n866 0.0143019
R2458 Isum.n874 Isum.n794 0.0143019
R2459 Isum.n909 Isum.n908 0.0143019
R2460 Isum.n915 Isum.n777 0.0143019
R2461 Isum.n408 Isum.n391 0.0119263
R2462 Isum.n443 Isum.n370 0.0119263
R2463 Isum.n545 Isum.n366 0.0119027
R2464 Isum.n525 Isum.n470 0.0119027
R2465 Isum.n518 Isum.n485 0.0119027
R2466 Isum.n710 Isum.n127 0.0119027
R2467 Isum.n979 Isum.n741 0.0115204
R2468 Isum.n982 Isum.n743 0.0115204
R2469 Isum.n993 Isum.n967 0.0115204
R2470 Isum.n996 Isum.n969 0.0115204
R2471 Isum.n382 Isum.n380 0.0104174
R2472 Isum.n424 Isum.n382 0.0104174
R2473 Isum.n866 Isum.n797 0.00970128
R2474 Isum.n874 Isum.n873 0.00970128
R2475 Isum.n909 Isum.n779 0.00970128
R2476 Isum.n916 Isum.n915 0.00970128
R2477 Isum.n523 Isum.n477 0.0086448
R2478 Isum.n520 Isum.n477 0.0086448
R2479 Isum.n979 Isum.n740 0.00784694
R2480 Isum.n982 Isum.n744 0.00784694
R2481 Isum.n993 Isum.n966 0.00784694
R2482 Isum.n996 Isum.n970 0.00784694
R2483 Isum.n379 Isum.n377 0.00645041
R2484 Isum.n419 Isum.n383 0.00645041
R2485 Isum.n542 Isum.n366 0.00538688
R2486 Isum.n528 Isum.n470 0.00538688
R2487 Isum.n515 Isum.n485 0.00538688
R2488 Isum.n711 Isum.n710 0.00538688
R2489 Isum.n861 Isum.n847 0.00510064
R2490 Isum.n883 Isum.n788 0.00510064
R2491 Isum.n897 Isum.n783 0.00510064
R2492 Isum.n928 Isum.n927 0.00510064
R2493 Isum.n976 Isum.n737 0.00417347
R2494 Isum.n985 Isum.n747 0.00417347
R2495 Isum.n990 Isum.n963 0.00417347
R2496 Isum.n999 Isum.n973 0.00417347
R2497 Isum.n142 Isum.n113 0.0041
R2498 Isum.n541 Isum.n540 0.00284163
R2499 Isum.n131 Isum.n123 0.00284163
R2500 Isum.n546 Isum.n545 0.00273982
R2501 Isum.n440 Isum.n372 0.00248347
R2502 Isum.n376 Isum.n373 0.00248347
R2503 Isum.n414 Isum.n386 0.00248347
R2504 Isum.n405 Isum.n389 0.00248347
R2505 Isum.n126 Isum.n55 0.00233258
R2506 Isum.n536 Isum.n452 0.00212896
R2507 Isum.n464 Isum.n460 0.00212896
R2508 Isum.n510 Isum.n498 0.00212896
R2509 Isum.n708 Isum.n128 0.00212896
R2510 Isum.n372 Isum.n370 0.00149173
R2511 Isum.n405 Isum.n391 0.00149173
R2512 Isum.n127 Isum.n126 0.00090724
R2513 VDD.n387 VDD.n386 175.351
R2514 VDD.n452 VDD.n451 175.351
R2515 VDD.n388 VDD.n387 175.351
R2516 VDD.n451 VDD.n450 175.351
R2517 VDD.n231 VDD.n64 163.012
R2518 VDD.n742 VDD.n30 163.012
R2519 VDD.n596 VDD.n594 162.663
R2520 VDD.n677 VDD.n557 162.663
R2521 VDD.n602 VDD.n594 162.663
R2522 VDD.n677 VDD.n676 162.663
R2523 VDD.n740 VDD.n30 52.6716
R2524 VDD.n66 VDD.n64 52.6716
R2525 VDD.n230 VDD.n229 47.422
R2526 VDD.n143 VDD.n120 47.422
R2527 VDD.n143 VDD.n142 47.422
R2528 VDD.n157 VDD.n117 47.422
R2529 VDD.n158 VDD.n157 47.422
R2530 VDD.n161 VDD.n160 47.422
R2531 VDD.n160 VDD.n159 47.422
R2532 VDD.n208 VDD.n207 47.422
R2533 VDD.n207 VDD.n206 47.422
R2534 VDD.n206 VDD.n205 47.422
R2535 VDD.n204 VDD.n203 47.422
R2536 VDD.n203 VDD.n99 47.422
R2537 VDD.n193 VDD.n192 47.422
R2538 VDD.n192 VDD.n191 47.422
R2539 VDD.n190 VDD.n189 47.422
R2540 VDD.n189 VDD.n187 47.422
R2541 VDD.n741 VDD.n31 47.422
R2542 VDD.n159 VDD.t18 42.6798
R2543 VDD.t15 VDD.n204 42.6798
R2544 VDD.n120 VDD.t27 33.1955
R2545 VDD.t21 VDD.n158 33.1955
R2546 VDD.n193 VDD.t12 33.1955
R2547 VDD.n187 VDD.t6 33.1955
R2548 VDD.t33 VDD.n228 27.8606
R2549 VDD.n301 VDD.t30 27.8606
R2550 VDD.n142 VDD.t24 23.7112
R2551 VDD.t24 VDD.n117 23.7112
R2552 VDD.n191 VDD.t9 23.7112
R2553 VDD.t9 VDD.n190 23.7112
R2554 VDD.n229 VDD.t33 19.5619
R2555 VDD.t30 VDD.n31 19.5619
R2556 VDD.n499 VDD.t0 18.3399
R2557 VDD.n735 VDD.t2 17.528
R2558 VDD.n500 VDD.t4 17.528
R2559 VDD.n293 VDD.t29 14.9553
R2560 VDD.n238 VDD.t32 14.9553
R2561 VDD.n228 VDD.t27 14.2269
R2562 VDD.n301 VDD.t6 14.2269
R2563 VDD.n225 VDD.n73 14.1851
R2564 VDD.n298 VDD.n40 14.1851
R2565 VDD.n231 VDD.n65 14.0005
R2566 VDD.n227 VDD.n65 14.0005
R2567 VDD.n227 VDD.n69 14.0005
R2568 VDD.n144 VDD.n69 14.0005
R2569 VDD.n144 VDD.n119 14.0005
R2570 VDD.n155 VDD.n119 14.0005
R2571 VDD.n156 VDD.n155 14.0005
R2572 VDD.n156 VDD.n80 14.0005
R2573 VDD.n81 VDD.n80 14.0005
R2574 VDD.n82 VDD.n81 14.0005
R2575 VDD.n91 VDD.n82 14.0005
R2576 VDD.n209 VDD.n91 14.0005
R2577 VDD.n209 VDD.n92 14.0005
R2578 VDD.n92 VDD.n5 14.0005
R2579 VDD.n6 VDD.n5 14.0005
R2580 VDD.n7 VDD.n6 14.0005
R2581 VDD.n202 VDD.n7 14.0005
R2582 VDD.n202 VDD.n201 14.0005
R2583 VDD.n201 VDD.n194 14.0005
R2584 VDD.n194 VDD.n17 14.0005
R2585 VDD.n18 VDD.n17 14.0005
R2586 VDD.n19 VDD.n18 14.0005
R2587 VDD.n188 VDD.n19 14.0005
R2588 VDD.n188 VDD.n37 14.0005
R2589 VDD.n300 VDD.n37 14.0005
R2590 VDD.n300 VDD.n29 14.0005
R2591 VDD.n742 VDD.n29 14.0005
R2592 VDD.n126 VDD.n67 14.0005
R2593 VDD.n68 VDD.n67 14.0005
R2594 VDD.n132 VDD.n68 14.0005
R2595 VDD.n132 VDD.n121 14.0005
R2596 VDD.n141 VDD.n121 14.0005
R2597 VDD.n141 VDD.n122 14.0005
R2598 VDD.n122 VDD.n118 14.0005
R2599 VDD.n118 VDD.n115 14.0005
R2600 VDD.n162 VDD.n115 14.0005
R2601 VDD.n162 VDD.n116 14.0005
R2602 VDD.n116 VDD.n112 14.0005
R2603 VDD.n112 VDD.n93 14.0005
R2604 VDD.n94 VDD.n93 14.0005
R2605 VDD.n95 VDD.n94 14.0005
R2606 VDD.n96 VDD.n95 14.0005
R2607 VDD.n97 VDD.n96 14.0005
R2608 VDD.n98 VDD.n97 14.0005
R2609 VDD.n106 VDD.n98 14.0005
R2610 VDD.n106 VDD.n100 14.0005
R2611 VDD.n101 VDD.n100 14.0005
R2612 VDD.n102 VDD.n101 14.0005
R2613 VDD.n103 VDD.n102 14.0005
R2614 VDD.n186 VDD.n103 14.0005
R2615 VDD.n186 VDD.n36 14.0005
R2616 VDD.n302 VDD.n36 14.0005
R2617 VDD.n302 VDD.n32 14.0005
R2618 VDD.n739 VDD.n32 14.0005
R2619 VDD.n596 VDD.n595 14.0005
R2620 VDD.n595 VDD.n504 14.0005
R2621 VDD.n505 VDD.n504 14.0005
R2622 VDD.n506 VDD.n505 14.0005
R2623 VDD.n509 VDD.n506 14.0005
R2624 VDD.n510 VDD.n509 14.0005
R2625 VDD.n511 VDD.n510 14.0005
R2626 VDD.n512 VDD.n511 14.0005
R2627 VDD.n515 VDD.n512 14.0005
R2628 VDD.n516 VDD.n515 14.0005
R2629 VDD.n517 VDD.n516 14.0005
R2630 VDD.n518 VDD.n517 14.0005
R2631 VDD.n521 VDD.n518 14.0005
R2632 VDD.n522 VDD.n521 14.0005
R2633 VDD.n523 VDD.n522 14.0005
R2634 VDD.n524 VDD.n523 14.0005
R2635 VDD.n527 VDD.n524 14.0005
R2636 VDD.n528 VDD.n527 14.0005
R2637 VDD.n529 VDD.n528 14.0005
R2638 VDD.n530 VDD.n529 14.0005
R2639 VDD.n533 VDD.n530 14.0005
R2640 VDD.n534 VDD.n533 14.0005
R2641 VDD.n535 VDD.n534 14.0005
R2642 VDD.n536 VDD.n535 14.0005
R2643 VDD.n539 VDD.n536 14.0005
R2644 VDD.n540 VDD.n539 14.0005
R2645 VDD.n541 VDD.n540 14.0005
R2646 VDD.n542 VDD.n541 14.0005
R2647 VDD.n545 VDD.n542 14.0005
R2648 VDD.n546 VDD.n545 14.0005
R2649 VDD.n547 VDD.n546 14.0005
R2650 VDD.n548 VDD.n547 14.0005
R2651 VDD.n551 VDD.n548 14.0005
R2652 VDD.n552 VDD.n551 14.0005
R2653 VDD.n553 VDD.n552 14.0005
R2654 VDD.n554 VDD.n553 14.0005
R2655 VDD.n557 VDD.n554 14.0005
R2656 VDD.n603 VDD.n602 14.0005
R2657 VDD.n604 VDD.n603 14.0005
R2658 VDD.n604 VDD.n590 14.0005
R2659 VDD.n610 VDD.n590 14.0005
R2660 VDD.n611 VDD.n610 14.0005
R2661 VDD.n612 VDD.n611 14.0005
R2662 VDD.n612 VDD.n586 14.0005
R2663 VDD.n618 VDD.n586 14.0005
R2664 VDD.n619 VDD.n618 14.0005
R2665 VDD.n620 VDD.n619 14.0005
R2666 VDD.n620 VDD.n582 14.0005
R2667 VDD.n626 VDD.n582 14.0005
R2668 VDD.n627 VDD.n626 14.0005
R2669 VDD.n628 VDD.n627 14.0005
R2670 VDD.n628 VDD.n578 14.0005
R2671 VDD.n634 VDD.n578 14.0005
R2672 VDD.n635 VDD.n634 14.0005
R2673 VDD.n636 VDD.n635 14.0005
R2674 VDD.n636 VDD.n574 14.0005
R2675 VDD.n642 VDD.n574 14.0005
R2676 VDD.n643 VDD.n642 14.0005
R2677 VDD.n644 VDD.n643 14.0005
R2678 VDD.n644 VDD.n570 14.0005
R2679 VDD.n650 VDD.n570 14.0005
R2680 VDD.n651 VDD.n650 14.0005
R2681 VDD.n652 VDD.n651 14.0005
R2682 VDD.n652 VDD.n566 14.0005
R2683 VDD.n658 VDD.n566 14.0005
R2684 VDD.n659 VDD.n658 14.0005
R2685 VDD.n660 VDD.n659 14.0005
R2686 VDD.n660 VDD.n562 14.0005
R2687 VDD.n666 VDD.n562 14.0005
R2688 VDD.n667 VDD.n666 14.0005
R2689 VDD.n669 VDD.n667 14.0005
R2690 VDD.n669 VDD.n668 14.0005
R2691 VDD.n668 VDD.n558 14.0005
R2692 VDD.n676 VDD.n558 14.0005
R2693 VDD.n386 VDD.n383 14.0005
R2694 VDD.n383 VDD.n310 14.0005
R2695 VDD.n311 VDD.n310 14.0005
R2696 VDD.n312 VDD.n311 14.0005
R2697 VDD.n315 VDD.n312 14.0005
R2698 VDD.n316 VDD.n315 14.0005
R2699 VDD.n317 VDD.n316 14.0005
R2700 VDD.n318 VDD.n317 14.0005
R2701 VDD.n321 VDD.n318 14.0005
R2702 VDD.n322 VDD.n321 14.0005
R2703 VDD.n323 VDD.n322 14.0005
R2704 VDD.n324 VDD.n323 14.0005
R2705 VDD.n327 VDD.n324 14.0005
R2706 VDD.n328 VDD.n327 14.0005
R2707 VDD.n329 VDD.n328 14.0005
R2708 VDD.n330 VDD.n329 14.0005
R2709 VDD.n333 VDD.n330 14.0005
R2710 VDD.n334 VDD.n333 14.0005
R2711 VDD.n335 VDD.n334 14.0005
R2712 VDD.n336 VDD.n335 14.0005
R2713 VDD.n339 VDD.n336 14.0005
R2714 VDD.n340 VDD.n339 14.0005
R2715 VDD.n341 VDD.n340 14.0005
R2716 VDD.n342 VDD.n341 14.0005
R2717 VDD.n345 VDD.n342 14.0005
R2718 VDD.n346 VDD.n345 14.0005
R2719 VDD.n347 VDD.n346 14.0005
R2720 VDD.n348 VDD.n347 14.0005
R2721 VDD.n351 VDD.n348 14.0005
R2722 VDD.n452 VDD.n351 14.0005
R2723 VDD.n388 VDD.n380 14.0005
R2724 VDD.n394 VDD.n380 14.0005
R2725 VDD.n395 VDD.n394 14.0005
R2726 VDD.n396 VDD.n395 14.0005
R2727 VDD.n396 VDD.n376 14.0005
R2728 VDD.n402 VDD.n376 14.0005
R2729 VDD.n403 VDD.n402 14.0005
R2730 VDD.n404 VDD.n403 14.0005
R2731 VDD.n404 VDD.n372 14.0005
R2732 VDD.n410 VDD.n372 14.0005
R2733 VDD.n411 VDD.n410 14.0005
R2734 VDD.n412 VDD.n411 14.0005
R2735 VDD.n412 VDD.n368 14.0005
R2736 VDD.n418 VDD.n368 14.0005
R2737 VDD.n419 VDD.n418 14.0005
R2738 VDD.n420 VDD.n419 14.0005
R2739 VDD.n420 VDD.n364 14.0005
R2740 VDD.n426 VDD.n364 14.0005
R2741 VDD.n427 VDD.n426 14.0005
R2742 VDD.n428 VDD.n427 14.0005
R2743 VDD.n428 VDD.n360 14.0005
R2744 VDD.n434 VDD.n360 14.0005
R2745 VDD.n435 VDD.n434 14.0005
R2746 VDD.n436 VDD.n435 14.0005
R2747 VDD.n436 VDD.n356 14.0005
R2748 VDD.n442 VDD.n356 14.0005
R2749 VDD.n443 VDD.n442 14.0005
R2750 VDD.n444 VDD.n443 14.0005
R2751 VDD.n444 VDD.n352 14.0005
R2752 VDD.n450 VDD.n352 14.0005
R2753 VDD.n288 VDD.n287 12.5005
R2754 VDD.n45 VDD.n44 12.5005
R2755 VDD.n280 VDD.n47 12.5005
R2756 VDD.n282 VDD.n281 12.5005
R2757 VDD.n278 VDD.n46 12.5005
R2758 VDD.n276 VDD.n275 12.5005
R2759 VDD.n274 VDD.n48 12.5005
R2760 VDD.n265 VDD.n49 12.5005
R2761 VDD.n267 VDD.n51 12.5005
R2762 VDD.n269 VDD.n268 12.5005
R2763 VDD.n264 VDD.n50 12.5005
R2764 VDD.n263 VDD.n262 12.5005
R2765 VDD.n261 VDD.n260 12.5005
R2766 VDD.n259 VDD.n258 12.5005
R2767 VDD.n257 VDD.n54 12.5005
R2768 VDD.n256 VDD.n255 12.5005
R2769 VDD.n253 VDD.n252 12.5005
R2770 VDD.n251 VDD.n56 12.5005
R2771 VDD.n250 VDD.n249 12.5005
R2772 VDD.n247 VDD.n57 12.5005
R2773 VDD.n39 VDD.n25 12.5005
R2774 VDD.n748 VDD.n24 12.5005
R2775 VDD.n749 VDD.n23 12.5005
R2776 VDD.n21 VDD.n15 12.5005
R2777 VDD.n753 VDD.n14 12.5005
R2778 VDD.n196 VDD.n13 12.5005
R2779 VDD.n199 VDD.n198 12.5005
R2780 VDD.n195 VDD.n12 12.5005
R2781 VDD.n758 VDD.n11 12.5005
R2782 VDD.n9 VDD.n3 12.5005
R2783 VDD.n762 VDD.n2 12.5005
R2784 VDD.n89 VDD.n0 12.5005
R2785 VDD.n211 VDD.n90 12.5005
R2786 VDD.n212 VDD.n87 12.5005
R2787 VDD.n215 VDD.n86 12.5005
R2788 VDD.n85 VDD.n78 12.5005
R2789 VDD.n219 VDD.n77 12.5005
R2790 VDD.n151 VDD.n76 12.5005
R2791 VDD.n153 VDD.n152 12.5005
R2792 VDD.n149 VDD.n147 12.5005
R2793 VDD.n148 VDD.n75 12.5005
R2794 VDD.n224 VDD.n74 12.5005
R2795 VDD.n161 VDD.t3 12.4486
R2796 VDD.t1 VDD.n99 12.4486
R2797 VDD.t7 VDD.n745 11.4188
R2798 VDD.t28 VDD.n62 11.4188
R2799 VDD.n734 VDD.n733 10.9103
R2800 VDD.n498 VDD.n497 10.7663
R2801 VDD.n736 VDD.n735 10.1327
R2802 VDD.n247 VDD.n246 9.95036
R2803 VDD.n289 VDD.n288 9.95036
R2804 VDD.n498 VDD.t51 9.89435
R2805 VDD.n89 VDD.n2 9.86111
R2806 VDD.n268 VDD.n264 9.86111
R2807 VDD.n87 VDD.n86 9.55788
R2808 VDD.n195 VDD.n11 9.55788
R2809 VDD.n260 VDD.n259 9.55788
R2810 VDD.n265 VDD.n48 9.55788
R2811 VDD.n244 VDD.t50 9.1205
R2812 VDD.n291 VDD.t36 9.1205
R2813 VDD.n148 VDD.n74 8.34496
R2814 VDD.n151 VDD.n77 8.34496
R2815 VDD.n196 VDD.n14 8.34496
R2816 VDD.n39 VDD.n24 8.34496
R2817 VDD.n255 VDD.n253 8.34496
R2818 VDD.n281 VDD.n278 8.34496
R2819 VDD.n747 VDD.n746 7.53568
R2820 VDD.n757 VDD.n756 7.53568
R2821 VDD.n214 VDD.n213 7.53568
R2822 VDD.n223 VDD.n222 7.53568
R2823 VDD.n286 VDD.n285 7.53568
R2824 VDD.n273 VDD.n272 7.53568
R2825 VDD.n240 VDD.n53 7.53568
R2826 VDD.n243 VDD.n242 7.53568
R2827 VDD.n755 VDD.n754 7.49884
R2828 VDD VDD.n1 7.49884
R2829 VDD.n221 VDD.n220 7.49884
R2830 VDD.n284 VDD.n283 7.49884
R2831 VDD.n271 VDD.n270 7.49884
R2832 VDD.n241 VDD.n55 7.49884
R2833 VDD.n149 VDD.n148 7.13204
R2834 VDD.n152 VDD.n151 7.13204
R2835 VDD.n21 VDD.n14 7.13204
R2836 VDD.n24 VDD.n23 7.13204
R2837 VDD.n249 VDD.n247 7.13204
R2838 VDD.n253 VDD.n56 7.13204
R2839 VDD.n281 VDD.n280 7.13204
R2840 VDD.n288 VDD.n44 7.13204
R2841 VDD.n454 VDD.n350 6.47119
R2842 VDD.n448 VDD.n350 6.47119
R2843 VDD.n390 VDD.n382 6.47119
R2844 VDD.n384 VDD.n382 6.47119
R2845 VDD.n128 VDD.n61 6.32942
R2846 VDD.n679 VDD.n678 6.32816
R2847 VDD.n678 VDD.n556 6.32816
R2848 VDD.n600 VDD.n599 6.32816
R2849 VDD.n599 VDD.n598 6.32816
R2850 VDD.n234 VDD.n61 6.30962
R2851 VDD.n232 VDD.n231 6.3005
R2852 VDD.n231 VDD.n230 6.3005
R2853 VDD.n65 VDD.n63 6.3005
R2854 VDD.n229 VDD.n65 6.3005
R2855 VDD.n227 VDD.n226 6.3005
R2856 VDD.n228 VDD.n227 6.3005
R2857 VDD.n70 VDD.n69 6.3005
R2858 VDD.n120 VDD.n69 6.3005
R2859 VDD.n145 VDD.n144 6.3005
R2860 VDD.n144 VDD.n143 6.3005
R2861 VDD.n146 VDD.n119 6.3005
R2862 VDD.n142 VDD.n119 6.3005
R2863 VDD.n155 VDD.n154 6.3005
R2864 VDD.n155 VDD.n117 6.3005
R2865 VDD.n156 VDD.n79 6.3005
R2866 VDD.n157 VDD.n156 6.3005
R2867 VDD.n218 VDD.n80 6.3005
R2868 VDD.n158 VDD.n80 6.3005
R2869 VDD.n217 VDD.n81 6.3005
R2870 VDD.n161 VDD.n81 6.3005
R2871 VDD.n216 VDD.n82 6.3005
R2872 VDD.n160 VDD.n82 6.3005
R2873 VDD.n91 VDD.n83 6.3005
R2874 VDD.n159 VDD.n91 6.3005
R2875 VDD.n210 VDD.n209 6.3005
R2876 VDD.n209 VDD.n208 6.3005
R2877 VDD.n92 VDD.n4 6.3005
R2878 VDD.n207 VDD.n92 6.3005
R2879 VDD.n761 VDD.n5 6.3005
R2880 VDD.n206 VDD.n5 6.3005
R2881 VDD.n760 VDD.n6 6.3005
R2882 VDD.n205 VDD.n6 6.3005
R2883 VDD.n759 VDD.n7 6.3005
R2884 VDD.n204 VDD.n7 6.3005
R2885 VDD.n202 VDD.n8 6.3005
R2886 VDD.n203 VDD.n202 6.3005
R2887 VDD.n201 VDD.n200 6.3005
R2888 VDD.n201 VDD.n99 6.3005
R2889 VDD.n194 VDD.n16 6.3005
R2890 VDD.n194 VDD.n193 6.3005
R2891 VDD.n752 VDD.n17 6.3005
R2892 VDD.n192 VDD.n17 6.3005
R2893 VDD.n751 VDD.n18 6.3005
R2894 VDD.n191 VDD.n18 6.3005
R2895 VDD.n750 VDD.n19 6.3005
R2896 VDD.n190 VDD.n19 6.3005
R2897 VDD.n188 VDD.n20 6.3005
R2898 VDD.n189 VDD.n188 6.3005
R2899 VDD.n38 VDD.n37 6.3005
R2900 VDD.n187 VDD.n37 6.3005
R2901 VDD.n300 VDD.n299 6.3005
R2902 VDD.n301 VDD.n300 6.3005
R2903 VDD.n29 VDD.n28 6.3005
R2904 VDD.n31 VDD.n29 6.3005
R2905 VDD.n743 VDD.n742 6.3005
R2906 VDD.n742 VDD.n741 6.3005
R2907 VDD.n739 VDD.n738 6.3005
R2908 VDD.n33 VDD.n32 6.3005
R2909 VDD.n32 VDD.n31 6.3005
R2910 VDD.n303 VDD.n302 6.3005
R2911 VDD.n302 VDD.n301 6.3005
R2912 VDD.n36 VDD.n35 6.3005
R2913 VDD.n187 VDD.n36 6.3005
R2914 VDD.n186 VDD.n185 6.3005
R2915 VDD.n189 VDD.n186 6.3005
R2916 VDD.n104 VDD.n103 6.3005
R2917 VDD.n190 VDD.n103 6.3005
R2918 VDD.n181 VDD.n102 6.3005
R2919 VDD.n191 VDD.n102 6.3005
R2920 VDD.n180 VDD.n101 6.3005
R2921 VDD.n192 VDD.n101 6.3005
R2922 VDD.n179 VDD.n100 6.3005
R2923 VDD.n193 VDD.n100 6.3005
R2924 VDD.n107 VDD.n106 6.3005
R2925 VDD.n106 VDD.n99 6.3005
R2926 VDD.n175 VDD.n98 6.3005
R2927 VDD.n203 VDD.n98 6.3005
R2928 VDD.n174 VDD.n97 6.3005
R2929 VDD.n204 VDD.n97 6.3005
R2930 VDD.n173 VDD.n96 6.3005
R2931 VDD.n205 VDD.n96 6.3005
R2932 VDD.n109 VDD.n95 6.3005
R2933 VDD.n206 VDD.n95 6.3005
R2934 VDD.n169 VDD.n94 6.3005
R2935 VDD.n207 VDD.n94 6.3005
R2936 VDD.n168 VDD.n93 6.3005
R2937 VDD.n208 VDD.n93 6.3005
R2938 VDD.n167 VDD.n112 6.3005
R2939 VDD.n159 VDD.n112 6.3005
R2940 VDD.n116 VDD.n111 6.3005
R2941 VDD.n160 VDD.n116 6.3005
R2942 VDD.n163 VDD.n162 6.3005
R2943 VDD.n162 VDD.n161 6.3005
R2944 VDD.n115 VDD.n114 6.3005
R2945 VDD.n158 VDD.n115 6.3005
R2946 VDD.n136 VDD.n118 6.3005
R2947 VDD.n157 VDD.n118 6.3005
R2948 VDD.n124 VDD.n122 6.3005
R2949 VDD.n122 VDD.n117 6.3005
R2950 VDD.n141 VDD.n140 6.3005
R2951 VDD.n142 VDD.n141 6.3005
R2952 VDD.n123 VDD.n121 6.3005
R2953 VDD.n143 VDD.n121 6.3005
R2954 VDD.n133 VDD.n132 6.3005
R2955 VDD.n132 VDD.n120 6.3005
R2956 VDD.n131 VDD.n68 6.3005
R2957 VDD.n228 VDD.n68 6.3005
R2958 VDD.n130 VDD.n67 6.3005
R2959 VDD.n229 VDD.n67 6.3005
R2960 VDD.n127 VDD.n126 6.3005
R2961 VDD.n557 VDD.n555 6.3005
R2962 VDD.n681 VDD.n554 6.3005
R2963 VDD.n682 VDD.n553 6.3005
R2964 VDD.n683 VDD.n552 6.3005
R2965 VDD.n551 VDD.n549 6.3005
R2966 VDD.n687 VDD.n548 6.3005
R2967 VDD.n688 VDD.n547 6.3005
R2968 VDD.n689 VDD.n546 6.3005
R2969 VDD.n545 VDD.n543 6.3005
R2970 VDD.n693 VDD.n542 6.3005
R2971 VDD.n694 VDD.n541 6.3005
R2972 VDD.n695 VDD.n540 6.3005
R2973 VDD.n539 VDD.n537 6.3005
R2974 VDD.n699 VDD.n536 6.3005
R2975 VDD.n700 VDD.n535 6.3005
R2976 VDD.n701 VDD.n534 6.3005
R2977 VDD.n533 VDD.n531 6.3005
R2978 VDD.n705 VDD.n530 6.3005
R2979 VDD.n706 VDD.n529 6.3005
R2980 VDD.n707 VDD.n528 6.3005
R2981 VDD.n527 VDD.n525 6.3005
R2982 VDD.n711 VDD.n524 6.3005
R2983 VDD.n712 VDD.n523 6.3005
R2984 VDD.n713 VDD.n522 6.3005
R2985 VDD.n521 VDD.n519 6.3005
R2986 VDD.n717 VDD.n518 6.3005
R2987 VDD.n718 VDD.n517 6.3005
R2988 VDD.n719 VDD.n516 6.3005
R2989 VDD.n515 VDD.n513 6.3005
R2990 VDD.n723 VDD.n512 6.3005
R2991 VDD.n724 VDD.n511 6.3005
R2992 VDD.n725 VDD.n510 6.3005
R2993 VDD.n509 VDD.n507 6.3005
R2994 VDD.n729 VDD.n506 6.3005
R2995 VDD.n730 VDD.n505 6.3005
R2996 VDD.n731 VDD.n504 6.3005
R2997 VDD.n595 VDD.n503 6.3005
R2998 VDD.n597 VDD.n596 6.3005
R2999 VDD.n676 VDD.n675 6.3005
R3000 VDD.n674 VDD.n558 6.3005
R3001 VDD.n668 VDD.n559 6.3005
R3002 VDD.n670 VDD.n669 6.3005
R3003 VDD.n667 VDD.n561 6.3005
R3004 VDD.n666 VDD.n665 6.3005
R3005 VDD.n563 VDD.n562 6.3005
R3006 VDD.n661 VDD.n660 6.3005
R3007 VDD.n659 VDD.n565 6.3005
R3008 VDD.n658 VDD.n657 6.3005
R3009 VDD.n567 VDD.n566 6.3005
R3010 VDD.n653 VDD.n652 6.3005
R3011 VDD.n651 VDD.n569 6.3005
R3012 VDD.n650 VDD.n649 6.3005
R3013 VDD.n571 VDD.n570 6.3005
R3014 VDD.n645 VDD.n644 6.3005
R3015 VDD.n643 VDD.n573 6.3005
R3016 VDD.n642 VDD.n641 6.3005
R3017 VDD.n575 VDD.n574 6.3005
R3018 VDD.n637 VDD.n636 6.3005
R3019 VDD.n635 VDD.n577 6.3005
R3020 VDD.n634 VDD.n633 6.3005
R3021 VDD.n579 VDD.n578 6.3005
R3022 VDD.n629 VDD.n628 6.3005
R3023 VDD.n627 VDD.n581 6.3005
R3024 VDD.n626 VDD.n625 6.3005
R3025 VDD.n583 VDD.n582 6.3005
R3026 VDD.n621 VDD.n620 6.3005
R3027 VDD.n619 VDD.n585 6.3005
R3028 VDD.n618 VDD.n617 6.3005
R3029 VDD.n587 VDD.n586 6.3005
R3030 VDD.n613 VDD.n612 6.3005
R3031 VDD.n611 VDD.n589 6.3005
R3032 VDD.n610 VDD.n609 6.3005
R3033 VDD.n591 VDD.n590 6.3005
R3034 VDD.n605 VDD.n604 6.3005
R3035 VDD.n603 VDD.n593 6.3005
R3036 VDD.n602 VDD.n601 6.3005
R3037 VDD.n453 VDD.n452 6.3005
R3038 VDD.n351 VDD.n349 6.3005
R3039 VDD.n457 VDD.n348 6.3005
R3040 VDD.n458 VDD.n347 6.3005
R3041 VDD.n459 VDD.n346 6.3005
R3042 VDD.n345 VDD.n343 6.3005
R3043 VDD.n463 VDD.n342 6.3005
R3044 VDD.n464 VDD.n341 6.3005
R3045 VDD.n465 VDD.n340 6.3005
R3046 VDD.n339 VDD.n337 6.3005
R3047 VDD.n469 VDD.n336 6.3005
R3048 VDD.n470 VDD.n335 6.3005
R3049 VDD.n471 VDD.n334 6.3005
R3050 VDD.n333 VDD.n331 6.3005
R3051 VDD.n475 VDD.n330 6.3005
R3052 VDD.n476 VDD.n329 6.3005
R3053 VDD.n477 VDD.n328 6.3005
R3054 VDD.n327 VDD.n325 6.3005
R3055 VDD.n481 VDD.n324 6.3005
R3056 VDD.n482 VDD.n323 6.3005
R3057 VDD.n483 VDD.n322 6.3005
R3058 VDD.n321 VDD.n319 6.3005
R3059 VDD.n487 VDD.n318 6.3005
R3060 VDD.n488 VDD.n317 6.3005
R3061 VDD.n489 VDD.n316 6.3005
R3062 VDD.n315 VDD.n313 6.3005
R3063 VDD.n493 VDD.n312 6.3005
R3064 VDD.n494 VDD.n311 6.3005
R3065 VDD.n495 VDD.n310 6.3005
R3066 VDD.n383 VDD.n309 6.3005
R3067 VDD.n386 VDD.n385 6.3005
R3068 VDD.n450 VDD.n449 6.3005
R3069 VDD.n353 VDD.n352 6.3005
R3070 VDD.n445 VDD.n444 6.3005
R3071 VDD.n443 VDD.n355 6.3005
R3072 VDD.n442 VDD.n441 6.3005
R3073 VDD.n357 VDD.n356 6.3005
R3074 VDD.n437 VDD.n436 6.3005
R3075 VDD.n435 VDD.n359 6.3005
R3076 VDD.n434 VDD.n433 6.3005
R3077 VDD.n361 VDD.n360 6.3005
R3078 VDD.n429 VDD.n428 6.3005
R3079 VDD.n427 VDD.n363 6.3005
R3080 VDD.n426 VDD.n425 6.3005
R3081 VDD.n365 VDD.n364 6.3005
R3082 VDD.n421 VDD.n420 6.3005
R3083 VDD.n419 VDD.n367 6.3005
R3084 VDD.n418 VDD.n417 6.3005
R3085 VDD.n369 VDD.n368 6.3005
R3086 VDD.n413 VDD.n412 6.3005
R3087 VDD.n411 VDD.n371 6.3005
R3088 VDD.n410 VDD.n409 6.3005
R3089 VDD.n373 VDD.n372 6.3005
R3090 VDD.n405 VDD.n404 6.3005
R3091 VDD.n403 VDD.n375 6.3005
R3092 VDD.n402 VDD.n401 6.3005
R3093 VDD.n377 VDD.n376 6.3005
R3094 VDD.n397 VDD.n396 6.3005
R3095 VDD.n395 VDD.n379 6.3005
R3096 VDD.n394 VDD.n393 6.3005
R3097 VDD.n381 VDD.n380 6.3005
R3098 VDD.n389 VDD.n388 6.3005
R3099 VDD.n306 VDD.n27 6.2132
R3100 VDD.n736 VDD.n306 6.071
R3101 VDD.n86 VDD.n85 5.91912
R3102 VDD.n198 VDD.n195 5.91912
R3103 VDD.n259 VDD.n54 5.91912
R3104 VDD.n276 VDD.n48 5.91912
R3105 VDD.n290 VDD.n289 5.8218
R3106 VDD.n246 VDD.n245 5.8218
R3107 VDD.n90 VDD.n89 5.61588
R3108 VDD.n9 VDD.n2 5.61588
R3109 VDD.n264 VDD.n263 5.61588
R3110 VDD.n268 VDD.n267 5.61588
R3111 VDD.n88 VDD.n87 5.05435
R3112 VDD.n11 VDD.n10 5.05435
R3113 VDD.n260 VDD.n52 5.05435
R3114 VDD.n266 VDD.n265 5.05435
R3115 VDD.n208 VDD.t18 4.74265
R3116 VDD.n205 VDD.t15 4.74265
R3117 VDD.n244 VDD.n239 4.69811
R3118 VDD.n292 VDD.n291 4.69811
R3119 VDD.n593 VDD.n592 4.5005
R3120 VDD.n606 VDD.n605 4.5005
R3121 VDD.n607 VDD.n591 4.5005
R3122 VDD.n609 VDD.n608 4.5005
R3123 VDD.n589 VDD.n588 4.5005
R3124 VDD.n614 VDD.n613 4.5005
R3125 VDD.n615 VDD.n587 4.5005
R3126 VDD.n617 VDD.n616 4.5005
R3127 VDD.n585 VDD.n584 4.5005
R3128 VDD.n622 VDD.n621 4.5005
R3129 VDD.n623 VDD.n583 4.5005
R3130 VDD.n625 VDD.n624 4.5005
R3131 VDD.n581 VDD.n580 4.5005
R3132 VDD.n630 VDD.n629 4.5005
R3133 VDD.n631 VDD.n579 4.5005
R3134 VDD.n633 VDD.n632 4.5005
R3135 VDD.n577 VDD.n576 4.5005
R3136 VDD.n638 VDD.n637 4.5005
R3137 VDD.n639 VDD.n575 4.5005
R3138 VDD.n641 VDD.n640 4.5005
R3139 VDD.n573 VDD.n572 4.5005
R3140 VDD.n646 VDD.n645 4.5005
R3141 VDD.n647 VDD.n571 4.5005
R3142 VDD.n649 VDD.n648 4.5005
R3143 VDD.n569 VDD.n568 4.5005
R3144 VDD.n654 VDD.n653 4.5005
R3145 VDD.n655 VDD.n567 4.5005
R3146 VDD.n657 VDD.n656 4.5005
R3147 VDD.n565 VDD.n564 4.5005
R3148 VDD.n662 VDD.n661 4.5005
R3149 VDD.n663 VDD.n563 4.5005
R3150 VDD.n665 VDD.n664 4.5005
R3151 VDD.n561 VDD.n560 4.5005
R3152 VDD.n671 VDD.n670 4.5005
R3153 VDD.n672 VDD.n559 4.5005
R3154 VDD.n674 VDD.n673 4.5005
R3155 VDD.n675 VDD.n556 4.5005
R3156 VDD.n601 VDD.n600 4.5005
R3157 VDD.n503 VDD.n501 4.5005
R3158 VDD.n732 VDD.n731 4.5005
R3159 VDD.n730 VDD.n502 4.5005
R3160 VDD.n729 VDD.n728 4.5005
R3161 VDD.n727 VDD.n507 4.5005
R3162 VDD.n726 VDD.n725 4.5005
R3163 VDD.n724 VDD.n508 4.5005
R3164 VDD.n723 VDD.n722 4.5005
R3165 VDD.n721 VDD.n513 4.5005
R3166 VDD.n720 VDD.n719 4.5005
R3167 VDD.n718 VDD.n514 4.5005
R3168 VDD.n717 VDD.n716 4.5005
R3169 VDD.n715 VDD.n519 4.5005
R3170 VDD.n714 VDD.n713 4.5005
R3171 VDD.n712 VDD.n520 4.5005
R3172 VDD.n711 VDD.n710 4.5005
R3173 VDD.n709 VDD.n525 4.5005
R3174 VDD.n708 VDD.n707 4.5005
R3175 VDD.n706 VDD.n526 4.5005
R3176 VDD.n705 VDD.n704 4.5005
R3177 VDD.n703 VDD.n531 4.5005
R3178 VDD.n702 VDD.n701 4.5005
R3179 VDD.n700 VDD.n532 4.5005
R3180 VDD.n699 VDD.n698 4.5005
R3181 VDD.n697 VDD.n537 4.5005
R3182 VDD.n696 VDD.n695 4.5005
R3183 VDD.n694 VDD.n538 4.5005
R3184 VDD.n693 VDD.n692 4.5005
R3185 VDD.n691 VDD.n543 4.5005
R3186 VDD.n690 VDD.n689 4.5005
R3187 VDD.n688 VDD.n544 4.5005
R3188 VDD.n687 VDD.n686 4.5005
R3189 VDD.n685 VDD.n549 4.5005
R3190 VDD.n684 VDD.n683 4.5005
R3191 VDD.n682 VDD.n550 4.5005
R3192 VDD.n681 VDD.n680 4.5005
R3193 VDD.n679 VDD.n555 4.5005
R3194 VDD.n598 VDD.n597 4.5005
R3195 VDD.n391 VDD.n381 4.5005
R3196 VDD.n393 VDD.n392 4.5005
R3197 VDD.n379 VDD.n378 4.5005
R3198 VDD.n398 VDD.n397 4.5005
R3199 VDD.n399 VDD.n377 4.5005
R3200 VDD.n401 VDD.n400 4.5005
R3201 VDD.n375 VDD.n374 4.5005
R3202 VDD.n406 VDD.n405 4.5005
R3203 VDD.n407 VDD.n373 4.5005
R3204 VDD.n409 VDD.n408 4.5005
R3205 VDD.n371 VDD.n370 4.5005
R3206 VDD.n414 VDD.n413 4.5005
R3207 VDD.n415 VDD.n369 4.5005
R3208 VDD.n417 VDD.n416 4.5005
R3209 VDD.n367 VDD.n366 4.5005
R3210 VDD.n422 VDD.n421 4.5005
R3211 VDD.n423 VDD.n365 4.5005
R3212 VDD.n425 VDD.n424 4.5005
R3213 VDD.n363 VDD.n362 4.5005
R3214 VDD.n430 VDD.n429 4.5005
R3215 VDD.n431 VDD.n361 4.5005
R3216 VDD.n433 VDD.n432 4.5005
R3217 VDD.n359 VDD.n358 4.5005
R3218 VDD.n438 VDD.n437 4.5005
R3219 VDD.n439 VDD.n357 4.5005
R3220 VDD.n441 VDD.n440 4.5005
R3221 VDD.n355 VDD.n354 4.5005
R3222 VDD.n446 VDD.n445 4.5005
R3223 VDD.n447 VDD.n353 4.5005
R3224 VDD.n449 VDD.n448 4.5005
R3225 VDD.n390 VDD.n389 4.5005
R3226 VDD.n309 VDD.n307 4.5005
R3227 VDD.n496 VDD.n495 4.5005
R3228 VDD.n494 VDD.n308 4.5005
R3229 VDD.n493 VDD.n492 4.5005
R3230 VDD.n491 VDD.n313 4.5005
R3231 VDD.n490 VDD.n489 4.5005
R3232 VDD.n488 VDD.n314 4.5005
R3233 VDD.n487 VDD.n486 4.5005
R3234 VDD.n485 VDD.n319 4.5005
R3235 VDD.n484 VDD.n483 4.5005
R3236 VDD.n482 VDD.n320 4.5005
R3237 VDD.n481 VDD.n480 4.5005
R3238 VDD.n479 VDD.n325 4.5005
R3239 VDD.n478 VDD.n477 4.5005
R3240 VDD.n476 VDD.n326 4.5005
R3241 VDD.n475 VDD.n474 4.5005
R3242 VDD.n473 VDD.n331 4.5005
R3243 VDD.n472 VDD.n471 4.5005
R3244 VDD.n470 VDD.n332 4.5005
R3245 VDD.n469 VDD.n468 4.5005
R3246 VDD.n467 VDD.n337 4.5005
R3247 VDD.n466 VDD.n465 4.5005
R3248 VDD.n464 VDD.n338 4.5005
R3249 VDD.n463 VDD.n462 4.5005
R3250 VDD.n461 VDD.n343 4.5005
R3251 VDD.n460 VDD.n459 4.5005
R3252 VDD.n458 VDD.n344 4.5005
R3253 VDD.n457 VDD.n456 4.5005
R3254 VDD.n455 VDD.n349 4.5005
R3255 VDD.n454 VDD.n453 4.5005
R3256 VDD.n385 VDD.n384 4.5005
R3257 VDD.n130 VDD.n129 4.5005
R3258 VDD.n131 VDD.n125 4.5005
R3259 VDD.n134 VDD.n133 4.5005
R3260 VDD.n135 VDD.n123 4.5005
R3261 VDD.n140 VDD.n139 4.5005
R3262 VDD.n138 VDD.n124 4.5005
R3263 VDD.n137 VDD.n136 4.5005
R3264 VDD.n114 VDD.n113 4.5005
R3265 VDD.n164 VDD.n163 4.5005
R3266 VDD.n165 VDD.n111 4.5005
R3267 VDD.n167 VDD.n166 4.5005
R3268 VDD.n168 VDD.n110 4.5005
R3269 VDD.n170 VDD.n169 4.5005
R3270 VDD.n171 VDD.n109 4.5005
R3271 VDD.n173 VDD.n172 4.5005
R3272 VDD.n174 VDD.n108 4.5005
R3273 VDD.n176 VDD.n175 4.5005
R3274 VDD.n177 VDD.n107 4.5005
R3275 VDD.n179 VDD.n178 4.5005
R3276 VDD.n180 VDD.n105 4.5005
R3277 VDD.n182 VDD.n181 4.5005
R3278 VDD.n183 VDD.n104 4.5005
R3279 VDD.n185 VDD.n184 4.5005
R3280 VDD.n35 VDD.n34 4.5005
R3281 VDD.n304 VDD.n303 4.5005
R3282 VDD.n305 VDD.n33 4.5005
R3283 VDD.n738 VDD.n737 4.5005
R3284 VDD.n128 VDD.n127 4.5005
R3285 VDD.n291 VDD.n290 4.5005
R3286 VDD.n245 VDD.n244 4.5005
R3287 VDD.n233 VDD.n232 4.5005
R3288 VDD.n71 VDD.n63 4.5005
R3289 VDD.n226 VDD.n225 4.5005
R3290 VDD.n224 VDD.n70 4.5005
R3291 VDD.n145 VDD.n75 4.5005
R3292 VDD.n147 VDD.n146 4.5005
R3293 VDD.n154 VDD.n153 4.5005
R3294 VDD.n79 VDD.n76 4.5005
R3295 VDD.n219 VDD.n218 4.5005
R3296 VDD.n217 VDD.n78 4.5005
R3297 VDD.n216 VDD.n215 4.5005
R3298 VDD.n212 VDD.n83 4.5005
R3299 VDD.n211 VDD.n210 4.5005
R3300 VDD.n4 VDD.n0 4.5005
R3301 VDD.n762 VDD.n761 4.5005
R3302 VDD.n760 VDD.n3 4.5005
R3303 VDD.n759 VDD.n758 4.5005
R3304 VDD.n12 VDD.n8 4.5005
R3305 VDD.n200 VDD.n199 4.5005
R3306 VDD.n16 VDD.n13 4.5005
R3307 VDD.n753 VDD.n752 4.5005
R3308 VDD.n751 VDD.n15 4.5005
R3309 VDD.n750 VDD.n749 4.5005
R3310 VDD.n748 VDD.n20 4.5005
R3311 VDD.n38 VDD.n25 4.5005
R3312 VDD.n299 VDD.n298 4.5005
R3313 VDD.n28 VDD.n26 4.5005
R3314 VDD.n744 VDD.n743 4.5005
R3315 VDD.n740 VDD.n739 4.10674
R3316 VDD.n126 VDD.n66 4.10674
R3317 VDD.n74 VDD.n73 3.93127
R3318 VDD.n84 VDD.n77 3.93127
R3319 VDD.n197 VDD.n196 3.93127
R3320 VDD.n40 VDD.n39 3.93127
R3321 VDD.n255 VDD.n254 3.93127
R3322 VDD.n278 VDD.n277 3.93127
R3323 VDD.n746 VDD.t10 3.9205
R3324 VDD.n746 VDD.t7 3.9205
R3325 VDD.t13 VDD.n755 3.9205
R3326 VDD.n755 VDD.t10 3.9205
R3327 VDD.n756 VDD.t16 3.9205
R3328 VDD.n756 VDD.t13 3.9205
R3329 VDD.t19 VDD.n1 3.9205
R3330 VDD.t16 VDD.n1 3.9205
R3331 VDD.n213 VDD.t22 3.9205
R3332 VDD.n213 VDD.t19 3.9205
R3333 VDD.t25 VDD.n221 3.9205
R3334 VDD.n221 VDD.t22 3.9205
R3335 VDD.n222 VDD.t28 3.9205
R3336 VDD.n222 VDD.t25 3.9205
R3337 VDD.n285 VDD.t38 3.9205
R3338 VDD.n285 VDD.t36 3.9205
R3339 VDD.n284 VDD.t40 3.9205
R3340 VDD.t38 VDD.n284 3.9205
R3341 VDD.n272 VDD.t42 3.9205
R3342 VDD.n272 VDD.t40 3.9205
R3343 VDD.n271 VDD.t44 3.9205
R3344 VDD.t42 VDD.n271 3.9205
R3345 VDD.t46 VDD.n240 3.9205
R3346 VDD.n240 VDD.t44 3.9205
R3347 VDD.t48 VDD.n241 3.9205
R3348 VDD.n241 VDD.t46 3.9205
R3349 VDD.t50 VDD.n243 3.9205
R3350 VDD.n243 VDD.t48 3.9205
R3351 VDD.n500 VDD.n499 3.4493
R3352 VDD.n150 VDD.n149 2.80819
R3353 VDD.n152 VDD.n150 2.80819
R3354 VDD.n22 VDD.n21 2.80819
R3355 VDD.n23 VDD.n22 2.80819
R3356 VDD.n249 VDD.n248 2.80819
R3357 VDD.n248 VDD.n56 2.80819
R3358 VDD.n280 VDD.n279 2.80819
R3359 VDD.n279 VDD.n44 2.80819
R3360 VDD.n246 VDD.t49 2.73469
R3361 VDD.n289 VDD.t35 2.73469
R3362 VDD.n237 VDD.n236 2.35281
R3363 VDD.n294 VDD.n41 2.35281
R3364 VDD.n42 VDD.t31 2.16689
R3365 VDD.t34 VDD.n235 2.1594
R3366 VDD.n499 VDD.n498 2.1227
R3367 VDD.n230 VDD.n66 2.03658
R3368 VDD.n741 VDD.n740 2.03658
R3369 VDD.t3 VDD.t21 1.7788
R3370 VDD.t12 VDD.t1 1.7788
R3371 VDD.n85 VDD.n84 1.68512
R3372 VDD.n198 VDD.n197 1.68512
R3373 VDD.n254 VDD.n54 1.68512
R3374 VDD.n277 VDD.n276 1.68512
R3375 VDD.n296 VDD.n41 1.66246
R3376 VDD.n236 VDD.n60 1.65213
R3377 VDD.n236 VDD.t34 1.23336
R3378 VDD.t31 VDD.n41 1.23336
R3379 VDD.n734 VDD.n500 0.9887
R3380 VDD.n73 VDD.t26 0.913
R3381 VDD.n150 VDD.t23 0.913
R3382 VDD.n84 VDD.t20 0.913
R3383 VDD.n88 VDD.t17 0.913
R3384 VDD.n10 VDD.t14 0.913
R3385 VDD.n197 VDD.t11 0.913
R3386 VDD.n22 VDD.t8 0.913
R3387 VDD.n40 VDD.t5 0.913
R3388 VDD.n248 VDD.t47 0.913
R3389 VDD.n254 VDD.t45 0.913
R3390 VDD.n52 VDD.t43 0.913
R3391 VDD.n266 VDD.t41 0.913
R3392 VDD.n277 VDD.t39 0.913
R3393 VDD.n279 VDD.t37 0.913
R3394 VDD.n90 VDD.n88 0.562038
R3395 VDD.n10 VDD.n9 0.562038
R3396 VDD.n263 VDD.n52 0.562038
R3397 VDD.n267 VDD.n266 0.562038
R3398 VDD.n42 VDD.n27 0.462063
R3399 VDD.n235 VDD.n234 0.437113
R3400 VDD.n735 VDD.n734 0.3839
R3401 VDD.n306 VDD.n30 0.203726
R3402 VDD.n64 VDD.n61 0.203726
R3403 VDD.n678 VDD.n677 0.197375
R3404 VDD.n599 VDD.n594 0.197375
R3405 VDD.n451 VDD.n350 0.1755
R3406 VDD.n387 VDD.n382 0.1755
R3407 VDD.n737 VDD.n736 0.1625
R3408 VDD.n130 VDD.n127 0.1445
R3409 VDD.n131 VDD.n130 0.1445
R3410 VDD.n133 VDD.n131 0.1445
R3411 VDD.n133 VDD.n123 0.1445
R3412 VDD.n140 VDD.n123 0.1445
R3413 VDD.n140 VDD.n124 0.1445
R3414 VDD.n136 VDD.n124 0.1445
R3415 VDD.n136 VDD.n114 0.1445
R3416 VDD.n163 VDD.n114 0.1445
R3417 VDD.n163 VDD.n111 0.1445
R3418 VDD.n167 VDD.n111 0.1445
R3419 VDD.n168 VDD.n167 0.1445
R3420 VDD.n169 VDD.n168 0.1445
R3421 VDD.n169 VDD.n109 0.1445
R3422 VDD.n173 VDD.n109 0.1445
R3423 VDD.n174 VDD.n173 0.1445
R3424 VDD.n175 VDD.n174 0.1445
R3425 VDD.n175 VDD.n107 0.1445
R3426 VDD.n179 VDD.n107 0.1445
R3427 VDD.n180 VDD.n179 0.1445
R3428 VDD.n181 VDD.n180 0.1445
R3429 VDD.n181 VDD.n104 0.1445
R3430 VDD.n185 VDD.n104 0.1445
R3431 VDD.n185 VDD.n35 0.1445
R3432 VDD.n303 VDD.n35 0.1445
R3433 VDD.n303 VDD.n33 0.1445
R3434 VDD.n738 VDD.n33 0.1445
R3435 VDD.n232 VDD.n63 0.1445
R3436 VDD.n226 VDD.n63 0.1445
R3437 VDD.n226 VDD.n70 0.1445
R3438 VDD.n145 VDD.n70 0.1445
R3439 VDD.n146 VDD.n145 0.1445
R3440 VDD.n154 VDD.n146 0.1445
R3441 VDD.n154 VDD.n79 0.1445
R3442 VDD.n218 VDD.n79 0.1445
R3443 VDD.n218 VDD.n217 0.1445
R3444 VDD.n217 VDD.n216 0.1445
R3445 VDD.n216 VDD.n83 0.1445
R3446 VDD.n210 VDD.n83 0.1445
R3447 VDD.n210 VDD.n4 0.1445
R3448 VDD.n761 VDD.n4 0.1445
R3449 VDD.n761 VDD.n760 0.1445
R3450 VDD.n760 VDD.n759 0.1445
R3451 VDD.n759 VDD.n8 0.1445
R3452 VDD.n200 VDD.n8 0.1445
R3453 VDD.n200 VDD.n16 0.1445
R3454 VDD.n752 VDD.n16 0.1445
R3455 VDD.n752 VDD.n751 0.1445
R3456 VDD.n751 VDD.n750 0.1445
R3457 VDD.n750 VDD.n20 0.1445
R3458 VDD.n38 VDD.n20 0.1445
R3459 VDD.n299 VDD.n38 0.1445
R3460 VDD.n299 VDD.n28 0.1445
R3461 VDD.n743 VDD.n28 0.1445
R3462 VDD.n601 VDD.n593 0.1445
R3463 VDD.n605 VDD.n593 0.1445
R3464 VDD.n605 VDD.n591 0.1445
R3465 VDD.n609 VDD.n591 0.1445
R3466 VDD.n609 VDD.n589 0.1445
R3467 VDD.n613 VDD.n589 0.1445
R3468 VDD.n613 VDD.n587 0.1445
R3469 VDD.n617 VDD.n587 0.1445
R3470 VDD.n617 VDD.n585 0.1445
R3471 VDD.n621 VDD.n585 0.1445
R3472 VDD.n621 VDD.n583 0.1445
R3473 VDD.n625 VDD.n583 0.1445
R3474 VDD.n625 VDD.n581 0.1445
R3475 VDD.n629 VDD.n581 0.1445
R3476 VDD.n629 VDD.n579 0.1445
R3477 VDD.n633 VDD.n579 0.1445
R3478 VDD.n633 VDD.n577 0.1445
R3479 VDD.n637 VDD.n577 0.1445
R3480 VDD.n637 VDD.n575 0.1445
R3481 VDD.n641 VDD.n575 0.1445
R3482 VDD.n641 VDD.n573 0.1445
R3483 VDD.n645 VDD.n573 0.1445
R3484 VDD.n645 VDD.n571 0.1445
R3485 VDD.n649 VDD.n571 0.1445
R3486 VDD.n649 VDD.n569 0.1445
R3487 VDD.n653 VDD.n569 0.1445
R3488 VDD.n653 VDD.n567 0.1445
R3489 VDD.n657 VDD.n567 0.1445
R3490 VDD.n657 VDD.n565 0.1445
R3491 VDD.n661 VDD.n565 0.1445
R3492 VDD.n661 VDD.n563 0.1445
R3493 VDD.n665 VDD.n563 0.1445
R3494 VDD.n665 VDD.n561 0.1445
R3495 VDD.n670 VDD.n561 0.1445
R3496 VDD.n670 VDD.n559 0.1445
R3497 VDD.n674 VDD.n559 0.1445
R3498 VDD.n675 VDD.n674 0.1445
R3499 VDD.n597 VDD.n503 0.1445
R3500 VDD.n731 VDD.n503 0.1445
R3501 VDD.n731 VDD.n730 0.1445
R3502 VDD.n730 VDD.n729 0.1445
R3503 VDD.n729 VDD.n507 0.1445
R3504 VDD.n725 VDD.n507 0.1445
R3505 VDD.n725 VDD.n724 0.1445
R3506 VDD.n724 VDD.n723 0.1445
R3507 VDD.n723 VDD.n513 0.1445
R3508 VDD.n719 VDD.n513 0.1445
R3509 VDD.n719 VDD.n718 0.1445
R3510 VDD.n718 VDD.n717 0.1445
R3511 VDD.n717 VDD.n519 0.1445
R3512 VDD.n713 VDD.n519 0.1445
R3513 VDD.n713 VDD.n712 0.1445
R3514 VDD.n712 VDD.n711 0.1445
R3515 VDD.n711 VDD.n525 0.1445
R3516 VDD.n707 VDD.n525 0.1445
R3517 VDD.n707 VDD.n706 0.1445
R3518 VDD.n706 VDD.n705 0.1445
R3519 VDD.n705 VDD.n531 0.1445
R3520 VDD.n701 VDD.n531 0.1445
R3521 VDD.n701 VDD.n700 0.1445
R3522 VDD.n700 VDD.n699 0.1445
R3523 VDD.n699 VDD.n537 0.1445
R3524 VDD.n695 VDD.n537 0.1445
R3525 VDD.n695 VDD.n694 0.1445
R3526 VDD.n694 VDD.n693 0.1445
R3527 VDD.n693 VDD.n543 0.1445
R3528 VDD.n689 VDD.n543 0.1445
R3529 VDD.n689 VDD.n688 0.1445
R3530 VDD.n688 VDD.n687 0.1445
R3531 VDD.n687 VDD.n549 0.1445
R3532 VDD.n683 VDD.n549 0.1445
R3533 VDD.n683 VDD.n682 0.1445
R3534 VDD.n682 VDD.n681 0.1445
R3535 VDD.n681 VDD.n555 0.1445
R3536 VDD.n600 VDD.n592 0.1445
R3537 VDD.n606 VDD.n592 0.1445
R3538 VDD.n607 VDD.n606 0.1445
R3539 VDD.n608 VDD.n607 0.1445
R3540 VDD.n608 VDD.n588 0.1445
R3541 VDD.n614 VDD.n588 0.1445
R3542 VDD.n615 VDD.n614 0.1445
R3543 VDD.n616 VDD.n615 0.1445
R3544 VDD.n616 VDD.n584 0.1445
R3545 VDD.n622 VDD.n584 0.1445
R3546 VDD.n623 VDD.n622 0.1445
R3547 VDD.n624 VDD.n623 0.1445
R3548 VDD.n624 VDD.n580 0.1445
R3549 VDD.n630 VDD.n580 0.1445
R3550 VDD.n631 VDD.n630 0.1445
R3551 VDD.n632 VDD.n631 0.1445
R3552 VDD.n632 VDD.n576 0.1445
R3553 VDD.n638 VDD.n576 0.1445
R3554 VDD.n639 VDD.n638 0.1445
R3555 VDD.n640 VDD.n639 0.1445
R3556 VDD.n640 VDD.n572 0.1445
R3557 VDD.n646 VDD.n572 0.1445
R3558 VDD.n647 VDD.n646 0.1445
R3559 VDD.n648 VDD.n647 0.1445
R3560 VDD.n648 VDD.n568 0.1445
R3561 VDD.n654 VDD.n568 0.1445
R3562 VDD.n655 VDD.n654 0.1445
R3563 VDD.n656 VDD.n655 0.1445
R3564 VDD.n656 VDD.n564 0.1445
R3565 VDD.n662 VDD.n564 0.1445
R3566 VDD.n663 VDD.n662 0.1445
R3567 VDD.n664 VDD.n663 0.1445
R3568 VDD.n664 VDD.n560 0.1445
R3569 VDD.n671 VDD.n560 0.1445
R3570 VDD.n672 VDD.n671 0.1445
R3571 VDD.n673 VDD.n672 0.1445
R3572 VDD.n673 VDD.n556 0.1445
R3573 VDD.n598 VDD.n501 0.1445
R3574 VDD.n732 VDD.n502 0.1445
R3575 VDD.n728 VDD.n502 0.1445
R3576 VDD.n728 VDD.n727 0.1445
R3577 VDD.n727 VDD.n726 0.1445
R3578 VDD.n726 VDD.n508 0.1445
R3579 VDD.n722 VDD.n508 0.1445
R3580 VDD.n722 VDD.n721 0.1445
R3581 VDD.n721 VDD.n720 0.1445
R3582 VDD.n720 VDD.n514 0.1445
R3583 VDD.n716 VDD.n514 0.1445
R3584 VDD.n716 VDD.n715 0.1445
R3585 VDD.n715 VDD.n714 0.1445
R3586 VDD.n714 VDD.n520 0.1445
R3587 VDD.n710 VDD.n520 0.1445
R3588 VDD.n710 VDD.n709 0.1445
R3589 VDD.n709 VDD.n708 0.1445
R3590 VDD.n708 VDD.n526 0.1445
R3591 VDD.n704 VDD.n526 0.1445
R3592 VDD.n704 VDD.n703 0.1445
R3593 VDD.n703 VDD.n702 0.1445
R3594 VDD.n702 VDD.n532 0.1445
R3595 VDD.n698 VDD.n532 0.1445
R3596 VDD.n698 VDD.n697 0.1445
R3597 VDD.n697 VDD.n696 0.1445
R3598 VDD.n696 VDD.n538 0.1445
R3599 VDD.n692 VDD.n538 0.1445
R3600 VDD.n692 VDD.n691 0.1445
R3601 VDD.n691 VDD.n690 0.1445
R3602 VDD.n690 VDD.n544 0.1445
R3603 VDD.n686 VDD.n544 0.1445
R3604 VDD.n686 VDD.n685 0.1445
R3605 VDD.n685 VDD.n684 0.1445
R3606 VDD.n684 VDD.n550 0.1445
R3607 VDD.n680 VDD.n550 0.1445
R3608 VDD.n680 VDD.n679 0.1445
R3609 VDD.n389 VDD.n381 0.1445
R3610 VDD.n393 VDD.n381 0.1445
R3611 VDD.n393 VDD.n379 0.1445
R3612 VDD.n397 VDD.n379 0.1445
R3613 VDD.n397 VDD.n377 0.1445
R3614 VDD.n401 VDD.n377 0.1445
R3615 VDD.n401 VDD.n375 0.1445
R3616 VDD.n405 VDD.n375 0.1445
R3617 VDD.n405 VDD.n373 0.1445
R3618 VDD.n409 VDD.n373 0.1445
R3619 VDD.n409 VDD.n371 0.1445
R3620 VDD.n413 VDD.n371 0.1445
R3621 VDD.n413 VDD.n369 0.1445
R3622 VDD.n417 VDD.n369 0.1445
R3623 VDD.n417 VDD.n367 0.1445
R3624 VDD.n421 VDD.n367 0.1445
R3625 VDD.n421 VDD.n365 0.1445
R3626 VDD.n425 VDD.n365 0.1445
R3627 VDD.n425 VDD.n363 0.1445
R3628 VDD.n429 VDD.n363 0.1445
R3629 VDD.n429 VDD.n361 0.1445
R3630 VDD.n433 VDD.n361 0.1445
R3631 VDD.n433 VDD.n359 0.1445
R3632 VDD.n437 VDD.n359 0.1445
R3633 VDD.n437 VDD.n357 0.1445
R3634 VDD.n441 VDD.n357 0.1445
R3635 VDD.n441 VDD.n355 0.1445
R3636 VDD.n445 VDD.n355 0.1445
R3637 VDD.n445 VDD.n353 0.1445
R3638 VDD.n449 VDD.n353 0.1445
R3639 VDD.n385 VDD.n309 0.1445
R3640 VDD.n495 VDD.n309 0.1445
R3641 VDD.n495 VDD.n494 0.1445
R3642 VDD.n494 VDD.n493 0.1445
R3643 VDD.n493 VDD.n313 0.1445
R3644 VDD.n489 VDD.n313 0.1445
R3645 VDD.n489 VDD.n488 0.1445
R3646 VDD.n488 VDD.n487 0.1445
R3647 VDD.n487 VDD.n319 0.1445
R3648 VDD.n483 VDD.n319 0.1445
R3649 VDD.n483 VDD.n482 0.1445
R3650 VDD.n482 VDD.n481 0.1445
R3651 VDD.n481 VDD.n325 0.1445
R3652 VDD.n477 VDD.n325 0.1445
R3653 VDD.n477 VDD.n476 0.1445
R3654 VDD.n476 VDD.n475 0.1445
R3655 VDD.n475 VDD.n331 0.1445
R3656 VDD.n471 VDD.n331 0.1445
R3657 VDD.n471 VDD.n470 0.1445
R3658 VDD.n470 VDD.n469 0.1445
R3659 VDD.n469 VDD.n337 0.1445
R3660 VDD.n465 VDD.n337 0.1445
R3661 VDD.n465 VDD.n464 0.1445
R3662 VDD.n464 VDD.n463 0.1445
R3663 VDD.n463 VDD.n343 0.1445
R3664 VDD.n459 VDD.n343 0.1445
R3665 VDD.n459 VDD.n458 0.1445
R3666 VDD.n458 VDD.n457 0.1445
R3667 VDD.n457 VDD.n349 0.1445
R3668 VDD.n453 VDD.n349 0.1445
R3669 VDD.n391 VDD.n390 0.1445
R3670 VDD.n392 VDD.n391 0.1445
R3671 VDD.n392 VDD.n378 0.1445
R3672 VDD.n398 VDD.n378 0.1445
R3673 VDD.n399 VDD.n398 0.1445
R3674 VDD.n400 VDD.n399 0.1445
R3675 VDD.n400 VDD.n374 0.1445
R3676 VDD.n406 VDD.n374 0.1445
R3677 VDD.n407 VDD.n406 0.1445
R3678 VDD.n408 VDD.n407 0.1445
R3679 VDD.n408 VDD.n370 0.1445
R3680 VDD.n414 VDD.n370 0.1445
R3681 VDD.n415 VDD.n414 0.1445
R3682 VDD.n416 VDD.n415 0.1445
R3683 VDD.n416 VDD.n366 0.1445
R3684 VDD.n422 VDD.n366 0.1445
R3685 VDD.n423 VDD.n422 0.1445
R3686 VDD.n424 VDD.n423 0.1445
R3687 VDD.n424 VDD.n362 0.1445
R3688 VDD.n430 VDD.n362 0.1445
R3689 VDD.n431 VDD.n430 0.1445
R3690 VDD.n432 VDD.n431 0.1445
R3691 VDD.n432 VDD.n358 0.1445
R3692 VDD.n438 VDD.n358 0.1445
R3693 VDD.n439 VDD.n438 0.1445
R3694 VDD.n440 VDD.n439 0.1445
R3695 VDD.n440 VDD.n354 0.1445
R3696 VDD.n446 VDD.n354 0.1445
R3697 VDD.n447 VDD.n446 0.1445
R3698 VDD.n448 VDD.n447 0.1445
R3699 VDD.n384 VDD.n307 0.1445
R3700 VDD.n496 VDD.n308 0.1445
R3701 VDD.n492 VDD.n308 0.1445
R3702 VDD.n492 VDD.n491 0.1445
R3703 VDD.n491 VDD.n490 0.1445
R3704 VDD.n490 VDD.n314 0.1445
R3705 VDD.n486 VDD.n314 0.1445
R3706 VDD.n486 VDD.n485 0.1445
R3707 VDD.n485 VDD.n484 0.1445
R3708 VDD.n484 VDD.n320 0.1445
R3709 VDD.n480 VDD.n320 0.1445
R3710 VDD.n480 VDD.n479 0.1445
R3711 VDD.n479 VDD.n478 0.1445
R3712 VDD.n478 VDD.n326 0.1445
R3713 VDD.n474 VDD.n326 0.1445
R3714 VDD.n474 VDD.n473 0.1445
R3715 VDD.n473 VDD.n472 0.1445
R3716 VDD.n472 VDD.n332 0.1445
R3717 VDD.n468 VDD.n332 0.1445
R3718 VDD.n468 VDD.n467 0.1445
R3719 VDD.n467 VDD.n466 0.1445
R3720 VDD.n466 VDD.n338 0.1445
R3721 VDD.n462 VDD.n338 0.1445
R3722 VDD.n462 VDD.n461 0.1445
R3723 VDD.n461 VDD.n460 0.1445
R3724 VDD.n460 VDD.n344 0.1445
R3725 VDD.n456 VDD.n344 0.1445
R3726 VDD.n456 VDD.n455 0.1445
R3727 VDD.n455 VDD.n454 0.1445
R3728 VDD.n129 VDD.n128 0.1445
R3729 VDD.n129 VDD.n125 0.1445
R3730 VDD.n134 VDD.n125 0.1445
R3731 VDD.n135 VDD.n134 0.1445
R3732 VDD.n139 VDD.n135 0.1445
R3733 VDD.n139 VDD.n138 0.1445
R3734 VDD.n138 VDD.n137 0.1445
R3735 VDD.n137 VDD.n113 0.1445
R3736 VDD.n164 VDD.n113 0.1445
R3737 VDD.n165 VDD.n164 0.1445
R3738 VDD.n166 VDD.n165 0.1445
R3739 VDD.n166 VDD.n110 0.1445
R3740 VDD.n170 VDD.n110 0.1445
R3741 VDD.n171 VDD.n170 0.1445
R3742 VDD.n172 VDD.n171 0.1445
R3743 VDD.n172 VDD.n108 0.1445
R3744 VDD.n176 VDD.n108 0.1445
R3745 VDD.n177 VDD.n176 0.1445
R3746 VDD.n178 VDD.n177 0.1445
R3747 VDD.n178 VDD.n105 0.1445
R3748 VDD.n182 VDD.n105 0.1445
R3749 VDD.n183 VDD.n182 0.1445
R3750 VDD.n184 VDD.n183 0.1445
R3751 VDD.n184 VDD.n34 0.1445
R3752 VDD.n304 VDD.n34 0.1445
R3753 VDD.n305 VDD.n304 0.1445
R3754 VDD.n737 VDD.n305 0.1445
R3755 VDD.n235 VDD.n59 0.107278
R3756 VDD.n295 VDD.n42 0.0922644
R3757 VDD.n733 VDD.n732 0.0905
R3758 VDD.n72 VDD.n60 0.0847125
R3759 VDD.n297 VDD.n296 0.0779226
R3760 VDD.n497 VDD.n496 0.0761
R3761 VDD.n497 VDD.n307 0.0689
R3762 VDD.n294 VDD.n293 0.0572937
R3763 VDD.n238 VDD.n237 0.0572937
R3764 VDD.n293 VDD.n292 0.0552335
R3765 VDD.n239 VDD.n238 0.0552335
R3766 VDD.n733 VDD.n501 0.0545
R3767 VDD.n296 VDD.n295 0.0430846
R3768 VDD.n60 VDD.n59 0.0367015
R3769 VDD.n295 VDD.n294 0.0277385
R3770 VDD.n237 VDD.n59 0.0277385
R3771 VDD.n250 VDD.n57 0.0203347
R3772 VDD.n251 VDD.n250 0.0203347
R3773 VDD.n252 VDD.n251 0.0203347
R3774 VDD.n257 VDD.n256 0.0203347
R3775 VDD.n258 VDD.n257 0.0203347
R3776 VDD.n262 VDD.n261 0.0203347
R3777 VDD.n262 VDD.n50 0.0203347
R3778 VDD.n269 VDD.n51 0.0203347
R3779 VDD.n51 VDD.n49 0.0203347
R3780 VDD.n275 VDD.n274 0.0203347
R3781 VDD.n275 VDD.n46 0.0203347
R3782 VDD.n282 VDD.n47 0.0203347
R3783 VDD.n47 VDD.n45 0.0203347
R3784 VDD.n287 VDD.n45 0.0203347
R3785 VDD.n292 VDD.n43 0.0186975
R3786 VDD.n239 VDD.n58 0.0186975
R3787 VDD.n256 VDD.n55 0.0183512
R3788 VDD.n283 VDD.n46 0.0183512
R3789 VDD.n225 VDD.n224 0.0167896
R3790 VDD.n147 VDD.n75 0.0167896
R3791 VDD.n153 VDD.n147 0.0167896
R3792 VDD.n153 VDD.n76 0.0167896
R3793 VDD.n219 VDD.n78 0.0167896
R3794 VDD.n215 VDD.n78 0.0167896
R3795 VDD.n212 VDD.n211 0.0167896
R3796 VDD.n211 VDD.n0 0.0167896
R3797 VDD.n762 VDD.n3 0.0167896
R3798 VDD.n758 VDD.n3 0.0167896
R3799 VDD.n199 VDD.n12 0.0167896
R3800 VDD.n199 VDD.n13 0.0167896
R3801 VDD.n753 VDD.n15 0.0167896
R3802 VDD.n749 VDD.n15 0.0167896
R3803 VDD.n749 VDD.n748 0.0167896
R3804 VDD.n298 VDD.n25 0.0167896
R3805 VDD.n224 VDD.n223 0.0151606
R3806 VDD.n220 VDD.n219 0.0151606
R3807 VDD.n754 VDD.n13 0.0151606
R3808 VDD.n747 VDD.n25 0.0151606
R3809 VDD.n72 VDD.n71 0.014448
R3810 VDD.n297 VDD.n26 0.014448
R3811 VDD.n261 VDD.n53 0.0143843
R3812 VDD.n273 VDD.n49 0.0143843
R3813 VDD.n290 VDD.n43 0.0119263
R3814 VDD.n245 VDD.n58 0.0119263
R3815 VDD.n233 VDD.n62 0.0119027
R3816 VDD.n214 VDD.n212 0.0119027
R3817 VDD.n758 VDD.n757 0.0119027
R3818 VDD.n745 VDD.n744 0.0119027
R3819 VDD.n270 VDD.n50 0.0104174
R3820 VDD.n270 VDD.n269 0.0104174
R3821 VDD VDD.n0 0.0086448
R3822 VDD VDD.n762 0.0086448
R3823 VDD.n258 VDD.n53 0.00645041
R3824 VDD.n274 VDD.n273 0.00645041
R3825 VDD.n71 VDD.n62 0.00538688
R3826 VDD.n215 VDD.n214 0.00538688
R3827 VDD.n757 VDD.n12 0.00538688
R3828 VDD.n745 VDD.n26 0.00538688
R3829 VDD.n225 VDD.n72 0.00284163
R3830 VDD.n298 VDD.n297 0.00284163
R3831 VDD.n234 VDD.n233 0.00273982
R3832 VDD.n744 VDD.n27 0.00273982
R3833 VDD.n242 VDD.n57 0.00248347
R3834 VDD.n252 VDD.n55 0.00248347
R3835 VDD.n283 VDD.n282 0.00248347
R3836 VDD.n287 VDD.n286 0.00248347
R3837 VDD.n223 VDD.n75 0.00212896
R3838 VDD.n220 VDD.n76 0.00212896
R3839 VDD.n754 VDD.n753 0.00212896
R3840 VDD.n748 VDD.n747 0.00212896
R3841 VDD.n242 VDD.n58 0.00149173
R3842 VDD.n286 VDD.n43 0.00149173
R3843 VSS.n1292 VSS.n169 42920
R3844 VSS.t22 VSS.t27 288.606
R3845 VSS.n376 VSS.n373 286.904
R3846 VSS.n482 VSS.n180 286.904
R3847 VSS.n482 VSS.n311 286.904
R3848 VSS.n1291 VSS.n205 273.538
R3849 VSS.n1282 VSS.n213 273.538
R3850 VSS.n242 VSS.n238 272.904
R3851 VSS.n1290 VSS.n207 272.904
R3852 VSS.n1281 VSS.n238 272.904
R3853 VSS.n1284 VSS.n207 272.904
R3854 VSS.n1060 VSS.n1051 181.125
R3855 VSS.n1060 VSS.n1059 181.125
R3856 VSS.n36 VSS.n31 181.125
R3857 VSS.n1372 VSS.n31 181.125
R3858 VSS.n1062 VSS.n309 167.125
R3859 VSS.n1062 VSS.n310 167.125
R3860 VSS.n622 VSS.n483 167.125
R3861 VSS.n919 VSS.n483 167.125
R3862 VSS.n921 VSS.n920 113.588
R3863 VSS.n1061 VSS.n169 112.719
R3864 VSS.n921 VSS.n485 66.6464
R3865 VSS.n376 VSS.n375 59.3778
R3866 VSS.n382 VSS.n372 47.5847
R3867 VSS.n382 VSS.n366 47.5847
R3868 VSS.n393 VSS.n366 47.5847
R3869 VSS.n393 VSS.n359 47.5847
R3870 VSS.n402 VSS.n359 47.5847
R3871 VSS.n1371 VSS.n33 47.5847
R3872 VSS.n1371 VSS.n35 47.5847
R3873 VSS.n1359 VSS.n60 47.5847
R3874 VSS.n1359 VSS.n63 47.5847
R3875 VSS.n1353 VSS.n74 47.5847
R3876 VSS.n1347 VSS.n74 47.5847
R3877 VSS.n1341 VSS.n92 47.5847
R3878 VSS.n1341 VSS.n95 47.5847
R3879 VSS.n1335 VSS.n106 47.5847
R3880 VSS.n1329 VSS.n106 47.5847
R3881 VSS.n1329 VSS.n116 47.5847
R3882 VSS.n1323 VSS.n127 47.5847
R3883 VSS.n1317 VSS.n127 47.5847
R3884 VSS.n1311 VSS.n145 47.5847
R3885 VSS.n1311 VSS.n148 47.5847
R3886 VSS.n1305 VSS.n159 47.5847
R3887 VSS.n1299 VSS.n159 47.5847
R3888 VSS.n1292 VSS.n1291 46.3628
R3889 VSS.n920 VSS.n205 46.3628
R3890 VSS.t27 VSS.n921 46.3628
R3891 VSS.n485 VSS.n213 46.3628
R3892 VSS.n1282 VSS.n214 46.3628
R3893 VSS.n103 VSS.n95 42.8263
R3894 VSS.n1323 VSS.n124 42.8263
R3895 VSS.n360 VSS.n33 33.3094
R3896 VSS.n60 VSS.n48 33.3094
R3897 VSS.n1347 VSS.n84 33.3094
R3898 VSS.n145 VSS.n137 33.3094
R3899 VSS.n484 VSS.t1 32.4435
R3900 VSS.n1365 VSS.n45 27.9562
R3901 VSS.n71 VSS.n63 23.7926
R3902 VSS.n1353 VSS.n71 23.7926
R3903 VSS.n156 VSS.n148 23.7926
R3904 VSS.n1305 VSS.n156 23.7926
R3905 VSS.n1061 VSS.t22 23.4714
R3906 Isum VSS.n1453 19.6673
R3907 VSS.n45 VSS.n35 19.629
R3908 VSS.n306 VSS.t48 19.395
R3909 VSS.n315 VSS.t47 19.2512
R3910 VSS.n707 VSS.n706 15.8697
R3911 VSS.n792 VSS.n650 15.8697
R3912 VSS.n718 VSS.n717 15.8697
R3913 VSS.n780 VSS.n779 15.8697
R3914 VSS.n622 VSS.n621 15.5561
R3915 VSS.n619 VSS.n507 15.5561
R3916 VSS.n615 VSS.n614 15.5561
R3917 VSS.n612 VSS.n513 15.5561
R3918 VSS.n608 VSS.n607 15.5561
R3919 VSS.n605 VSS.n520 15.5561
R3920 VSS.n601 VSS.n600 15.5561
R3921 VSS.n598 VSS.n527 15.5561
R3922 VSS.n594 VSS.n593 15.5561
R3923 VSS.n591 VSS.n534 15.5561
R3924 VSS.n587 VSS.n586 15.5561
R3925 VSS.n584 VSS.n541 15.5561
R3926 VSS.n580 VSS.n579 15.5561
R3927 VSS.n577 VSS.n548 15.5561
R3928 VSS.n573 VSS.n572 15.5561
R3929 VSS.n570 VSS.n555 15.5561
R3930 VSS.n566 VSS.n565 15.5561
R3931 VSS.n919 VSS.n503 15.5561
R3932 VSS.n913 VSS.n912 15.5561
R3933 VSS.n909 VSS.n908 15.5561
R3934 VSS.n905 VSS.n904 15.5561
R3935 VSS.n901 VSS.n900 15.5561
R3936 VSS.n897 VSS.n896 15.5561
R3937 VSS.n893 VSS.n892 15.5561
R3938 VSS.n889 VSS.n888 15.5561
R3939 VSS.n885 VSS.n884 15.5561
R3940 VSS.n881 VSS.n880 15.5561
R3941 VSS.n877 VSS.n876 15.5561
R3942 VSS.n873 VSS.n872 15.5561
R3943 VSS.n869 VSS.n868 15.5561
R3944 VSS.n865 VSS.n864 15.5561
R3945 VSS.n861 VSS.n860 15.5561
R3946 VSS.n857 VSS.n856 15.5561
R3947 VSS.n853 VSS.n852 15.5561
R3948 VSS.n381 VSS.n373 15.5561
R3949 VSS.n381 VSS.n365 15.5561
R3950 VSS.n394 VSS.n365 15.5561
R3951 VSS.n394 VSS.n361 15.5561
R3952 VSS.n401 VSS.n361 15.5561
R3953 VSS.n401 VSS.n37 15.5561
R3954 VSS.n1370 VSS.n37 15.5561
R3955 VSS.n1370 VSS.n38 15.5561
R3956 VSS.n1366 VSS.n38 15.5561
R3957 VSS.n1366 VSS.n44 15.5561
R3958 VSS.n1358 VSS.n44 15.5561
R3959 VSS.n1358 VSS.n64 15.5561
R3960 VSS.n1354 VSS.n64 15.5561
R3961 VSS.n1354 VSS.n70 15.5561
R3962 VSS.n1346 VSS.n70 15.5561
R3963 VSS.n1346 VSS.n85 15.5561
R3964 VSS.n1342 VSS.n85 15.5561
R3965 VSS.n1342 VSS.n91 15.5561
R3966 VSS.n1334 VSS.n91 15.5561
R3967 VSS.n1334 VSS.n107 15.5561
R3968 VSS.n1330 VSS.n107 15.5561
R3969 VSS.n1330 VSS.n113 15.5561
R3970 VSS.n1322 VSS.n113 15.5561
R3971 VSS.n1322 VSS.n128 15.5561
R3972 VSS.n1318 VSS.n128 15.5561
R3973 VSS.n1318 VSS.n134 15.5561
R3974 VSS.n1310 VSS.n134 15.5561
R3975 VSS.n1310 VSS.n149 15.5561
R3976 VSS.n1306 VSS.n149 15.5561
R3977 VSS.n1306 VSS.n155 15.5561
R3978 VSS.n1298 VSS.n155 15.5561
R3979 VSS.n1298 VSS.n170 15.5561
R3980 VSS.n1294 VSS.n176 15.5561
R3981 VSS.n319 VSS.n176 15.5561
R3982 VSS.n323 VSS.n322 15.5561
R3983 VSS.n329 VSS.n328 15.5561
R3984 VSS.n331 VSS.n180 15.5561
R3985 VSS.n383 VSS.n371 15.5561
R3986 VSS.n383 VSS.n367 15.5561
R3987 VSS.n392 VSS.n367 15.5561
R3988 VSS.n392 VSS.n358 15.5561
R3989 VSS.n403 VSS.n358 15.5561
R3990 VSS.n404 VSS.n403 15.5561
R3991 VSS.n404 VSS.n34 15.5561
R3992 VSS.n407 VSS.n34 15.5561
R3993 VSS.n407 VSS.n47 15.5561
R3994 VSS.n412 VSS.n47 15.5561
R3995 VSS.n412 VSS.n62 15.5561
R3996 VSS.n415 VSS.n62 15.5561
R3997 VSS.n415 VSS.n73 15.5561
R3998 VSS.n420 VSS.n73 15.5561
R3999 VSS.n420 VSS.n83 15.5561
R4000 VSS.n423 VSS.n83 15.5561
R4001 VSS.n423 VSS.n94 15.5561
R4002 VSS.n428 VSS.n94 15.5561
R4003 VSS.n428 VSS.n105 15.5561
R4004 VSS.n431 VSS.n105 15.5561
R4005 VSS.n431 VSS.n115 15.5561
R4006 VSS.n436 VSS.n115 15.5561
R4007 VSS.n436 VSS.n126 15.5561
R4008 VSS.n439 VSS.n126 15.5561
R4009 VSS.n439 VSS.n136 15.5561
R4010 VSS.n444 VSS.n136 15.5561
R4011 VSS.n444 VSS.n147 15.5561
R4012 VSS.n447 VSS.n147 15.5561
R4013 VSS.n447 VSS.n158 15.5561
R4014 VSS.n452 VSS.n158 15.5561
R4015 VSS.n452 VSS.n168 15.5561
R4016 VSS.n456 VSS.n168 15.5561
R4017 VSS.n462 VSS.n341 15.5561
R4018 VSS.n466 VSS.n464 15.5561
R4019 VSS.n473 VSS.n337 15.5561
R4020 VSS.n477 VSS.n475 15.5561
R4021 VSS.n49 VSS.n36 15.5561
R4022 VSS.n1364 VSS.n49 15.5561
R4023 VSS.n1364 VSS.n50 15.5561
R4024 VSS.n1360 VSS.n50 15.5561
R4025 VSS.n1360 VSS.n59 15.5561
R4026 VSS.n1352 VSS.n59 15.5561
R4027 VSS.n1352 VSS.n75 15.5561
R4028 VSS.n1348 VSS.n75 15.5561
R4029 VSS.n1348 VSS.n81 15.5561
R4030 VSS.n1340 VSS.n81 15.5561
R4031 VSS.n1340 VSS.n96 15.5561
R4032 VSS.n1336 VSS.n96 15.5561
R4033 VSS.n1336 VSS.n102 15.5561
R4034 VSS.n1328 VSS.n102 15.5561
R4035 VSS.n1328 VSS.n117 15.5561
R4036 VSS.n1324 VSS.n117 15.5561
R4037 VSS.n1324 VSS.n123 15.5561
R4038 VSS.n1316 VSS.n123 15.5561
R4039 VSS.n1316 VSS.n138 15.5561
R4040 VSS.n1312 VSS.n138 15.5561
R4041 VSS.n1312 VSS.n144 15.5561
R4042 VSS.n1304 VSS.n144 15.5561
R4043 VSS.n1304 VSS.n160 15.5561
R4044 VSS.n1300 VSS.n160 15.5561
R4045 VSS.n1300 VSS.n166 15.5561
R4046 VSS.n1053 VSS.n166 15.5561
R4047 VSS.n1372 VSS.n32 15.5561
R4048 VSS.n46 VSS.n32 15.5561
R4049 VSS.n976 VSS.n46 15.5561
R4050 VSS.n976 VSS.n61 15.5561
R4051 VSS.n961 VSS.n61 15.5561
R4052 VSS.n961 VSS.n72 15.5561
R4053 VSS.n987 VSS.n72 15.5561
R4054 VSS.n987 VSS.n82 15.5561
R4055 VSS.n948 VSS.n82 15.5561
R4056 VSS.n948 VSS.n93 15.5561
R4057 VSS.n1004 VSS.n93 15.5561
R4058 VSS.n1004 VSS.n104 15.5561
R4059 VSS.n943 VSS.n104 15.5561
R4060 VSS.n943 VSS.n114 15.5561
R4061 VSS.n1014 VSS.n114 15.5561
R4062 VSS.n1014 VSS.n125 15.5561
R4063 VSS.n1016 VSS.n125 15.5561
R4064 VSS.n1016 VSS.n135 15.5561
R4065 VSS.n1027 VSS.n135 15.5561
R4066 VSS.n1027 VSS.n146 15.5561
R4067 VSS.n931 VSS.n146 15.5561
R4068 VSS.n931 VSS.n157 15.5561
R4069 VSS.n1038 VSS.n157 15.5561
R4070 VSS.n1038 VSS.n167 15.5561
R4071 VSS.n1047 VSS.n167 15.5561
R4072 VSS.n1048 VSS.n1047 15.5561
R4073 VSS.n244 VSS.n243 15.5561
R4074 VSS.n248 VSS.n247 15.5561
R4075 VSS.n250 VSS.n249 15.5561
R4076 VSS.n254 VSS.n253 15.5561
R4077 VSS.n256 VSS.n255 15.5561
R4078 VSS.n260 VSS.n259 15.5561
R4079 VSS.n262 VSS.n261 15.5561
R4080 VSS.n266 VSS.n265 15.5561
R4081 VSS.n268 VSS.n267 15.5561
R4082 VSS.n272 VSS.n271 15.5561
R4083 VSS.n274 VSS.n273 15.5561
R4084 VSS.n278 VSS.n277 15.5561
R4085 VSS.n280 VSS.n279 15.5561
R4086 VSS.n284 VSS.n283 15.5561
R4087 VSS.n286 VSS.n285 15.5561
R4088 VSS.n290 VSS.n289 15.5561
R4089 VSS.n292 VSS.n291 15.5561
R4090 VSS.n296 VSS.n295 15.5561
R4091 VSS.n298 VSS.n297 15.5561
R4092 VSS.n302 VSS.n301 15.5561
R4093 VSS.n304 VSS.n303 15.5561
R4094 VSS.n1069 VSS.n1068 15.5561
R4095 VSS.n1071 VSS.n1070 15.5561
R4096 VSS.n1290 VSS.n206 15.5561
R4097 VSS.n1281 VSS.n239 15.5561
R4098 VSS.n1146 VSS.n1145 15.5561
R4099 VSS.n1148 VSS.n1147 15.5561
R4100 VSS.n1152 VSS.n1151 15.5561
R4101 VSS.n1154 VSS.n1153 15.5561
R4102 VSS.n1158 VSS.n1157 15.5561
R4103 VSS.n1160 VSS.n1159 15.5561
R4104 VSS.n1164 VSS.n1163 15.5561
R4105 VSS.n1166 VSS.n1165 15.5561
R4106 VSS.n1170 VSS.n1169 15.5561
R4107 VSS.n1172 VSS.n1171 15.5561
R4108 VSS.n1176 VSS.n1175 15.5561
R4109 VSS.n1178 VSS.n1177 15.5561
R4110 VSS.n1182 VSS.n1181 15.5561
R4111 VSS.n1184 VSS.n1183 15.5561
R4112 VSS.n1188 VSS.n1187 15.5561
R4113 VSS.n1190 VSS.n1189 15.5561
R4114 VSS.n1194 VSS.n1193 15.5561
R4115 VSS.n1196 VSS.n1195 15.5561
R4116 VSS.n1200 VSS.n1199 15.5561
R4117 VSS.n1202 VSS.n1201 15.5561
R4118 VSS.n1206 VSS.n1205 15.5561
R4119 VSS.n1208 VSS.n1207 15.5561
R4120 VSS.n1210 VSS.n212 15.5561
R4121 VSS.n1447 VSS.n4 14.9553
R4122 VSS.n1381 VSS.n1380 14.9553
R4123 VSS.n316 VSS.n315 14.4671
R4124 VSS.n402 VSS.n360 14.2758
R4125 VSS.n1365 VSS.n48 14.2758
R4126 VSS.n92 VSS.n84 14.2758
R4127 VSS.n1317 VSS.n137 14.2758
R4128 VSS.n1299 VSS.n169 14.2758
R4129 VSS.n974 VSS.n973 14.1851
R4130 VSS.n930 VSS.n929 14.1851
R4131 VSS.n484 VSS.n169 13.32
R4132 VSS.n781 VSS.n657 12.5005
R4133 VSS.n783 VSS.n782 12.5005
R4134 VSS.n778 VSS.n656 12.5005
R4135 VSS.n776 VSS.n775 12.5005
R4136 VSS.n774 VSS.n658 12.5005
R4137 VSS.n765 VSS.n659 12.5005
R4138 VSS.n766 VSS.n661 12.5005
R4139 VSS.n768 VSS.n767 12.5005
R4140 VSS.n764 VSS.n660 12.5005
R4141 VSS.n763 VSS.n762 12.5005
R4142 VSS.n761 VSS.n760 12.5005
R4143 VSS.n759 VSS.n758 12.5005
R4144 VSS.n757 VSS.n664 12.5005
R4145 VSS.n756 VSS.n755 12.5005
R4146 VSS.n753 VSS.n665 12.5005
R4147 VSS.n752 VSS.n751 12.5005
R4148 VSS.n750 VSS.n749 12.5005
R4149 VSS.n748 VSS.n667 12.5005
R4150 VSS.n747 VSS.n746 12.5005
R4151 VSS.n736 VSS.n669 12.5005
R4152 VSS.n738 VSS.n737 12.5005
R4153 VSS.n735 VSS.n671 12.5005
R4154 VSS.n734 VSS.n733 12.5005
R4155 VSS.n732 VSS.n672 12.5005
R4156 VSS.n722 VSS.n673 12.5005
R4157 VSS.n723 VSS.n716 12.5005
R4158 VSS.n726 VSS.n725 12.5005
R4159 VSS.n721 VSS.n715 12.5005
R4160 VSS.n720 VSS.n719 12.5005
R4161 VSS.n794 VSS.n793 12.5005
R4162 VSS.n795 VSS.n649 12.5005
R4163 VSS.n797 VSS.n796 12.5005
R4164 VSS.n799 VSS.n798 12.5005
R4165 VSS.n800 VSS.n647 12.5005
R4166 VSS.n802 VSS.n801 12.5005
R4167 VSS.n803 VSS.n646 12.5005
R4168 VSS.n805 VSS.n804 12.5005
R4169 VSS.n806 VSS.n644 12.5005
R4170 VSS.n808 VSS.n807 12.5005
R4171 VSS.n809 VSS.n643 12.5005
R4172 VSS.n811 VSS.n810 12.5005
R4173 VSS.n812 VSS.n642 12.5005
R4174 VSS.n815 VSS.n814 12.5005
R4175 VSS.n816 VSS.n641 12.5005
R4176 VSS.n684 VSS.n640 12.5005
R4177 VSS.n687 VSS.n686 12.5005
R4178 VSS.n688 VSS.n683 12.5005
R4179 VSS.n690 VSS.n689 12.5005
R4180 VSS.n692 VSS.n691 12.5005
R4181 VSS.n693 VSS.n681 12.5005
R4182 VSS.n695 VSS.n694 12.5005
R4183 VSS.n696 VSS.n680 12.5005
R4184 VSS.n698 VSS.n697 12.5005
R4185 VSS.n699 VSS.n678 12.5005
R4186 VSS.n701 VSS.n700 12.5005
R4187 VSS.n702 VSS.n677 12.5005
R4188 VSS.n704 VSS.n703 12.5005
R4189 VSS.n705 VSS.n676 12.5005
R4190 VSS.n1441 VSS.n1440 12.5005
R4191 VSS.n8 VSS.n7 12.5005
R4192 VSS.n1432 VSS.n11 12.5005
R4193 VSS.n1434 VSS.n1433 12.5005
R4194 VSS.n1429 VSS.n10 12.5005
R4195 VSS.n1427 VSS.n1426 12.5005
R4196 VSS.n1425 VSS.n13 12.5005
R4197 VSS.n1415 VSS.n14 12.5005
R4198 VSS.n1417 VSS.n17 12.5005
R4199 VSS.n1419 VSS.n1418 12.5005
R4200 VSS.n1413 VSS.n16 12.5005
R4201 VSS.n1412 VSS.n1411 12.5005
R4202 VSS.n1410 VSS.n1409 12.5005
R4203 VSS.n1408 VSS.n1407 12.5005
R4204 VSS.n1406 VSS.n21 12.5005
R4205 VSS.n1405 VSS.n1404 12.5005
R4206 VSS.n1401 VSS.n1400 12.5005
R4207 VSS.n1399 VSS.n23 12.5005
R4208 VSS.n1398 VSS.n1397 12.5005
R4209 VSS.n1394 VSS.n24 12.5005
R4210 VSS.n1041 VSS.n927 12.5005
R4211 VSS.n1034 VSS.n926 12.5005
R4212 VSS.n1036 VSS.n1035 12.5005
R4213 VSS.n1032 VSS.n933 12.5005
R4214 VSS.n1031 VSS.n1030 12.5005
R4215 VSS.n1026 VSS.n935 12.5005
R4216 VSS.n1025 VSS.n1024 12.5005
R4217 VSS.n1021 VSS.n938 12.5005
R4218 VSS.n1020 VSS.n1019 12.5005
R4219 VSS.n1010 VSS.n941 12.5005
R4220 VSS.n1012 VSS.n1011 12.5005
R4221 VSS.n1009 VSS.n1008 12.5005
R4222 VSS.n1007 VSS.n946 12.5005
R4223 VSS.n953 VSS.n947 12.5005
R4224 VSS.n1002 VSS.n954 12.5005
R4225 VSS.n958 VSS.n950 12.5005
R4226 VSS.n990 VSS.n960 12.5005
R4227 VSS.n983 VSS.n956 12.5005
R4228 VSS.n985 VSS.n984 12.5005
R4229 VSS.n981 VSS.n963 12.5005
R4230 VSS.n980 VSS.n979 12.5005
R4231 VSS.n975 VSS.n965 12.5005
R4232 VSS.n779 VSS.t28 12.1498
R4233 VSS.n718 VSS.t46 12.1498
R4234 VSS.n849 VSS.t2 12.1268
R4235 VSS.n916 VSS.t20 12.1268
R4236 VSS.n1045 VSS.n1044 12.1268
R4237 VSS.n966 VSS.n29 12.1268
R4238 VSS.n787 VSS.t21 12.0353
R4239 VSS.n713 VSS.t24 12.0353
R4240 VSS.n1394 VSS.n1393 9.95036
R4241 VSS.n1443 VSS.n1441 9.95036
R4242 VSS.n699 VSS.n698 9.86111
R4243 VSS.n694 VSS.n693 9.86111
R4244 VSS.n806 VSS.n805 9.86111
R4245 VSS.n801 VSS.n800 9.86111
R4246 VSS.n722 VSS.n672 9.86111
R4247 VSS.n737 VSS.n735 9.86111
R4248 VSS.n767 VSS.n764 9.86111
R4249 VSS.n765 VSS.n658 9.86111
R4250 VSS.n1011 VSS.n1009 9.86111
R4251 VSS.n1418 VSS.n1413 9.86111
R4252 VSS.n1390 VSS.n1389 9.8285
R4253 VSS.n1445 VSS.n6 9.8285
R4254 VSS.n954 VSS.n953 9.55788
R4255 VSS.n1021 VSS.n1020 9.55788
R4256 VSS.n1409 VSS.n1408 9.55788
R4257 VSS.n1415 VSS.n13 9.55788
R4258 VSS.n704 VSS.n677 8.95142
R4259 VSS.n689 VSS.n688 8.95142
R4260 VSS.n811 VSS.n643 8.95142
R4261 VSS.n796 VSS.n795 8.95142
R4262 VSS.n725 VSS.n721 8.95142
R4263 VSS.n748 VSS.n747 8.95142
R4264 VSS.n760 VSS.n759 8.95142
R4265 VSS.n782 VSS.n778 8.95142
R4266 VSS.n743 VSS.n665 8.63668
R4267 VSS.n848 VSS.n847 8.63568
R4268 VSS.n844 VSS.n843 8.63568
R4269 VSS.n840 VSS.n816 8.63568
R4270 VSS.n837 VSS.n836 8.63568
R4271 VSS.n833 VSS.n832 8.63568
R4272 VSS.n1043 VSS.n1042 8.63568
R4273 VSS.n996 VSS.n942 8.63568
R4274 VSS.n1001 VSS.n1000 8.63568
R4275 VSS.n968 VSS.n967 8.63568
R4276 VSS.n1439 VSS.n1438 8.63568
R4277 VSS.n1424 VSS.n1423 8.63568
R4278 VSS.n1383 VSS.n20 8.63568
R4279 VSS.n1388 VSS.n1387 8.63568
R4280 VSS.n773 VSS.n772 8.59884
R4281 VSS.n742 VSS.n663 8.59884
R4282 VSS.n745 VSS.n744 8.59884
R4283 VSS.n731 VSS.n730 8.59884
R4284 VSS.n846 VSS.n845 8.59884
R4285 VSS.n842 VSS.n841 8.59884
R4286 VSS.n839 VSS.n838 8.59884
R4287 VSS.n835 VSS.n834 8.59884
R4288 VSS.n994 VSS.n936 8.59884
R4289 VSS.n998 VSS.n945 8.59884
R4290 VSS.n992 VSS.n991 8.59884
R4291 VSS.n1436 VSS.n1435 8.59884
R4292 VSS.n1421 VSS.n1420 8.59884
R4293 VSS.n1385 VSS.n22 8.59884
R4294 VSS.n980 VSS.n965 8.34496
R4295 VSS.n983 VSS.n960 8.34496
R4296 VSS.n1031 VSS.n935 8.34496
R4297 VSS.n1034 VSS.n927 8.34496
R4298 VSS.n1404 VSS.n1401 8.34496
R4299 VSS.n1433 VSS.n1429 8.34496
R4300 VSS.n684 VSS.n641 7.7385
R4301 VSS.n814 VSS.n641 7.7385
R4302 VSS.n753 VSS.n752 7.7385
R4303 VSS.n755 VSS.n753 7.7385
R4304 VSS.n378 VSS.n377 7.39502
R4305 VSS.n481 VSS.n334 7.39502
R4306 VSS.n481 VSS.n480 7.39502
R4307 VSS.n377 VSS.n369 7.39502
R4308 VSS.n1143 VSS.n1142 7.2529
R4309 VSS.n1279 VSS.n1143 7.2529
R4310 VSS.n1287 VSS.n1286 7.16339
R4311 VSS.n1288 VSS.n1287 7.16339
R4312 VSS.n981 VSS.n980 7.13204
R4313 VSS.n984 VSS.n983 7.13204
R4314 VSS.n1032 VSS.n1031 7.13204
R4315 VSS.n1035 VSS.n1034 7.13204
R4316 VSS.n1397 VSS.n1394 7.13204
R4317 VSS.n1401 VSS.n23 7.13204
R4318 VSS.n1433 VSS.n1432 7.13204
R4319 VSS.n1441 VSS.n7 7.13204
R4320 VSS.n705 VSS.n704 6.52558
R4321 VSS.n688 VSS.n687 6.52558
R4322 VSS.n812 VSS.n811 6.52558
R4323 VSS.n795 VSS.n794 6.52558
R4324 VSS.n721 VSS.n720 6.52558
R4325 VSS.n749 VSS.n748 6.52558
R4326 VSS.n759 VSS.n664 6.52558
R4327 VSS.n782 VSS.n781 6.52558
R4328 VSS.n1057 VSS.n1 6.32942
R4329 VSS.n53 VSS.n28 6.32942
R4330 VSS.n1452 VSS.n1 6.30962
R4331 VSS.n1375 VSS.n28 6.30962
R4332 VSS.n785 VSS.n655 6.3005
R4333 VSS.n771 VSS.n770 6.3005
R4334 VSS.n741 VSS.n740 6.3005
R4335 VSS.n729 VSS.n728 6.3005
R4336 VSS.n1063 VSS.n308 6.1873
R4337 VSS.n625 VSS.n624 6.1873
R4338 VSS.n917 VSS.n625 6.1873
R4339 VSS.n1064 VSS.n1063 6.1693
R4340 VSS.n958 VSS.n954 5.91912
R4341 VSS.n1024 VSS.n1021 5.91912
R4342 VSS.n1408 VSS.n21 5.91912
R4343 VSS.n1427 VSS.n13 5.91912
R4344 VSS.n1444 VSS.n1443 5.8218
R4345 VSS.n1393 VSS.n1391 5.8218
R4346 VSS.n1065 VSS.n306 5.7623
R4347 VSS.n700 VSS.n699 5.61588
R4348 VSS.n698 VSS.n680 5.61588
R4349 VSS.n694 VSS.n680 5.61588
R4350 VSS.n693 VSS.n692 5.61588
R4351 VSS.n807 VSS.n806 5.61588
R4352 VSS.n805 VSS.n646 5.61588
R4353 VSS.n801 VSS.n646 5.61588
R4354 VSS.n800 VSS.n799 5.61588
R4355 VSS.n723 VSS.n722 5.61588
R4356 VSS.n734 VSS.n672 5.61588
R4357 VSS.n735 VSS.n734 5.61588
R4358 VSS.n737 VSS.n736 5.61588
R4359 VSS.n764 VSS.n763 5.61588
R4360 VSS.n767 VSS.n766 5.61588
R4361 VSS.n766 VSS.n765 5.61588
R4362 VSS.n776 VSS.n658 5.61588
R4363 VSS.n1009 VSS.n946 5.61588
R4364 VSS.n1011 VSS.n1010 5.61588
R4365 VSS.n1413 VSS.n1412 5.61588
R4366 VSS.n1418 VSS.n1417 5.61588
R4367 VSS.n1065 VSS.n1064 5.4941
R4368 VSS.n1040 VSS.n167 5.2005
R4369 VSS.n1299 VSS.n167 5.2005
R4370 VSS.n1039 VSS.n1038 5.2005
R4371 VSS.n1038 VSS.n159 5.2005
R4372 VSS.n1037 VSS.n157 5.2005
R4373 VSS.n1305 VSS.n157 5.2005
R4374 VSS.n932 VSS.n931 5.2005
R4375 VSS.n931 VSS.n148 5.2005
R4376 VSS.n1029 VSS.n146 5.2005
R4377 VSS.n1311 VSS.n146 5.2005
R4378 VSS.n1028 VSS.n1027 5.2005
R4379 VSS.n1027 VSS.n145 5.2005
R4380 VSS.n937 VSS.n135 5.2005
R4381 VSS.n1317 VSS.n135 5.2005
R4382 VSS.n1017 VSS.n1016 5.2005
R4383 VSS.n1016 VSS.n127 5.2005
R4384 VSS.n1018 VSS.n125 5.2005
R4385 VSS.n1323 VSS.n125 5.2005
R4386 VSS.n1015 VSS.n1014 5.2005
R4387 VSS.n1014 VSS.n116 5.2005
R4388 VSS.n1013 VSS.n114 5.2005
R4389 VSS.n1329 VSS.n114 5.2005
R4390 VSS.n944 VSS.n943 5.2005
R4391 VSS.n943 VSS.n106 5.2005
R4392 VSS.n1006 VSS.n104 5.2005
R4393 VSS.n1335 VSS.n104 5.2005
R4394 VSS.n1005 VSS.n1004 5.2005
R4395 VSS.n1004 VSS.n95 5.2005
R4396 VSS.n1003 VSS.n93 5.2005
R4397 VSS.n1341 VSS.n93 5.2005
R4398 VSS.n949 VSS.n948 5.2005
R4399 VSS.n948 VSS.n92 5.2005
R4400 VSS.n989 VSS.n82 5.2005
R4401 VSS.n1347 VSS.n82 5.2005
R4402 VSS.n988 VSS.n987 5.2005
R4403 VSS.n987 VSS.n74 5.2005
R4404 VSS.n986 VSS.n72 5.2005
R4405 VSS.n1353 VSS.n72 5.2005
R4406 VSS.n962 VSS.n961 5.2005
R4407 VSS.n961 VSS.n63 5.2005
R4408 VSS.n978 VSS.n61 5.2005
R4409 VSS.n1359 VSS.n61 5.2005
R4410 VSS.n977 VSS.n976 5.2005
R4411 VSS.n976 VSS.n60 5.2005
R4412 VSS.n969 VSS.n46 5.2005
R4413 VSS.n1365 VSS.n46 5.2005
R4414 VSS.n32 VSS.n30 5.2005
R4415 VSS.n35 VSS.n32 5.2005
R4416 VSS.n1373 VSS.n1372 5.2005
R4417 VSS.n1372 VSS.n1371 5.2005
R4418 VSS.n1301 VSS.n1300 5.2005
R4419 VSS.n1300 VSS.n1299 5.2005
R4420 VSS.n1302 VSS.n160 5.2005
R4421 VSS.n160 VSS.n159 5.2005
R4422 VSS.n1304 VSS.n1303 5.2005
R4423 VSS.n1305 VSS.n1304 5.2005
R4424 VSS.n144 VSS.n143 5.2005
R4425 VSS.n148 VSS.n144 5.2005
R4426 VSS.n1313 VSS.n1312 5.2005
R4427 VSS.n1312 VSS.n1311 5.2005
R4428 VSS.n1314 VSS.n138 5.2005
R4429 VSS.n145 VSS.n138 5.2005
R4430 VSS.n1316 VSS.n1315 5.2005
R4431 VSS.n1317 VSS.n1316 5.2005
R4432 VSS.n123 VSS.n122 5.2005
R4433 VSS.n127 VSS.n123 5.2005
R4434 VSS.n1325 VSS.n1324 5.2005
R4435 VSS.n1324 VSS.n1323 5.2005
R4436 VSS.n1326 VSS.n117 5.2005
R4437 VSS.n117 VSS.n116 5.2005
R4438 VSS.n1328 VSS.n1327 5.2005
R4439 VSS.n1329 VSS.n1328 5.2005
R4440 VSS.n102 VSS.n101 5.2005
R4441 VSS.n106 VSS.n102 5.2005
R4442 VSS.n1337 VSS.n1336 5.2005
R4443 VSS.n1336 VSS.n1335 5.2005
R4444 VSS.n1338 VSS.n96 5.2005
R4445 VSS.n96 VSS.n95 5.2005
R4446 VSS.n1340 VSS.n1339 5.2005
R4447 VSS.n1341 VSS.n1340 5.2005
R4448 VSS.n81 VSS.n80 5.2005
R4449 VSS.n92 VSS.n81 5.2005
R4450 VSS.n1349 VSS.n1348 5.2005
R4451 VSS.n1348 VSS.n1347 5.2005
R4452 VSS.n1350 VSS.n75 5.2005
R4453 VSS.n75 VSS.n74 5.2005
R4454 VSS.n1352 VSS.n1351 5.2005
R4455 VSS.n1353 VSS.n1352 5.2005
R4456 VSS.n59 VSS.n58 5.2005
R4457 VSS.n63 VSS.n59 5.2005
R4458 VSS.n1361 VSS.n1360 5.2005
R4459 VSS.n1360 VSS.n1359 5.2005
R4460 VSS.n1362 VSS.n50 5.2005
R4461 VSS.n60 VSS.n50 5.2005
R4462 VSS.n1364 VSS.n1363 5.2005
R4463 VSS.n1365 VSS.n1364 5.2005
R4464 VSS.n51 VSS.n49 5.2005
R4465 VSS.n49 VSS.n35 5.2005
R4466 VSS.n52 VSS.n36 5.2005
R4467 VSS.n1371 VSS.n36 5.2005
R4468 VSS.n454 VSS.n168 5.2005
R4469 VSS.n1299 VSS.n168 5.2005
R4470 VSS.n453 VSS.n452 5.2005
R4471 VSS.n452 VSS.n159 5.2005
R4472 VSS.n344 VSS.n158 5.2005
R4473 VSS.n1305 VSS.n158 5.2005
R4474 VSS.n448 VSS.n447 5.2005
R4475 VSS.n447 VSS.n148 5.2005
R4476 VSS.n446 VSS.n147 5.2005
R4477 VSS.n1311 VSS.n147 5.2005
R4478 VSS.n445 VSS.n444 5.2005
R4479 VSS.n444 VSS.n145 5.2005
R4480 VSS.n346 VSS.n136 5.2005
R4481 VSS.n1317 VSS.n136 5.2005
R4482 VSS.n440 VSS.n439 5.2005
R4483 VSS.n439 VSS.n127 5.2005
R4484 VSS.n438 VSS.n126 5.2005
R4485 VSS.n1323 VSS.n126 5.2005
R4486 VSS.n437 VSS.n436 5.2005
R4487 VSS.n436 VSS.n116 5.2005
R4488 VSS.n348 VSS.n115 5.2005
R4489 VSS.n1329 VSS.n115 5.2005
R4490 VSS.n432 VSS.n431 5.2005
R4491 VSS.n431 VSS.n106 5.2005
R4492 VSS.n430 VSS.n105 5.2005
R4493 VSS.n1335 VSS.n105 5.2005
R4494 VSS.n429 VSS.n428 5.2005
R4495 VSS.n428 VSS.n95 5.2005
R4496 VSS.n350 VSS.n94 5.2005
R4497 VSS.n1341 VSS.n94 5.2005
R4498 VSS.n424 VSS.n423 5.2005
R4499 VSS.n423 VSS.n92 5.2005
R4500 VSS.n422 VSS.n83 5.2005
R4501 VSS.n1347 VSS.n83 5.2005
R4502 VSS.n421 VSS.n420 5.2005
R4503 VSS.n420 VSS.n74 5.2005
R4504 VSS.n352 VSS.n73 5.2005
R4505 VSS.n1353 VSS.n73 5.2005
R4506 VSS.n416 VSS.n415 5.2005
R4507 VSS.n415 VSS.n63 5.2005
R4508 VSS.n414 VSS.n62 5.2005
R4509 VSS.n1359 VSS.n62 5.2005
R4510 VSS.n413 VSS.n412 5.2005
R4511 VSS.n412 VSS.n60 5.2005
R4512 VSS.n354 VSS.n47 5.2005
R4513 VSS.n1365 VSS.n47 5.2005
R4514 VSS.n408 VSS.n407 5.2005
R4515 VSS.n407 VSS.n35 5.2005
R4516 VSS.n406 VSS.n34 5.2005
R4517 VSS.n1371 VSS.n34 5.2005
R4518 VSS.n405 VSS.n404 5.2005
R4519 VSS.n404 VSS.n33 5.2005
R4520 VSS.n403 VSS.n356 5.2005
R4521 VSS.n403 VSS.n402 5.2005
R4522 VSS.n390 VSS.n358 5.2005
R4523 VSS.n359 VSS.n358 5.2005
R4524 VSS.n392 VSS.n391 5.2005
R4525 VSS.n393 VSS.n392 5.2005
R4526 VSS.n368 VSS.n367 5.2005
R4527 VSS.n367 VSS.n366 5.2005
R4528 VSS.n384 VSS.n383 5.2005
R4529 VSS.n383 VSS.n382 5.2005
R4530 VSS.n371 VSS.n370 5.2005
R4531 VSS.n374 VSS.n373 5.2005
R4532 VSS.n373 VSS.n372 5.2005
R4533 VSS.n381 VSS.n380 5.2005
R4534 VSS.n382 VSS.n381 5.2005
R4535 VSS.n365 VSS.n364 5.2005
R4536 VSS.n366 VSS.n365 5.2005
R4537 VSS.n395 VSS.n394 5.2005
R4538 VSS.n394 VSS.n393 5.2005
R4539 VSS.n362 VSS.n361 5.2005
R4540 VSS.n361 VSS.n359 5.2005
R4541 VSS.n401 VSS.n400 5.2005
R4542 VSS.n402 VSS.n401 5.2005
R4543 VSS.n39 VSS.n37 5.2005
R4544 VSS.n37 VSS.n33 5.2005
R4545 VSS.n1370 VSS.n1369 5.2005
R4546 VSS.n1371 VSS.n1370 5.2005
R4547 VSS.n1368 VSS.n38 5.2005
R4548 VSS.n38 VSS.n35 5.2005
R4549 VSS.n1367 VSS.n1366 5.2005
R4550 VSS.n1366 VSS.n1365 5.2005
R4551 VSS.n44 VSS.n43 5.2005
R4552 VSS.n60 VSS.n44 5.2005
R4553 VSS.n1358 VSS.n1357 5.2005
R4554 VSS.n1359 VSS.n1358 5.2005
R4555 VSS.n1356 VSS.n64 5.2005
R4556 VSS.n64 VSS.n63 5.2005
R4557 VSS.n1355 VSS.n1354 5.2005
R4558 VSS.n1354 VSS.n1353 5.2005
R4559 VSS.n70 VSS.n69 5.2005
R4560 VSS.n74 VSS.n70 5.2005
R4561 VSS.n1346 VSS.n1345 5.2005
R4562 VSS.n1347 VSS.n1346 5.2005
R4563 VSS.n1344 VSS.n85 5.2005
R4564 VSS.n92 VSS.n85 5.2005
R4565 VSS.n1343 VSS.n1342 5.2005
R4566 VSS.n1342 VSS.n1341 5.2005
R4567 VSS.n91 VSS.n90 5.2005
R4568 VSS.n95 VSS.n91 5.2005
R4569 VSS.n1334 VSS.n1333 5.2005
R4570 VSS.n1335 VSS.n1334 5.2005
R4571 VSS.n1332 VSS.n107 5.2005
R4572 VSS.n107 VSS.n106 5.2005
R4573 VSS.n1331 VSS.n1330 5.2005
R4574 VSS.n1330 VSS.n1329 5.2005
R4575 VSS.n113 VSS.n112 5.2005
R4576 VSS.n116 VSS.n113 5.2005
R4577 VSS.n1322 VSS.n1321 5.2005
R4578 VSS.n1323 VSS.n1322 5.2005
R4579 VSS.n1320 VSS.n128 5.2005
R4580 VSS.n128 VSS.n127 5.2005
R4581 VSS.n1319 VSS.n1318 5.2005
R4582 VSS.n1318 VSS.n1317 5.2005
R4583 VSS.n134 VSS.n133 5.2005
R4584 VSS.n145 VSS.n134 5.2005
R4585 VSS.n1310 VSS.n1309 5.2005
R4586 VSS.n1311 VSS.n1310 5.2005
R4587 VSS.n1308 VSS.n149 5.2005
R4588 VSS.n149 VSS.n148 5.2005
R4589 VSS.n1307 VSS.n1306 5.2005
R4590 VSS.n1306 VSS.n1305 5.2005
R4591 VSS.n155 VSS.n154 5.2005
R4592 VSS.n159 VSS.n155 5.2005
R4593 VSS.n1298 VSS.n1297 5.2005
R4594 VSS.n1299 VSS.n1298 5.2005
R4595 VSS.n1051 VSS.n1050 5.2005
R4596 VSS.n1049 VSS.n1048 5.2005
R4597 VSS.n1047 VSS.n923 5.2005
R4598 VSS.n1047 VSS.n205 5.2005
R4599 VSS.n1059 VSS.n1058 5.2005
R4600 VSS.n1054 VSS.n1053 5.2005
R4601 VSS.n166 VSS.n165 5.2005
R4602 VSS.n213 VSS.n166 5.2005
R4603 VSS.n850 VSS.n309 5.2005
R4604 VSS.n852 VSS.n851 5.2005
R4605 VSS.n854 VSS.n853 5.2005
R4606 VSS.n856 VSS.n855 5.2005
R4607 VSS.n858 VSS.n857 5.2005
R4608 VSS.n860 VSS.n859 5.2005
R4609 VSS.n862 VSS.n861 5.2005
R4610 VSS.n864 VSS.n863 5.2005
R4611 VSS.n866 VSS.n865 5.2005
R4612 VSS.n868 VSS.n867 5.2005
R4613 VSS.n870 VSS.n869 5.2005
R4614 VSS.n872 VSS.n871 5.2005
R4615 VSS.n874 VSS.n873 5.2005
R4616 VSS.n876 VSS.n875 5.2005
R4617 VSS.n878 VSS.n877 5.2005
R4618 VSS.n880 VSS.n879 5.2005
R4619 VSS.n882 VSS.n881 5.2005
R4620 VSS.n884 VSS.n883 5.2005
R4621 VSS.n886 VSS.n885 5.2005
R4622 VSS.n888 VSS.n887 5.2005
R4623 VSS.n890 VSS.n889 5.2005
R4624 VSS.n892 VSS.n891 5.2005
R4625 VSS.n894 VSS.n893 5.2005
R4626 VSS.n896 VSS.n895 5.2005
R4627 VSS.n898 VSS.n897 5.2005
R4628 VSS.n900 VSS.n899 5.2005
R4629 VSS.n902 VSS.n901 5.2005
R4630 VSS.n904 VSS.n903 5.2005
R4631 VSS.n906 VSS.n905 5.2005
R4632 VSS.n908 VSS.n907 5.2005
R4633 VSS.n910 VSS.n909 5.2005
R4634 VSS.n912 VSS.n911 5.2005
R4635 VSS.n914 VSS.n913 5.2005
R4636 VSS.n504 VSS.n503 5.2005
R4637 VSS.n919 VSS.n918 5.2005
R4638 VSS.n920 VSS.n919 5.2005
R4639 VSS.n561 VSS.n310 5.2005
R4640 VSS.n565 VSS.n562 5.2005
R4641 VSS.n567 VSS.n566 5.2005
R4642 VSS.n568 VSS.n555 5.2005
R4643 VSS.n570 VSS.n569 5.2005
R4644 VSS.n572 VSS.n553 5.2005
R4645 VSS.n574 VSS.n573 5.2005
R4646 VSS.n575 VSS.n548 5.2005
R4647 VSS.n577 VSS.n576 5.2005
R4648 VSS.n579 VSS.n546 5.2005
R4649 VSS.n581 VSS.n580 5.2005
R4650 VSS.n582 VSS.n541 5.2005
R4651 VSS.n584 VSS.n583 5.2005
R4652 VSS.n586 VSS.n539 5.2005
R4653 VSS.n588 VSS.n587 5.2005
R4654 VSS.n589 VSS.n534 5.2005
R4655 VSS.n591 VSS.n590 5.2005
R4656 VSS.n593 VSS.n532 5.2005
R4657 VSS.n595 VSS.n594 5.2005
R4658 VSS.n596 VSS.n527 5.2005
R4659 VSS.n598 VSS.n597 5.2005
R4660 VSS.n600 VSS.n525 5.2005
R4661 VSS.n602 VSS.n601 5.2005
R4662 VSS.n603 VSS.n520 5.2005
R4663 VSS.n605 VSS.n604 5.2005
R4664 VSS.n607 VSS.n518 5.2005
R4665 VSS.n609 VSS.n608 5.2005
R4666 VSS.n610 VSS.n513 5.2005
R4667 VSS.n612 VSS.n611 5.2005
R4668 VSS.n614 VSS.n511 5.2005
R4669 VSS.n616 VSS.n615 5.2005
R4670 VSS.n617 VSS.n507 5.2005
R4671 VSS.n619 VSS.n618 5.2005
R4672 VSS.n621 VSS.n506 5.2005
R4673 VSS.n623 VSS.n622 5.2005
R4674 VSS.n622 VSS.n485 5.2005
R4675 VSS.n479 VSS.n311 5.2005
R4676 VSS.n478 VSS.n477 5.2005
R4677 VSS.n475 VSS.n336 5.2005
R4678 VSS.n473 VSS.n472 5.2005
R4679 VSS.n338 VSS.n337 5.2005
R4680 VSS.n467 VSS.n466 5.2005
R4681 VSS.n464 VSS.n340 5.2005
R4682 VSS.n462 VSS.n461 5.2005
R4683 VSS.n342 VSS.n341 5.2005
R4684 VSS.n457 VSS.n456 5.2005
R4685 VSS.n1296 VSS.n170 5.2005
R4686 VSS.n1295 VSS.n1294 5.2005
R4687 VSS.n176 VSS.n175 5.2005
R4688 VSS.n1292 VSS.n176 5.2005
R4689 VSS.n320 VSS.n319 5.2005
R4690 VSS.n322 VSS.n321 5.2005
R4691 VSS.n324 VSS.n323 5.2005
R4692 VSS.n328 VSS.n313 5.2005
R4693 VSS.n330 VSS.n329 5.2005
R4694 VSS.n332 VSS.n331 5.2005
R4695 VSS.n333 VSS.n180 5.2005
R4696 VSS.n1292 VSS.n180 5.2005
R4697 VSS.n1290 VSS.n1289 5.2005
R4698 VSS.n1291 VSS.n1290 5.2005
R4699 VSS.n208 VSS.n206 5.2005
R4700 VSS.n1073 VSS.n1071 5.2005
R4701 VSS.n1074 VSS.n1070 5.2005
R4702 VSS.n1075 VSS.n1069 5.2005
R4703 VSS.n1068 VSS.n305 5.2005
R4704 VSS.n1079 VSS.n304 5.2005
R4705 VSS.n1080 VSS.n303 5.2005
R4706 VSS.n1081 VSS.n302 5.2005
R4707 VSS.n301 VSS.n299 5.2005
R4708 VSS.n1085 VSS.n298 5.2005
R4709 VSS.n1086 VSS.n297 5.2005
R4710 VSS.n1087 VSS.n296 5.2005
R4711 VSS.n295 VSS.n293 5.2005
R4712 VSS.n1091 VSS.n292 5.2005
R4713 VSS.n1092 VSS.n291 5.2005
R4714 VSS.n1093 VSS.n290 5.2005
R4715 VSS.n289 VSS.n287 5.2005
R4716 VSS.n1097 VSS.n286 5.2005
R4717 VSS.n1098 VSS.n285 5.2005
R4718 VSS.n1099 VSS.n284 5.2005
R4719 VSS.n283 VSS.n281 5.2005
R4720 VSS.n1103 VSS.n280 5.2005
R4721 VSS.n1104 VSS.n279 5.2005
R4722 VSS.n1105 VSS.n278 5.2005
R4723 VSS.n277 VSS.n275 5.2005
R4724 VSS.n1109 VSS.n274 5.2005
R4725 VSS.n1110 VSS.n273 5.2005
R4726 VSS.n1111 VSS.n272 5.2005
R4727 VSS.n271 VSS.n269 5.2005
R4728 VSS.n1115 VSS.n268 5.2005
R4729 VSS.n1116 VSS.n267 5.2005
R4730 VSS.n1117 VSS.n266 5.2005
R4731 VSS.n265 VSS.n263 5.2005
R4732 VSS.n1121 VSS.n262 5.2005
R4733 VSS.n1122 VSS.n261 5.2005
R4734 VSS.n1123 VSS.n260 5.2005
R4735 VSS.n259 VSS.n257 5.2005
R4736 VSS.n1127 VSS.n256 5.2005
R4737 VSS.n1128 VSS.n255 5.2005
R4738 VSS.n1129 VSS.n254 5.2005
R4739 VSS.n253 VSS.n251 5.2005
R4740 VSS.n1133 VSS.n250 5.2005
R4741 VSS.n1134 VSS.n249 5.2005
R4742 VSS.n1135 VSS.n248 5.2005
R4743 VSS.n247 VSS.n245 5.2005
R4744 VSS.n1139 VSS.n244 5.2005
R4745 VSS.n1140 VSS.n243 5.2005
R4746 VSS.n1141 VSS.n242 5.2005
R4747 VSS.n1285 VSS.n1284 5.2005
R4748 VSS.n212 VSS.n211 5.2005
R4749 VSS.n1211 VSS.n1210 5.2005
R4750 VSS.n1209 VSS.n1208 5.2005
R4751 VSS.n1215 VSS.n1207 5.2005
R4752 VSS.n1216 VSS.n1206 5.2005
R4753 VSS.n1217 VSS.n1205 5.2005
R4754 VSS.n1203 VSS.n1202 5.2005
R4755 VSS.n1221 VSS.n1201 5.2005
R4756 VSS.n1222 VSS.n1200 5.2005
R4757 VSS.n1223 VSS.n1199 5.2005
R4758 VSS.n1197 VSS.n1196 5.2005
R4759 VSS.n1227 VSS.n1195 5.2005
R4760 VSS.n1228 VSS.n1194 5.2005
R4761 VSS.n1229 VSS.n1193 5.2005
R4762 VSS.n1191 VSS.n1190 5.2005
R4763 VSS.n1233 VSS.n1189 5.2005
R4764 VSS.n1234 VSS.n1188 5.2005
R4765 VSS.n1235 VSS.n1187 5.2005
R4766 VSS.n1185 VSS.n1184 5.2005
R4767 VSS.n1239 VSS.n1183 5.2005
R4768 VSS.n1240 VSS.n1182 5.2005
R4769 VSS.n1241 VSS.n1181 5.2005
R4770 VSS.n1179 VSS.n1178 5.2005
R4771 VSS.n1244 VSS.n1177 5.2005
R4772 VSS.n1245 VSS.n1176 5.2005
R4773 VSS.n1246 VSS.n1175 5.2005
R4774 VSS.n1173 VSS.n1172 5.2005
R4775 VSS.n1250 VSS.n1171 5.2005
R4776 VSS.n1251 VSS.n1170 5.2005
R4777 VSS.n1252 VSS.n1169 5.2005
R4778 VSS.n1167 VSS.n1166 5.2005
R4779 VSS.n1256 VSS.n1165 5.2005
R4780 VSS.n1257 VSS.n1164 5.2005
R4781 VSS.n1258 VSS.n1163 5.2005
R4782 VSS.n1161 VSS.n1160 5.2005
R4783 VSS.n1262 VSS.n1159 5.2005
R4784 VSS.n1263 VSS.n1158 5.2005
R4785 VSS.n1264 VSS.n1157 5.2005
R4786 VSS.n1155 VSS.n1154 5.2005
R4787 VSS.n1268 VSS.n1153 5.2005
R4788 VSS.n1269 VSS.n1152 5.2005
R4789 VSS.n1270 VSS.n1151 5.2005
R4790 VSS.n1149 VSS.n1148 5.2005
R4791 VSS.n1274 VSS.n1147 5.2005
R4792 VSS.n1275 VSS.n1146 5.2005
R4793 VSS.n1276 VSS.n1145 5.2005
R4794 VSS.n240 VSS.n239 5.2005
R4795 VSS.n1281 VSS.n1280 5.2005
R4796 VSS.n1282 VSS.n1281 5.2005
R4797 VSS.n953 VSS.n952 5.05435
R4798 VSS.n1020 VSS.n940 5.05435
R4799 VSS.n1409 VSS.n19 5.05435
R4800 VSS.n1416 VSS.n1415 5.05435
R4801 VSS.n710 VSS.n709 4.96224
R4802 VSS.n791 VSS.n790 4.96224
R4803 VSS.n786 VSS.n785 4.85463
R4804 VSS.n770 VSS.n654 4.85463
R4805 VSS.n740 VSS.n670 4.85463
R4806 VSS.n728 VSS.n714 4.85463
R4807 VSS.n1335 VSS.n103 4.75892
R4808 VSS.n124 VSS.n116 4.75892
R4809 VSS.n1390 VSS.n1382 4.69811
R4810 VSS.n1446 VSS.n1445 4.69811
R4811 VSS.n712 VSS.n711 4.5725
R4812 VSS.n712 VSS.n675 4.5725
R4813 VSS.n788 VSS.n652 4.5725
R4814 VSS.n788 VSS.n653 4.5725
R4815 VSS.n740 VSS.n739 4.5005
R4816 VSS.n770 VSS.n769 4.5005
R4817 VSS.n785 VSS.n784 4.5005
R4818 VSS.n728 VSS.n727 4.5005
R4819 VSS.n790 VSS.n789 4.5005
R4820 VSS.n710 VSS.n674 4.5005
R4821 VSS.n506 VSS.n505 4.5005
R4822 VSS.n618 VSS.n508 4.5005
R4823 VSS.n617 VSS.n509 4.5005
R4824 VSS.n616 VSS.n510 4.5005
R4825 VSS.n514 VSS.n511 4.5005
R4826 VSS.n611 VSS.n515 4.5005
R4827 VSS.n610 VSS.n516 4.5005
R4828 VSS.n609 VSS.n517 4.5005
R4829 VSS.n521 VSS.n518 4.5005
R4830 VSS.n604 VSS.n522 4.5005
R4831 VSS.n603 VSS.n523 4.5005
R4832 VSS.n602 VSS.n524 4.5005
R4833 VSS.n528 VSS.n525 4.5005
R4834 VSS.n597 VSS.n529 4.5005
R4835 VSS.n596 VSS.n530 4.5005
R4836 VSS.n595 VSS.n531 4.5005
R4837 VSS.n535 VSS.n532 4.5005
R4838 VSS.n590 VSS.n536 4.5005
R4839 VSS.n589 VSS.n537 4.5005
R4840 VSS.n588 VSS.n538 4.5005
R4841 VSS.n542 VSS.n539 4.5005
R4842 VSS.n583 VSS.n543 4.5005
R4843 VSS.n582 VSS.n544 4.5005
R4844 VSS.n581 VSS.n545 4.5005
R4845 VSS.n549 VSS.n546 4.5005
R4846 VSS.n576 VSS.n550 4.5005
R4847 VSS.n575 VSS.n551 4.5005
R4848 VSS.n574 VSS.n552 4.5005
R4849 VSS.n556 VSS.n553 4.5005
R4850 VSS.n569 VSS.n557 4.5005
R4851 VSS.n568 VSS.n558 4.5005
R4852 VSS.n567 VSS.n559 4.5005
R4853 VSS.n562 VSS.n560 4.5005
R4854 VSS.n561 VSS.n308 4.5005
R4855 VSS.n624 VSS.n623 4.5005
R4856 VSS.n918 VSS.n917 4.5005
R4857 VSS.n916 VSS.n504 4.5005
R4858 VSS.n915 VSS.n914 4.5005
R4859 VSS.n911 VSS.n626 4.5005
R4860 VSS.n910 VSS.n627 4.5005
R4861 VSS.n907 VSS.n628 4.5005
R4862 VSS.n906 VSS.n629 4.5005
R4863 VSS.n903 VSS.n630 4.5005
R4864 VSS.n902 VSS.n631 4.5005
R4865 VSS.n899 VSS.n632 4.5005
R4866 VSS.n898 VSS.n633 4.5005
R4867 VSS.n895 VSS.n634 4.5005
R4868 VSS.n894 VSS.n635 4.5005
R4869 VSS.n891 VSS.n636 4.5005
R4870 VSS.n890 VSS.n637 4.5005
R4871 VSS.n887 VSS.n638 4.5005
R4872 VSS.n886 VSS.n639 4.5005
R4873 VSS.n883 VSS.n816 4.5005
R4874 VSS.n882 VSS.n817 4.5005
R4875 VSS.n879 VSS.n818 4.5005
R4876 VSS.n878 VSS.n819 4.5005
R4877 VSS.n875 VSS.n820 4.5005
R4878 VSS.n874 VSS.n821 4.5005
R4879 VSS.n871 VSS.n822 4.5005
R4880 VSS.n870 VSS.n823 4.5005
R4881 VSS.n867 VSS.n824 4.5005
R4882 VSS.n866 VSS.n825 4.5005
R4883 VSS.n863 VSS.n826 4.5005
R4884 VSS.n862 VSS.n827 4.5005
R4885 VSS.n859 VSS.n828 4.5005
R4886 VSS.n858 VSS.n829 4.5005
R4887 VSS.n855 VSS.n830 4.5005
R4888 VSS.n854 VSS.n831 4.5005
R4889 VSS.n851 VSS.n849 4.5005
R4890 VSS.n850 VSS.n307 4.5005
R4891 VSS.n378 VSS.n374 4.5005
R4892 VSS.n380 VSS.n379 4.5005
R4893 VSS.n364 VSS.n363 4.5005
R4894 VSS.n396 VSS.n395 4.5005
R4895 VSS.n397 VSS.n362 4.5005
R4896 VSS.n400 VSS.n399 4.5005
R4897 VSS.n398 VSS.n39 4.5005
R4898 VSS.n1369 VSS.n40 4.5005
R4899 VSS.n1368 VSS.n41 4.5005
R4900 VSS.n1367 VSS.n42 4.5005
R4901 VSS.n65 VSS.n43 4.5005
R4902 VSS.n1357 VSS.n66 4.5005
R4903 VSS.n1356 VSS.n67 4.5005
R4904 VSS.n1355 VSS.n68 4.5005
R4905 VSS.n86 VSS.n69 4.5005
R4906 VSS.n1345 VSS.n87 4.5005
R4907 VSS.n1344 VSS.n88 4.5005
R4908 VSS.n1343 VSS.n89 4.5005
R4909 VSS.n108 VSS.n90 4.5005
R4910 VSS.n1333 VSS.n109 4.5005
R4911 VSS.n1332 VSS.n110 4.5005
R4912 VSS.n1331 VSS.n111 4.5005
R4913 VSS.n129 VSS.n112 4.5005
R4914 VSS.n1321 VSS.n130 4.5005
R4915 VSS.n1320 VSS.n131 4.5005
R4916 VSS.n1319 VSS.n132 4.5005
R4917 VSS.n150 VSS.n133 4.5005
R4918 VSS.n1309 VSS.n151 4.5005
R4919 VSS.n1308 VSS.n152 4.5005
R4920 VSS.n1307 VSS.n153 4.5005
R4921 VSS.n171 VSS.n154 4.5005
R4922 VSS.n1297 VSS.n172 4.5005
R4923 VSS.n1296 VSS.n173 4.5005
R4924 VSS.n1295 VSS.n174 4.5005
R4925 VSS.n317 VSS.n175 4.5005
R4926 VSS.n320 VSS.n318 4.5005
R4927 VSS.n321 VSS.n314 4.5005
R4928 VSS.n325 VSS.n324 4.5005
R4929 VSS.n326 VSS.n313 4.5005
R4930 VSS.n330 VSS.n327 4.5005
R4931 VSS.n332 VSS.n312 4.5005
R4932 VSS.n334 VSS.n333 4.5005
R4933 VSS.n385 VSS.n384 4.5005
R4934 VSS.n386 VSS.n368 4.5005
R4935 VSS.n391 VSS.n387 4.5005
R4936 VSS.n390 VSS.n389 4.5005
R4937 VSS.n388 VSS.n356 4.5005
R4938 VSS.n405 VSS.n357 4.5005
R4939 VSS.n406 VSS.n355 4.5005
R4940 VSS.n409 VSS.n408 4.5005
R4941 VSS.n410 VSS.n354 4.5005
R4942 VSS.n413 VSS.n411 4.5005
R4943 VSS.n414 VSS.n353 4.5005
R4944 VSS.n417 VSS.n416 4.5005
R4945 VSS.n418 VSS.n352 4.5005
R4946 VSS.n421 VSS.n419 4.5005
R4947 VSS.n422 VSS.n351 4.5005
R4948 VSS.n425 VSS.n424 4.5005
R4949 VSS.n426 VSS.n350 4.5005
R4950 VSS.n429 VSS.n427 4.5005
R4951 VSS.n430 VSS.n349 4.5005
R4952 VSS.n433 VSS.n432 4.5005
R4953 VSS.n434 VSS.n348 4.5005
R4954 VSS.n437 VSS.n435 4.5005
R4955 VSS.n438 VSS.n347 4.5005
R4956 VSS.n441 VSS.n440 4.5005
R4957 VSS.n442 VSS.n346 4.5005
R4958 VSS.n445 VSS.n443 4.5005
R4959 VSS.n446 VSS.n345 4.5005
R4960 VSS.n449 VSS.n448 4.5005
R4961 VSS.n450 VSS.n344 4.5005
R4962 VSS.n453 VSS.n451 4.5005
R4963 VSS.n454 VSS.n343 4.5005
R4964 VSS.n458 VSS.n457 4.5005
R4965 VSS.n459 VSS.n342 4.5005
R4966 VSS.n461 VSS.n460 4.5005
R4967 VSS.n340 VSS.n339 4.5005
R4968 VSS.n468 VSS.n467 4.5005
R4969 VSS.n469 VSS.n338 4.5005
R4970 VSS.n472 VSS.n471 4.5005
R4971 VSS.n470 VSS.n336 4.5005
R4972 VSS.n478 VSS.n335 4.5005
R4973 VSS.n480 VSS.n479 4.5005
R4974 VSS.n370 VSS.n369 4.5005
R4975 VSS.n54 VSS.n51 4.5005
R4976 VSS.n1363 VSS.n55 4.5005
R4977 VSS.n1362 VSS.n56 4.5005
R4978 VSS.n1361 VSS.n57 4.5005
R4979 VSS.n76 VSS.n58 4.5005
R4980 VSS.n1351 VSS.n77 4.5005
R4981 VSS.n1350 VSS.n78 4.5005
R4982 VSS.n1349 VSS.n79 4.5005
R4983 VSS.n97 VSS.n80 4.5005
R4984 VSS.n1339 VSS.n98 4.5005
R4985 VSS.n1338 VSS.n99 4.5005
R4986 VSS.n1337 VSS.n100 4.5005
R4987 VSS.n118 VSS.n101 4.5005
R4988 VSS.n1327 VSS.n119 4.5005
R4989 VSS.n1326 VSS.n120 4.5005
R4990 VSS.n1325 VSS.n121 4.5005
R4991 VSS.n139 VSS.n122 4.5005
R4992 VSS.n1315 VSS.n140 4.5005
R4993 VSS.n1314 VSS.n141 4.5005
R4994 VSS.n1313 VSS.n142 4.5005
R4995 VSS.n161 VSS.n143 4.5005
R4996 VSS.n1303 VSS.n162 4.5005
R4997 VSS.n1302 VSS.n163 4.5005
R4998 VSS.n1301 VSS.n164 4.5005
R4999 VSS.n1055 VSS.n165 4.5005
R5000 VSS.n1056 VSS.n1054 4.5005
R5001 VSS.n1058 VSS.n1057 4.5005
R5002 VSS.n53 VSS.n52 4.5005
R5003 VSS.n1445 VSS.n1444 4.5005
R5004 VSS.n1391 VSS.n1390 4.5005
R5005 VSS.n970 VSS.n30 4.5005
R5006 VSS.n974 VSS.n969 4.5005
R5007 VSS.n977 VSS.n975 4.5005
R5008 VSS.n979 VSS.n978 4.5005
R5009 VSS.n963 VSS.n962 4.5005
R5010 VSS.n986 VSS.n985 4.5005
R5011 VSS.n988 VSS.n956 4.5005
R5012 VSS.n990 VSS.n989 4.5005
R5013 VSS.n950 VSS.n949 4.5005
R5014 VSS.n1003 VSS.n1002 4.5005
R5015 VSS.n1005 VSS.n947 4.5005
R5016 VSS.n1007 VSS.n1006 4.5005
R5017 VSS.n1008 VSS.n944 4.5005
R5018 VSS.n1013 VSS.n1012 4.5005
R5019 VSS.n1015 VSS.n941 4.5005
R5020 VSS.n1019 VSS.n1018 4.5005
R5021 VSS.n1017 VSS.n938 4.5005
R5022 VSS.n1025 VSS.n937 4.5005
R5023 VSS.n1028 VSS.n1026 4.5005
R5024 VSS.n1030 VSS.n1029 4.5005
R5025 VSS.n933 VSS.n932 4.5005
R5026 VSS.n1037 VSS.n1036 4.5005
R5027 VSS.n1039 VSS.n926 4.5005
R5028 VSS.n1041 VSS.n1040 4.5005
R5029 VSS.n930 VSS.n923 4.5005
R5030 VSS.n1049 VSS.n1046 4.5005
R5031 VSS.n1050 VSS.n0 4.5005
R5032 VSS.n1374 VSS.n1373 4.5005
R5033 VSS.n1140 VSS.n241 4.5005
R5034 VSS.n1139 VSS.n1138 4.5005
R5035 VSS.n1137 VSS.n245 4.5005
R5036 VSS.n1136 VSS.n1135 4.5005
R5037 VSS.n1134 VSS.n246 4.5005
R5038 VSS.n1133 VSS.n1132 4.5005
R5039 VSS.n1131 VSS.n251 4.5005
R5040 VSS.n1130 VSS.n1129 4.5005
R5041 VSS.n1128 VSS.n252 4.5005
R5042 VSS.n1127 VSS.n1126 4.5005
R5043 VSS.n1125 VSS.n257 4.5005
R5044 VSS.n1124 VSS.n1123 4.5005
R5045 VSS.n1122 VSS.n258 4.5005
R5046 VSS.n1121 VSS.n1120 4.5005
R5047 VSS.n1119 VSS.n263 4.5005
R5048 VSS.n1118 VSS.n1117 4.5005
R5049 VSS.n1116 VSS.n264 4.5005
R5050 VSS.n1115 VSS.n1114 4.5005
R5051 VSS.n1113 VSS.n269 4.5005
R5052 VSS.n1112 VSS.n1111 4.5005
R5053 VSS.n1110 VSS.n270 4.5005
R5054 VSS.n1109 VSS.n1108 4.5005
R5055 VSS.n1107 VSS.n275 4.5005
R5056 VSS.n1106 VSS.n1105 4.5005
R5057 VSS.n1104 VSS.n276 4.5005
R5058 VSS.n1103 VSS.n1102 4.5005
R5059 VSS.n1101 VSS.n281 4.5005
R5060 VSS.n1100 VSS.n1099 4.5005
R5061 VSS.n1098 VSS.n282 4.5005
R5062 VSS.n1097 VSS.n1096 4.5005
R5063 VSS.n1095 VSS.n287 4.5005
R5064 VSS.n1094 VSS.n1093 4.5005
R5065 VSS.n1092 VSS.n288 4.5005
R5066 VSS.n1091 VSS.n1090 4.5005
R5067 VSS.n1089 VSS.n293 4.5005
R5068 VSS.n1088 VSS.n1087 4.5005
R5069 VSS.n1086 VSS.n294 4.5005
R5070 VSS.n1085 VSS.n1084 4.5005
R5071 VSS.n1083 VSS.n299 4.5005
R5072 VSS.n1082 VSS.n1081 4.5005
R5073 VSS.n1066 VSS.n1065 4.5005
R5074 VSS.n1080 VSS.n300 4.5005
R5075 VSS.n1079 VSS.n1078 4.5005
R5076 VSS.n1077 VSS.n305 4.5005
R5077 VSS.n1076 VSS.n1075 4.5005
R5078 VSS.n1074 VSS.n1067 4.5005
R5079 VSS.n1073 VSS.n1072 4.5005
R5080 VSS.n209 VSS.n208 4.5005
R5081 VSS.n1289 VSS.n1288 4.5005
R5082 VSS.n1142 VSS.n1141 4.5005
R5083 VSS.n1278 VSS.n240 4.5005
R5084 VSS.n1277 VSS.n1276 4.5005
R5085 VSS.n1275 VSS.n1144 4.5005
R5086 VSS.n1274 VSS.n1273 4.5005
R5087 VSS.n1272 VSS.n1149 4.5005
R5088 VSS.n1271 VSS.n1270 4.5005
R5089 VSS.n1269 VSS.n1150 4.5005
R5090 VSS.n1268 VSS.n1267 4.5005
R5091 VSS.n1266 VSS.n1155 4.5005
R5092 VSS.n1265 VSS.n1264 4.5005
R5093 VSS.n1263 VSS.n1156 4.5005
R5094 VSS.n1262 VSS.n1261 4.5005
R5095 VSS.n1260 VSS.n1161 4.5005
R5096 VSS.n1259 VSS.n1258 4.5005
R5097 VSS.n1257 VSS.n1162 4.5005
R5098 VSS.n1256 VSS.n1255 4.5005
R5099 VSS.n1254 VSS.n1167 4.5005
R5100 VSS.n1253 VSS.n1252 4.5005
R5101 VSS.n1251 VSS.n1168 4.5005
R5102 VSS.n1250 VSS.n1249 4.5005
R5103 VSS.n1248 VSS.n1173 4.5005
R5104 VSS.n1247 VSS.n1246 4.5005
R5105 VSS.n1245 VSS.n1174 4.5005
R5106 VSS.n1244 VSS 4.5005
R5107 VSS.n1243 VSS.n1179 4.5005
R5108 VSS.n1242 VSS.n1241 4.5005
R5109 VSS.n1240 VSS.n1180 4.5005
R5110 VSS.n1239 VSS.n1238 4.5005
R5111 VSS.n1237 VSS.n1185 4.5005
R5112 VSS.n1236 VSS.n1235 4.5005
R5113 VSS.n1234 VSS.n1186 4.5005
R5114 VSS.n1233 VSS.n1232 4.5005
R5115 VSS.n1231 VSS.n1191 4.5005
R5116 VSS.n1230 VSS.n1229 4.5005
R5117 VSS.n1228 VSS.n1192 4.5005
R5118 VSS.n1227 VSS.n1226 4.5005
R5119 VSS.n1225 VSS.n1197 4.5005
R5120 VSS.n1224 VSS.n1223 4.5005
R5121 VSS.n1222 VSS.n1198 4.5005
R5122 VSS.n1221 VSS.n1220 4.5005
R5123 VSS.n1219 VSS.n1203 4.5005
R5124 VSS.n1218 VSS.n1217 4.5005
R5125 VSS.n1216 VSS.n1204 4.5005
R5126 VSS.n1215 VSS.n1214 4.5005
R5127 VSS.n1213 VSS.n1209 4.5005
R5128 VSS.n1212 VSS.n1211 4.5005
R5129 VSS.n211 VSS.n210 4.5005
R5130 VSS.n1286 VSS.n1285 4.5005
R5131 VSS.n1280 VSS.n1279 4.5005
R5132 VSS.n679 VSS.n677 4.49281
R5133 VSS.n689 VSS.n682 4.49281
R5134 VSS.n645 VSS.n643 4.49281
R5135 VSS.n796 VSS.n648 4.49281
R5136 VSS.n725 VSS.n724 4.49281
R5137 VSS.n747 VSS.n668 4.49281
R5138 VSS.n760 VSS.n662 4.49281
R5139 VSS.n778 VSS.n777 4.49281
R5140 VSS.n921 VSS.n484 4.05241
R5141 VSS.n375 VSS.n371 4.05141
R5142 VSS.n973 VSS.n965 3.93127
R5143 VSS.n960 VSS.n959 3.93127
R5144 VSS.n1023 VSS.n935 3.93127
R5145 VSS.n929 VSS.n927 3.93127
R5146 VSS.n1404 VSS.n1403 3.93127
R5147 VSS.n1429 VSS.n1428 3.93127
R5148 VSS.n729 VSS.t46 3.5285
R5149 VSS.t44 VSS.n729 3.5285
R5150 VSS.t30 VSS.n655 3.5285
R5151 VSS.t28 VSS.n655 3.5285
R5152 VSS.n772 VSS.t32 3.5285
R5153 VSS.n772 VSS.t30 3.5285
R5154 VSS.n771 VSS.t34 3.5285
R5155 VSS.t32 VSS.n771 3.5285
R5156 VSS.t36 VSS.n742 3.5285
R5157 VSS.n742 VSS.t34 3.5285
R5158 VSS.t38 VSS.n743 3.5285
R5159 VSS.n743 VSS.t36 3.5285
R5160 VSS.n744 VSS.t40 3.5285
R5161 VSS.n744 VSS.t38 3.5285
R5162 VSS.n741 VSS.t42 3.5285
R5163 VSS.t40 VSS.n741 3.5285
R5164 VSS.n730 VSS.t44 3.5285
R5165 VSS.n730 VSS.t42 3.5285
R5166 VSS.n848 VSS.t4 3.5285
R5167 VSS.t2 VSS.n848 3.5285
R5168 VSS.n846 VSS.t6 3.5285
R5169 VSS.t4 VSS.n846 3.5285
R5170 VSS.n844 VSS.t8 3.5285
R5171 VSS.t6 VSS.n844 3.5285
R5172 VSS.n842 VSS.t10 3.5285
R5173 VSS.t8 VSS.n842 3.5285
R5174 VSS.n840 VSS.t12 3.5285
R5175 VSS.t10 VSS.n840 3.5285
R5176 VSS.n839 VSS.t14 3.5285
R5177 VSS.t12 VSS.n839 3.5285
R5178 VSS.n837 VSS.t16 3.5285
R5179 VSS.t14 VSS.n837 3.5285
R5180 VSS.n835 VSS.t18 3.5285
R5181 VSS.t16 VSS.n835 3.5285
R5182 VSS.n833 VSS.t20 3.5285
R5183 VSS.t18 VSS.n833 3.5285
R5184 VSS.n1043 VSS.n925 3.5285
R5185 VSS.n1044 VSS.n1043 3.5285
R5186 VSS.n995 VSS.n994 3.5285
R5187 VSS.n994 VSS.n925 3.5285
R5188 VSS.n997 VSS.n996 3.5285
R5189 VSS.n996 VSS.n995 3.5285
R5190 VSS.n999 VSS.n998 3.5285
R5191 VSS.n998 VSS.n997 3.5285
R5192 VSS.n1000 VSS.n993 3.5285
R5193 VSS.n1000 VSS.n999 3.5285
R5194 VSS.n992 VSS.n955 3.5285
R5195 VSS.n993 VSS.n992 3.5285
R5196 VSS.n967 VSS.n966 3.5285
R5197 VSS.n967 VSS.n955 3.5285
R5198 VSS.n1438 VSS.n1437 3.5285
R5199 VSS.n1438 VSS.n6 3.5285
R5200 VSS.n1436 VSS.n9 3.5285
R5201 VSS.n1437 VSS.n1436 3.5285
R5202 VSS.n1423 VSS.n1422 3.5285
R5203 VSS.n1423 VSS.n9 3.5285
R5204 VSS.n1421 VSS.n15 3.5285
R5205 VSS.n1422 VSS.n1421 3.5285
R5206 VSS.n1384 VSS.n1383 3.5285
R5207 VSS.n1383 VSS.n15 3.5285
R5208 VSS.n1386 VSS.n1385 3.5285
R5209 VSS.n1385 VSS.n1384 3.5285
R5210 VSS.n1389 VSS.n1388 3.5285
R5211 VSS.n1388 VSS.n1386 3.5285
R5212 VSS.n685 VSS.n684 3.36973
R5213 VSS.n814 VSS.n813 3.36973
R5214 VSS.n752 VSS.n666 3.36973
R5215 VSS.n755 VSS.n754 3.36973
R5216 VSS.n620 VSS.n619 3.11744
R5217 VSS.n615 VSS.n512 3.11744
R5218 VSS.n613 VSS.n612 3.11744
R5219 VSS.n608 VSS.n519 3.11744
R5220 VSS.n606 VSS.n605 3.11744
R5221 VSS.n601 VSS.n526 3.11744
R5222 VSS.n599 VSS.n598 3.11744
R5223 VSS.n594 VSS.n533 3.11744
R5224 VSS.n592 VSS.n591 3.11744
R5225 VSS.n587 VSS.n540 3.11744
R5226 VSS.n585 VSS.n584 3.11744
R5227 VSS.n580 VSS.n547 3.11744
R5228 VSS.n578 VSS.n577 3.11744
R5229 VSS.n573 VSS.n554 3.11744
R5230 VSS.n571 VSS.n570 3.11744
R5231 VSS.n566 VSS.n563 3.11744
R5232 VSS.n564 VSS.n310 3.11744
R5233 VSS.n913 VSS.n502 3.11744
R5234 VSS.n909 VSS.n501 3.11744
R5235 VSS.n905 VSS.n500 3.11744
R5236 VSS.n901 VSS.n499 3.11744
R5237 VSS.n897 VSS.n498 3.11744
R5238 VSS.n893 VSS.n497 3.11744
R5239 VSS.n889 VSS.n496 3.11744
R5240 VSS.n885 VSS.n495 3.11744
R5241 VSS.n881 VSS.n494 3.11744
R5242 VSS.n877 VSS.n493 3.11744
R5243 VSS.n873 VSS.n492 3.11744
R5244 VSS.n869 VSS.n491 3.11744
R5245 VSS.n865 VSS.n490 3.11744
R5246 VSS.n861 VSS.n489 3.11744
R5247 VSS.n857 VSS.n488 3.11744
R5248 VSS.n853 VSS.n487 3.11744
R5249 VSS.n486 VSS.n309 3.11744
R5250 VSS.n1293 VSS.n170 3.11744
R5251 VSS.n319 VSS.n177 3.11744
R5252 VSS.n323 VSS.n178 3.11744
R5253 VSS.n329 VSS.n179 3.11744
R5254 VSS.n455 VSS.n341 3.11744
R5255 VSS.n464 VSS.n463 3.11744
R5256 VSS.n465 VSS.n337 3.11744
R5257 VSS.n475 VSS.n474 3.11744
R5258 VSS.n476 VSS.n311 3.11744
R5259 VSS.n1059 VSS.n1052 3.11744
R5260 VSS.n1051 VSS.n922 3.11744
R5261 VSS.n1048 VSS.n922 3.11744
R5262 VSS.n1053 VSS.n1052 3.11744
R5263 VSS.n852 VSS.n486 3.11744
R5264 VSS.n856 VSS.n487 3.11744
R5265 VSS.n860 VSS.n488 3.11744
R5266 VSS.n864 VSS.n489 3.11744
R5267 VSS.n868 VSS.n490 3.11744
R5268 VSS.n872 VSS.n491 3.11744
R5269 VSS.n876 VSS.n492 3.11744
R5270 VSS.n880 VSS.n493 3.11744
R5271 VSS.n884 VSS.n494 3.11744
R5272 VSS.n888 VSS.n495 3.11744
R5273 VSS.n892 VSS.n496 3.11744
R5274 VSS.n896 VSS.n497 3.11744
R5275 VSS.n900 VSS.n498 3.11744
R5276 VSS.n904 VSS.n499 3.11744
R5277 VSS.n908 VSS.n500 3.11744
R5278 VSS.n912 VSS.n501 3.11744
R5279 VSS.n503 VSS.n502 3.11744
R5280 VSS.n565 VSS.n564 3.11744
R5281 VSS.n563 VSS.n555 3.11744
R5282 VSS.n572 VSS.n571 3.11744
R5283 VSS.n554 VSS.n548 3.11744
R5284 VSS.n579 VSS.n578 3.11744
R5285 VSS.n547 VSS.n541 3.11744
R5286 VSS.n586 VSS.n585 3.11744
R5287 VSS.n540 VSS.n534 3.11744
R5288 VSS.n593 VSS.n592 3.11744
R5289 VSS.n533 VSS.n527 3.11744
R5290 VSS.n600 VSS.n599 3.11744
R5291 VSS.n526 VSS.n520 3.11744
R5292 VSS.n607 VSS.n606 3.11744
R5293 VSS.n519 VSS.n513 3.11744
R5294 VSS.n614 VSS.n613 3.11744
R5295 VSS.n512 VSS.n507 3.11744
R5296 VSS.n621 VSS.n620 3.11744
R5297 VSS.n477 VSS.n476 3.11744
R5298 VSS.n474 VSS.n473 3.11744
R5299 VSS.n466 VSS.n465 3.11744
R5300 VSS.n463 VSS.n462 3.11744
R5301 VSS.n456 VSS.n455 3.11744
R5302 VSS.n1294 VSS.n1293 3.11744
R5303 VSS.n322 VSS.n177 3.11744
R5304 VSS.n328 VSS.n178 3.11744
R5305 VSS.n331 VSS.n179 3.11744
R5306 VSS.n242 VSS.n181 3.11744
R5307 VSS.n244 VSS.n182 3.11744
R5308 VSS.n248 VSS.n183 3.11744
R5309 VSS.n250 VSS.n184 3.11744
R5310 VSS.n254 VSS.n185 3.11744
R5311 VSS.n256 VSS.n186 3.11744
R5312 VSS.n260 VSS.n187 3.11744
R5313 VSS.n262 VSS.n188 3.11744
R5314 VSS.n266 VSS.n189 3.11744
R5315 VSS.n268 VSS.n190 3.11744
R5316 VSS.n272 VSS.n191 3.11744
R5317 VSS.n274 VSS.n192 3.11744
R5318 VSS.n278 VSS.n193 3.11744
R5319 VSS.n280 VSS.n194 3.11744
R5320 VSS.n284 VSS.n195 3.11744
R5321 VSS.n286 VSS.n196 3.11744
R5322 VSS.n290 VSS.n197 3.11744
R5323 VSS.n292 VSS.n198 3.11744
R5324 VSS.n296 VSS.n199 3.11744
R5325 VSS.n298 VSS.n200 3.11744
R5326 VSS.n302 VSS.n201 3.11744
R5327 VSS.n304 VSS.n202 3.11744
R5328 VSS.n1069 VSS.n203 3.11744
R5329 VSS.n1071 VSS.n204 3.11744
R5330 VSS.n206 VSS.n204 3.11744
R5331 VSS.n1070 VSS.n203 3.11744
R5332 VSS.n1068 VSS.n202 3.11744
R5333 VSS.n303 VSS.n201 3.11744
R5334 VSS.n301 VSS.n200 3.11744
R5335 VSS.n297 VSS.n199 3.11744
R5336 VSS.n295 VSS.n198 3.11744
R5337 VSS.n291 VSS.n197 3.11744
R5338 VSS.n289 VSS.n196 3.11744
R5339 VSS.n285 VSS.n195 3.11744
R5340 VSS.n283 VSS.n194 3.11744
R5341 VSS.n279 VSS.n193 3.11744
R5342 VSS.n277 VSS.n192 3.11744
R5343 VSS.n273 VSS.n191 3.11744
R5344 VSS.n271 VSS.n190 3.11744
R5345 VSS.n267 VSS.n189 3.11744
R5346 VSS.n265 VSS.n188 3.11744
R5347 VSS.n261 VSS.n187 3.11744
R5348 VSS.n259 VSS.n186 3.11744
R5349 VSS.n255 VSS.n185 3.11744
R5350 VSS.n253 VSS.n184 3.11744
R5351 VSS.n249 VSS.n183 3.11744
R5352 VSS.n247 VSS.n182 3.11744
R5353 VSS.n243 VSS.n181 3.11744
R5354 VSS.n1145 VSS.n237 3.11744
R5355 VSS.n1147 VSS.n236 3.11744
R5356 VSS.n1151 VSS.n235 3.11744
R5357 VSS.n1153 VSS.n234 3.11744
R5358 VSS.n1157 VSS.n233 3.11744
R5359 VSS.n1159 VSS.n232 3.11744
R5360 VSS.n1163 VSS.n231 3.11744
R5361 VSS.n1165 VSS.n230 3.11744
R5362 VSS.n1169 VSS.n229 3.11744
R5363 VSS.n1171 VSS.n228 3.11744
R5364 VSS.n1175 VSS.n227 3.11744
R5365 VSS.n1177 VSS.n226 3.11744
R5366 VSS.n1181 VSS.n225 3.11744
R5367 VSS.n1183 VSS.n224 3.11744
R5368 VSS.n1187 VSS.n223 3.11744
R5369 VSS.n1189 VSS.n222 3.11744
R5370 VSS.n1193 VSS.n221 3.11744
R5371 VSS.n1195 VSS.n220 3.11744
R5372 VSS.n1199 VSS.n219 3.11744
R5373 VSS.n1201 VSS.n218 3.11744
R5374 VSS.n1205 VSS.n217 3.11744
R5375 VSS.n1207 VSS.n216 3.11744
R5376 VSS.n1210 VSS.n215 3.11744
R5377 VSS.n1284 VSS.n1283 3.11744
R5378 VSS.n1283 VSS.n212 3.11744
R5379 VSS.n1208 VSS.n215 3.11744
R5380 VSS.n1206 VSS.n216 3.11744
R5381 VSS.n1202 VSS.n217 3.11744
R5382 VSS.n1200 VSS.n218 3.11744
R5383 VSS.n1196 VSS.n219 3.11744
R5384 VSS.n1194 VSS.n220 3.11744
R5385 VSS.n1190 VSS.n221 3.11744
R5386 VSS.n1188 VSS.n222 3.11744
R5387 VSS.n1184 VSS.n223 3.11744
R5388 VSS.n1182 VSS.n224 3.11744
R5389 VSS.n1178 VSS.n225 3.11744
R5390 VSS.n1176 VSS.n226 3.11744
R5391 VSS.n1172 VSS.n227 3.11744
R5392 VSS.n1170 VSS.n228 3.11744
R5393 VSS.n1166 VSS.n229 3.11744
R5394 VSS.n1164 VSS.n230 3.11744
R5395 VSS.n1160 VSS.n231 3.11744
R5396 VSS.n1158 VSS.n232 3.11744
R5397 VSS.n1154 VSS.n233 3.11744
R5398 VSS.n1152 VSS.n234 3.11744
R5399 VSS.n1148 VSS.n235 3.11744
R5400 VSS.n1146 VSS.n236 3.11744
R5401 VSS.n239 VSS.n237 3.11744
R5402 VSS.n711 VSS.t25 2.8355
R5403 VSS.t25 VSS.n675 2.8355
R5404 VSS.t23 VSS.n652 2.8355
R5405 VSS.n653 VSS.t23 2.8355
R5406 VSS.n982 VSS.n981 2.80819
R5407 VSS.n984 VSS.n982 2.80819
R5408 VSS.n1033 VSS.n1032 2.80819
R5409 VSS.n1035 VSS.n1033 2.80819
R5410 VSS.n1397 VSS.n1396 2.80819
R5411 VSS.n1396 VSS.n23 2.80819
R5412 VSS.n1432 VSS.n1431 2.80819
R5413 VSS.n1431 VSS.n7 2.80819
R5414 VSS.n1393 VSS.n1392 2.73469
R5415 VSS.n1443 VSS.n1442 2.73469
R5416 VSS.n708 VSS.n675 2.38762
R5417 VSS.n653 VSS.n651 2.38762
R5418 VSS.n1379 VSS.n1378 2.35281
R5419 VSS.n1449 VSS.n1448 2.35281
R5420 VSS.n1451 VSS.n1450 2.27503
R5421 VSS.n1377 VSS.n1376 2.26755
R5422 VSS.n706 VSS.n705 2.24665
R5423 VSS.n687 VSS.n685 2.24665
R5424 VSS.n813 VSS.n812 2.24665
R5425 VSS.n794 VSS.n650 2.24665
R5426 VSS.n720 VSS.n717 2.24665
R5427 VSS.n749 VSS.n666 2.24665
R5428 VSS.n754 VSS.n664 2.24665
R5429 VSS.n781 VSS.n780 2.24665
R5430 VSS.n315 VSS.n306 1.8905
R5431 VSS.n959 VSS.n958 1.68512
R5432 VSS.n1024 VSS.n1023 1.68512
R5433 VSS.n1403 VSS.n21 1.68512
R5434 VSS.n1428 VSS.n1427 1.68512
R5435 VSS.n1449 VSS.n3 1.66246
R5436 VSS.n1378 VSS.n27 1.65213
R5437 VSS.n1378 VSS.n1377 1.3415
R5438 VSS.n1450 VSS.n1449 1.3415
R5439 VSS.n700 VSS.n679 1.12358
R5440 VSS.n692 VSS.n682 1.12358
R5441 VSS.n807 VSS.n645 1.12358
R5442 VSS.n799 VSS.n648 1.12358
R5443 VSS.n724 VSS.n723 1.12358
R5444 VSS.n736 VSS.n668 1.12358
R5445 VSS.n763 VSS.n662 1.12358
R5446 VSS.n777 VSS.n776 1.12358
R5447 VSS.n375 VSS.n372 1.07718
R5448 VSS.n922 VSS.n205 1.04278
R5449 VSS.n1052 VSS.n213 1.04278
R5450 VSS.n920 VSS.n486 1.04278
R5451 VSS.n920 VSS.n487 1.04278
R5452 VSS.n920 VSS.n488 1.04278
R5453 VSS.n920 VSS.n489 1.04278
R5454 VSS.n920 VSS.n490 1.04278
R5455 VSS.n920 VSS.n491 1.04278
R5456 VSS.n920 VSS.n492 1.04278
R5457 VSS.n920 VSS.n493 1.04278
R5458 VSS.n920 VSS.n494 1.04278
R5459 VSS.n920 VSS.n495 1.04278
R5460 VSS.n920 VSS.n496 1.04278
R5461 VSS.n920 VSS.n497 1.04278
R5462 VSS.n920 VSS.n498 1.04278
R5463 VSS.n920 VSS.n499 1.04278
R5464 VSS.n920 VSS.n500 1.04278
R5465 VSS.n920 VSS.n501 1.04278
R5466 VSS.n920 VSS.n502 1.04278
R5467 VSS.n564 VSS.n485 1.04278
R5468 VSS.n563 VSS.n485 1.04278
R5469 VSS.n571 VSS.n485 1.04278
R5470 VSS.n554 VSS.n485 1.04278
R5471 VSS.n578 VSS.n485 1.04278
R5472 VSS.n547 VSS.n485 1.04278
R5473 VSS.n585 VSS.n485 1.04278
R5474 VSS.n540 VSS.n485 1.04278
R5475 VSS.n592 VSS.n485 1.04278
R5476 VSS.n533 VSS.n485 1.04278
R5477 VSS.n599 VSS.n485 1.04278
R5478 VSS.n526 VSS.n485 1.04278
R5479 VSS.n606 VSS.n485 1.04278
R5480 VSS.n519 VSS.n485 1.04278
R5481 VSS.n613 VSS.n485 1.04278
R5482 VSS.n512 VSS.n485 1.04278
R5483 VSS.n620 VSS.n485 1.04278
R5484 VSS.n476 VSS.n214 1.04278
R5485 VSS.n474 VSS.n214 1.04278
R5486 VSS.n465 VSS.n214 1.04278
R5487 VSS.n463 VSS.n214 1.04278
R5488 VSS.n455 VSS.n214 1.04278
R5489 VSS.n1293 VSS.n1292 1.04278
R5490 VSS.n1292 VSS.n177 1.04278
R5491 VSS.n1292 VSS.n178 1.04278
R5492 VSS.n1292 VSS.n179 1.04278
R5493 VSS.n1291 VSS.n204 1.04278
R5494 VSS.n1291 VSS.n203 1.04278
R5495 VSS.n1291 VSS.n202 1.04278
R5496 VSS.n1291 VSS.n201 1.04278
R5497 VSS.n1291 VSS.n200 1.04278
R5498 VSS.n1291 VSS.n199 1.04278
R5499 VSS.n1291 VSS.n198 1.04278
R5500 VSS.n1291 VSS.n197 1.04278
R5501 VSS.n1291 VSS.n196 1.04278
R5502 VSS.n1291 VSS.n195 1.04278
R5503 VSS.n1291 VSS.n194 1.04278
R5504 VSS.n1291 VSS.n193 1.04278
R5505 VSS.n1291 VSS.n192 1.04278
R5506 VSS.n1291 VSS.n191 1.04278
R5507 VSS.n1291 VSS.n190 1.04278
R5508 VSS.n1291 VSS.n189 1.04278
R5509 VSS.n1291 VSS.n188 1.04278
R5510 VSS.n1291 VSS.n187 1.04278
R5511 VSS.n1291 VSS.n186 1.04278
R5512 VSS.n1291 VSS.n185 1.04278
R5513 VSS.n1291 VSS.n184 1.04278
R5514 VSS.n1291 VSS.n183 1.04278
R5515 VSS.n1291 VSS.n182 1.04278
R5516 VSS.n1291 VSS.n181 1.04278
R5517 VSS.n1283 VSS.n1282 1.04278
R5518 VSS.n1282 VSS.n215 1.04278
R5519 VSS.n1282 VSS.n216 1.04278
R5520 VSS.n1282 VSS.n217 1.04278
R5521 VSS.n1282 VSS.n218 1.04278
R5522 VSS.n1282 VSS.n219 1.04278
R5523 VSS.n1282 VSS.n220 1.04278
R5524 VSS.n1282 VSS.n221 1.04278
R5525 VSS.n1282 VSS.n222 1.04278
R5526 VSS.n1282 VSS.n223 1.04278
R5527 VSS.n1282 VSS.n224 1.04278
R5528 VSS.n1282 VSS.n225 1.04278
R5529 VSS.n1282 VSS.n226 1.04278
R5530 VSS.n1282 VSS.n227 1.04278
R5531 VSS.n1282 VSS.n228 1.04278
R5532 VSS.n1282 VSS.n229 1.04278
R5533 VSS.n1282 VSS.n230 1.04278
R5534 VSS.n1282 VSS.n231 1.04278
R5535 VSS.n1282 VSS.n232 1.04278
R5536 VSS.n1282 VSS.n233 1.04278
R5537 VSS.n1282 VSS.n234 1.04278
R5538 VSS.n1282 VSS.n235 1.04278
R5539 VSS.n1282 VSS.n236 1.04278
R5540 VSS.n1282 VSS.n237 1.04278
R5541 VSS.n714 VSS.n670 0.9221
R5542 VSS.n670 VSS.n665 0.9221
R5543 VSS.n665 VSS.n654 0.9221
R5544 VSS.n786 VSS.n654 0.9221
R5545 VSS.n646 VSS.t5 0.913
R5546 VSS.n680 VSS.t15 0.913
R5547 VSS.n706 VSS.t19 0.913
R5548 VSS.n679 VSS.t17 0.913
R5549 VSS.n682 VSS.t13 0.913
R5550 VSS.n685 VSS.t11 0.913
R5551 VSS.n813 VSS.t9 0.913
R5552 VSS.n645 VSS.t7 0.913
R5553 VSS.n648 VSS.t3 0.913
R5554 VSS.n650 VSS.t0 0.913
R5555 VSS.n766 VSS.t31 0.913
R5556 VSS.n734 VSS.t41 0.913
R5557 VSS.n717 VSS.t45 0.913
R5558 VSS.n724 VSS.t43 0.913
R5559 VSS.n668 VSS.t39 0.913
R5560 VSS.n666 VSS.t37 0.913
R5561 VSS.n754 VSS.t35 0.913
R5562 VSS.n662 VSS.t33 0.913
R5563 VSS.n777 VSS.t29 0.913
R5564 VSS.n780 VSS.t26 0.913
R5565 VSS.n973 VSS.n972 0.913
R5566 VSS.n982 VSS.n964 0.913
R5567 VSS.n959 VSS.n957 0.913
R5568 VSS.n952 VSS.n951 0.913
R5569 VSS.n940 VSS.n939 0.913
R5570 VSS.n1023 VSS.n1022 0.913
R5571 VSS.n1033 VSS.n934 0.913
R5572 VSS.n929 VSS.n928 0.913
R5573 VSS.n1396 VSS.n1395 0.913
R5574 VSS.n1403 VSS.n1402 0.913
R5575 VSS.n19 VSS.n18 0.913
R5576 VSS.n1416 VSS.n1414 0.913
R5577 VSS.n1428 VSS.n12 0.913
R5578 VSS.n1431 VSS.n1430 0.913
R5579 VSS.n952 VSS.n946 0.562038
R5580 VSS.n1010 VSS.n940 0.562038
R5581 VSS.n1412 VSS.n19 0.562038
R5582 VSS.n1417 VSS.n1416 0.562038
R5583 VSS.n1452 VSS.n1451 0.462063
R5584 VSS.n1376 VSS.n1375 0.437113
R5585 VSS.n787 VSS.n786 0.434069
R5586 VSS.n714 VSS.n713 0.434069
R5587 VSS.n625 VSS.n483 0.186214
R5588 VSS.n1061 VSS.n483 0.186214
R5589 VSS.n1063 VSS.n1062 0.186214
R5590 VSS.n1062 VSS.n1061 0.186214
R5591 VSS.n31 VSS.n28 0.168242
R5592 VSS.n360 VSS.n31 0.168242
R5593 VSS.n1060 VSS.n1 0.168242
R5594 VSS.n1061 VSS.n1060 0.168242
R5595 VSS.n1280 VSS.n240 0.1445
R5596 VSS.n1276 VSS.n240 0.1445
R5597 VSS.n1276 VSS.n1275 0.1445
R5598 VSS.n1275 VSS.n1274 0.1445
R5599 VSS.n1274 VSS.n1149 0.1445
R5600 VSS.n1270 VSS.n1149 0.1445
R5601 VSS.n1270 VSS.n1269 0.1445
R5602 VSS.n1269 VSS.n1268 0.1445
R5603 VSS.n1268 VSS.n1155 0.1445
R5604 VSS.n1264 VSS.n1155 0.1445
R5605 VSS.n1264 VSS.n1263 0.1445
R5606 VSS.n1263 VSS.n1262 0.1445
R5607 VSS.n1262 VSS.n1161 0.1445
R5608 VSS.n1258 VSS.n1161 0.1445
R5609 VSS.n1258 VSS.n1257 0.1445
R5610 VSS.n1257 VSS.n1256 0.1445
R5611 VSS.n1256 VSS.n1167 0.1445
R5612 VSS.n1252 VSS.n1167 0.1445
R5613 VSS.n1252 VSS.n1251 0.1445
R5614 VSS.n1251 VSS.n1250 0.1445
R5615 VSS.n1250 VSS.n1173 0.1445
R5616 VSS.n1246 VSS.n1173 0.1445
R5617 VSS.n1246 VSS.n1245 0.1445
R5618 VSS.n1245 VSS.n1244 0.1445
R5619 VSS.n1244 VSS.n1179 0.1445
R5620 VSS.n1241 VSS.n1179 0.1445
R5621 VSS.n1241 VSS.n1240 0.1445
R5622 VSS.n1240 VSS.n1239 0.1445
R5623 VSS.n1239 VSS.n1185 0.1445
R5624 VSS.n1235 VSS.n1185 0.1445
R5625 VSS.n1235 VSS.n1234 0.1445
R5626 VSS.n1234 VSS.n1233 0.1445
R5627 VSS.n1233 VSS.n1191 0.1445
R5628 VSS.n1229 VSS.n1191 0.1445
R5629 VSS.n1229 VSS.n1228 0.1445
R5630 VSS.n1228 VSS.n1227 0.1445
R5631 VSS.n1227 VSS.n1197 0.1445
R5632 VSS.n1223 VSS.n1197 0.1445
R5633 VSS.n1223 VSS.n1222 0.1445
R5634 VSS.n1222 VSS.n1221 0.1445
R5635 VSS.n1221 VSS.n1203 0.1445
R5636 VSS.n1217 VSS.n1203 0.1445
R5637 VSS.n1217 VSS.n1216 0.1445
R5638 VSS.n1216 VSS.n1215 0.1445
R5639 VSS.n1215 VSS.n1209 0.1445
R5640 VSS.n1211 VSS.n1209 0.1445
R5641 VSS.n1211 VSS.n211 0.1445
R5642 VSS.n1285 VSS.n211 0.1445
R5643 VSS.n384 VSS.n370 0.1445
R5644 VSS.n384 VSS.n368 0.1445
R5645 VSS.n391 VSS.n368 0.1445
R5646 VSS.n391 VSS.n390 0.1445
R5647 VSS.n390 VSS.n356 0.1445
R5648 VSS.n405 VSS.n356 0.1445
R5649 VSS.n406 VSS.n405 0.1445
R5650 VSS.n408 VSS.n406 0.1445
R5651 VSS.n408 VSS.n354 0.1445
R5652 VSS.n413 VSS.n354 0.1445
R5653 VSS.n414 VSS.n413 0.1445
R5654 VSS.n416 VSS.n414 0.1445
R5655 VSS.n416 VSS.n352 0.1445
R5656 VSS.n421 VSS.n352 0.1445
R5657 VSS.n422 VSS.n421 0.1445
R5658 VSS.n424 VSS.n422 0.1445
R5659 VSS.n424 VSS.n350 0.1445
R5660 VSS.n429 VSS.n350 0.1445
R5661 VSS.n430 VSS.n429 0.1445
R5662 VSS.n432 VSS.n430 0.1445
R5663 VSS.n432 VSS.n348 0.1445
R5664 VSS.n437 VSS.n348 0.1445
R5665 VSS.n438 VSS.n437 0.1445
R5666 VSS.n440 VSS.n438 0.1445
R5667 VSS.n440 VSS.n346 0.1445
R5668 VSS.n445 VSS.n346 0.1445
R5669 VSS.n446 VSS.n445 0.1445
R5670 VSS.n448 VSS.n446 0.1445
R5671 VSS.n448 VSS.n344 0.1445
R5672 VSS.n453 VSS.n344 0.1445
R5673 VSS.n454 VSS.n453 0.1445
R5674 VSS.n457 VSS.n454 0.1445
R5675 VSS.n457 VSS.n342 0.1445
R5676 VSS.n461 VSS.n342 0.1445
R5677 VSS.n461 VSS.n340 0.1445
R5678 VSS.n467 VSS.n340 0.1445
R5679 VSS.n467 VSS.n338 0.1445
R5680 VSS.n472 VSS.n338 0.1445
R5681 VSS.n472 VSS.n336 0.1445
R5682 VSS.n478 VSS.n336 0.1445
R5683 VSS.n479 VSS.n478 0.1445
R5684 VSS.n707 VSS.n676 0.1445
R5685 VSS.n703 VSS.n676 0.1445
R5686 VSS.n703 VSS.n702 0.1445
R5687 VSS.n702 VSS.n701 0.1445
R5688 VSS.n701 VSS.n678 0.1445
R5689 VSS.n697 VSS.n678 0.1445
R5690 VSS.n697 VSS.n696 0.1445
R5691 VSS.n696 VSS.n695 0.1445
R5692 VSS.n695 VSS.n681 0.1445
R5693 VSS.n691 VSS.n681 0.1445
R5694 VSS.n691 VSS.n690 0.1445
R5695 VSS.n690 VSS.n683 0.1445
R5696 VSS.n686 VSS.n683 0.1445
R5697 VSS.n686 VSS.n640 0.1445
R5698 VSS.n816 VSS.n640 0.1445
R5699 VSS.n816 VSS.n815 0.1445
R5700 VSS.n815 VSS.n642 0.1445
R5701 VSS.n810 VSS.n642 0.1445
R5702 VSS.n810 VSS.n809 0.1445
R5703 VSS.n809 VSS.n808 0.1445
R5704 VSS.n808 VSS.n644 0.1445
R5705 VSS.n804 VSS.n644 0.1445
R5706 VSS.n804 VSS.n803 0.1445
R5707 VSS.n803 VSS.n802 0.1445
R5708 VSS.n802 VSS.n647 0.1445
R5709 VSS.n798 VSS.n647 0.1445
R5710 VSS.n798 VSS.n797 0.1445
R5711 VSS.n797 VSS.n649 0.1445
R5712 VSS.n793 VSS.n649 0.1445
R5713 VSS.n793 VSS.n792 0.1445
R5714 VSS.n918 VSS.n504 0.1445
R5715 VSS.n914 VSS.n504 0.1445
R5716 VSS.n914 VSS.n911 0.1445
R5717 VSS.n911 VSS.n910 0.1445
R5718 VSS.n910 VSS.n907 0.1445
R5719 VSS.n907 VSS.n906 0.1445
R5720 VSS.n906 VSS.n903 0.1445
R5721 VSS.n903 VSS.n902 0.1445
R5722 VSS.n902 VSS.n899 0.1445
R5723 VSS.n899 VSS.n898 0.1445
R5724 VSS.n898 VSS.n895 0.1445
R5725 VSS.n895 VSS.n894 0.1445
R5726 VSS.n894 VSS.n891 0.1445
R5727 VSS.n891 VSS.n890 0.1445
R5728 VSS.n890 VSS.n887 0.1445
R5729 VSS.n887 VSS.n886 0.1445
R5730 VSS.n886 VSS.n883 0.1445
R5731 VSS.n883 VSS.n882 0.1445
R5732 VSS.n882 VSS.n879 0.1445
R5733 VSS.n879 VSS.n878 0.1445
R5734 VSS.n878 VSS.n875 0.1445
R5735 VSS.n875 VSS.n874 0.1445
R5736 VSS.n874 VSS.n871 0.1445
R5737 VSS.n871 VSS.n870 0.1445
R5738 VSS.n870 VSS.n867 0.1445
R5739 VSS.n867 VSS.n866 0.1445
R5740 VSS.n866 VSS.n863 0.1445
R5741 VSS.n863 VSS.n862 0.1445
R5742 VSS.n862 VSS.n859 0.1445
R5743 VSS.n859 VSS.n858 0.1445
R5744 VSS.n858 VSS.n855 0.1445
R5745 VSS.n855 VSS.n854 0.1445
R5746 VSS.n854 VSS.n851 0.1445
R5747 VSS.n851 VSS.n850 0.1445
R5748 VSS.n623 VSS.n506 0.1445
R5749 VSS.n618 VSS.n506 0.1445
R5750 VSS.n618 VSS.n617 0.1445
R5751 VSS.n617 VSS.n616 0.1445
R5752 VSS.n616 VSS.n511 0.1445
R5753 VSS.n611 VSS.n511 0.1445
R5754 VSS.n611 VSS.n610 0.1445
R5755 VSS.n610 VSS.n609 0.1445
R5756 VSS.n609 VSS.n518 0.1445
R5757 VSS.n604 VSS.n518 0.1445
R5758 VSS.n604 VSS.n603 0.1445
R5759 VSS.n603 VSS.n602 0.1445
R5760 VSS.n602 VSS.n525 0.1445
R5761 VSS.n597 VSS.n525 0.1445
R5762 VSS.n597 VSS.n596 0.1445
R5763 VSS.n596 VSS.n595 0.1445
R5764 VSS.n595 VSS.n532 0.1445
R5765 VSS.n590 VSS.n532 0.1445
R5766 VSS.n590 VSS.n589 0.1445
R5767 VSS.n589 VSS.n588 0.1445
R5768 VSS.n588 VSS.n539 0.1445
R5769 VSS.n583 VSS.n539 0.1445
R5770 VSS.n583 VSS.n582 0.1445
R5771 VSS.n582 VSS.n581 0.1445
R5772 VSS.n581 VSS.n546 0.1445
R5773 VSS.n576 VSS.n546 0.1445
R5774 VSS.n576 VSS.n575 0.1445
R5775 VSS.n575 VSS.n574 0.1445
R5776 VSS.n574 VSS.n553 0.1445
R5777 VSS.n569 VSS.n553 0.1445
R5778 VSS.n569 VSS.n568 0.1445
R5779 VSS.n568 VSS.n567 0.1445
R5780 VSS.n567 VSS.n562 0.1445
R5781 VSS.n562 VSS.n561 0.1445
R5782 VSS.n624 VSS.n505 0.1445
R5783 VSS.n508 VSS.n505 0.1445
R5784 VSS.n509 VSS.n508 0.1445
R5785 VSS.n510 VSS.n509 0.1445
R5786 VSS.n514 VSS.n510 0.1445
R5787 VSS.n515 VSS.n514 0.1445
R5788 VSS.n516 VSS.n515 0.1445
R5789 VSS.n517 VSS.n516 0.1445
R5790 VSS.n521 VSS.n517 0.1445
R5791 VSS.n522 VSS.n521 0.1445
R5792 VSS.n523 VSS.n522 0.1445
R5793 VSS.n524 VSS.n523 0.1445
R5794 VSS.n528 VSS.n524 0.1445
R5795 VSS.n529 VSS.n528 0.1445
R5796 VSS.n530 VSS.n529 0.1445
R5797 VSS.n531 VSS.n530 0.1445
R5798 VSS.n535 VSS.n531 0.1445
R5799 VSS.n536 VSS.n535 0.1445
R5800 VSS.n537 VSS.n536 0.1445
R5801 VSS.n538 VSS.n537 0.1445
R5802 VSS.n542 VSS.n538 0.1445
R5803 VSS.n543 VSS.n542 0.1445
R5804 VSS.n544 VSS.n543 0.1445
R5805 VSS.n545 VSS.n544 0.1445
R5806 VSS.n549 VSS.n545 0.1445
R5807 VSS.n550 VSS.n549 0.1445
R5808 VSS.n551 VSS.n550 0.1445
R5809 VSS.n552 VSS.n551 0.1445
R5810 VSS.n556 VSS.n552 0.1445
R5811 VSS.n557 VSS.n556 0.1445
R5812 VSS.n558 VSS.n557 0.1445
R5813 VSS.n559 VSS.n558 0.1445
R5814 VSS.n560 VSS.n559 0.1445
R5815 VSS.n560 VSS.n308 0.1445
R5816 VSS.n380 VSS.n374 0.1445
R5817 VSS.n380 VSS.n364 0.1445
R5818 VSS.n395 VSS.n364 0.1445
R5819 VSS.n395 VSS.n362 0.1445
R5820 VSS.n400 VSS.n362 0.1445
R5821 VSS.n400 VSS.n39 0.1445
R5822 VSS.n1369 VSS.n39 0.1445
R5823 VSS.n1369 VSS.n1368 0.1445
R5824 VSS.n1368 VSS.n1367 0.1445
R5825 VSS.n1367 VSS.n43 0.1445
R5826 VSS.n1357 VSS.n43 0.1445
R5827 VSS.n1357 VSS.n1356 0.1445
R5828 VSS.n1356 VSS.n1355 0.1445
R5829 VSS.n1355 VSS.n69 0.1445
R5830 VSS.n1345 VSS.n69 0.1445
R5831 VSS.n1345 VSS.n1344 0.1445
R5832 VSS.n1344 VSS.n1343 0.1445
R5833 VSS.n1343 VSS.n90 0.1445
R5834 VSS.n1333 VSS.n90 0.1445
R5835 VSS.n1333 VSS.n1332 0.1445
R5836 VSS.n1332 VSS.n1331 0.1445
R5837 VSS.n1331 VSS.n112 0.1445
R5838 VSS.n1321 VSS.n112 0.1445
R5839 VSS.n1321 VSS.n1320 0.1445
R5840 VSS.n1320 VSS.n1319 0.1445
R5841 VSS.n1319 VSS.n133 0.1445
R5842 VSS.n1309 VSS.n133 0.1445
R5843 VSS.n1309 VSS.n1308 0.1445
R5844 VSS.n1308 VSS.n1307 0.1445
R5845 VSS.n1307 VSS.n154 0.1445
R5846 VSS.n1297 VSS.n154 0.1445
R5847 VSS.n1297 VSS.n1296 0.1445
R5848 VSS.n1296 VSS.n1295 0.1445
R5849 VSS.n1295 VSS.n175 0.1445
R5850 VSS.n320 VSS.n175 0.1445
R5851 VSS.n321 VSS.n320 0.1445
R5852 VSS.n324 VSS.n321 0.1445
R5853 VSS.n324 VSS.n313 0.1445
R5854 VSS.n330 VSS.n313 0.1445
R5855 VSS.n332 VSS.n330 0.1445
R5856 VSS.n333 VSS.n332 0.1445
R5857 VSS.n379 VSS.n378 0.1445
R5858 VSS.n379 VSS.n363 0.1445
R5859 VSS.n396 VSS.n363 0.1445
R5860 VSS.n397 VSS.n396 0.1445
R5861 VSS.n399 VSS.n397 0.1445
R5862 VSS.n399 VSS.n398 0.1445
R5863 VSS.n398 VSS.n40 0.1445
R5864 VSS.n41 VSS.n40 0.1445
R5865 VSS.n42 VSS.n41 0.1445
R5866 VSS.n65 VSS.n42 0.1445
R5867 VSS.n66 VSS.n65 0.1445
R5868 VSS.n67 VSS.n66 0.1445
R5869 VSS.n68 VSS.n67 0.1445
R5870 VSS.n86 VSS.n68 0.1445
R5871 VSS.n87 VSS.n86 0.1445
R5872 VSS.n88 VSS.n87 0.1445
R5873 VSS.n89 VSS.n88 0.1445
R5874 VSS.n108 VSS.n89 0.1445
R5875 VSS.n109 VSS.n108 0.1445
R5876 VSS.n110 VSS.n109 0.1445
R5877 VSS.n111 VSS.n110 0.1445
R5878 VSS.n129 VSS.n111 0.1445
R5879 VSS.n130 VSS.n129 0.1445
R5880 VSS.n131 VSS.n130 0.1445
R5881 VSS.n132 VSS.n131 0.1445
R5882 VSS.n150 VSS.n132 0.1445
R5883 VSS.n151 VSS.n150 0.1445
R5884 VSS.n152 VSS.n151 0.1445
R5885 VSS.n153 VSS.n152 0.1445
R5886 VSS.n171 VSS.n153 0.1445
R5887 VSS.n172 VSS.n171 0.1445
R5888 VSS.n173 VSS.n172 0.1445
R5889 VSS.n174 VSS.n173 0.1445
R5890 VSS.n318 VSS.n317 0.1445
R5891 VSS.n318 VSS.n314 0.1445
R5892 VSS.n325 VSS.n314 0.1445
R5893 VSS.n326 VSS.n325 0.1445
R5894 VSS.n327 VSS.n326 0.1445
R5895 VSS.n327 VSS.n312 0.1445
R5896 VSS.n334 VSS.n312 0.1445
R5897 VSS.n385 VSS.n369 0.1445
R5898 VSS.n386 VSS.n385 0.1445
R5899 VSS.n387 VSS.n386 0.1445
R5900 VSS.n389 VSS.n387 0.1445
R5901 VSS.n389 VSS.n388 0.1445
R5902 VSS.n388 VSS.n357 0.1445
R5903 VSS.n357 VSS.n355 0.1445
R5904 VSS.n409 VSS.n355 0.1445
R5905 VSS.n410 VSS.n409 0.1445
R5906 VSS.n411 VSS.n410 0.1445
R5907 VSS.n411 VSS.n353 0.1445
R5908 VSS.n417 VSS.n353 0.1445
R5909 VSS.n418 VSS.n417 0.1445
R5910 VSS.n419 VSS.n418 0.1445
R5911 VSS.n419 VSS.n351 0.1445
R5912 VSS.n425 VSS.n351 0.1445
R5913 VSS.n426 VSS.n425 0.1445
R5914 VSS.n427 VSS.n426 0.1445
R5915 VSS.n427 VSS.n349 0.1445
R5916 VSS.n433 VSS.n349 0.1445
R5917 VSS.n434 VSS.n433 0.1445
R5918 VSS.n435 VSS.n434 0.1445
R5919 VSS.n435 VSS.n347 0.1445
R5920 VSS.n441 VSS.n347 0.1445
R5921 VSS.n442 VSS.n441 0.1445
R5922 VSS.n443 VSS.n442 0.1445
R5923 VSS.n443 VSS.n345 0.1445
R5924 VSS.n449 VSS.n345 0.1445
R5925 VSS.n450 VSS.n449 0.1445
R5926 VSS.n451 VSS.n450 0.1445
R5927 VSS.n451 VSS.n343 0.1445
R5928 VSS.n458 VSS.n343 0.1445
R5929 VSS.n459 VSS.n458 0.1445
R5930 VSS.n460 VSS.n459 0.1445
R5931 VSS.n460 VSS.n339 0.1445
R5932 VSS.n468 VSS.n339 0.1445
R5933 VSS.n469 VSS.n468 0.1445
R5934 VSS.n471 VSS.n469 0.1445
R5935 VSS.n471 VSS.n470 0.1445
R5936 VSS.n470 VSS.n335 0.1445
R5937 VSS.n480 VSS.n335 0.1445
R5938 VSS.n52 VSS.n51 0.1445
R5939 VSS.n1363 VSS.n51 0.1445
R5940 VSS.n1363 VSS.n1362 0.1445
R5941 VSS.n1362 VSS.n1361 0.1445
R5942 VSS.n1361 VSS.n58 0.1445
R5943 VSS.n1351 VSS.n58 0.1445
R5944 VSS.n1351 VSS.n1350 0.1445
R5945 VSS.n1350 VSS.n1349 0.1445
R5946 VSS.n1349 VSS.n80 0.1445
R5947 VSS.n1339 VSS.n80 0.1445
R5948 VSS.n1339 VSS.n1338 0.1445
R5949 VSS.n1338 VSS.n1337 0.1445
R5950 VSS.n1337 VSS.n101 0.1445
R5951 VSS.n1327 VSS.n101 0.1445
R5952 VSS.n1327 VSS.n1326 0.1445
R5953 VSS.n1326 VSS.n1325 0.1445
R5954 VSS.n1325 VSS.n122 0.1445
R5955 VSS.n1315 VSS.n122 0.1445
R5956 VSS.n1315 VSS.n1314 0.1445
R5957 VSS.n1314 VSS.n1313 0.1445
R5958 VSS.n1313 VSS.n143 0.1445
R5959 VSS.n1303 VSS.n143 0.1445
R5960 VSS.n1303 VSS.n1302 0.1445
R5961 VSS.n1302 VSS.n1301 0.1445
R5962 VSS.n1301 VSS.n165 0.1445
R5963 VSS.n1054 VSS.n165 0.1445
R5964 VSS.n1058 VSS.n1054 0.1445
R5965 VSS.n54 VSS.n53 0.1445
R5966 VSS.n55 VSS.n54 0.1445
R5967 VSS.n56 VSS.n55 0.1445
R5968 VSS.n57 VSS.n56 0.1445
R5969 VSS.n76 VSS.n57 0.1445
R5970 VSS.n77 VSS.n76 0.1445
R5971 VSS.n78 VSS.n77 0.1445
R5972 VSS.n79 VSS.n78 0.1445
R5973 VSS.n97 VSS.n79 0.1445
R5974 VSS.n98 VSS.n97 0.1445
R5975 VSS.n99 VSS.n98 0.1445
R5976 VSS.n100 VSS.n99 0.1445
R5977 VSS.n118 VSS.n100 0.1445
R5978 VSS.n119 VSS.n118 0.1445
R5979 VSS.n120 VSS.n119 0.1445
R5980 VSS.n121 VSS.n120 0.1445
R5981 VSS.n139 VSS.n121 0.1445
R5982 VSS.n140 VSS.n139 0.1445
R5983 VSS.n141 VSS.n140 0.1445
R5984 VSS.n142 VSS.n141 0.1445
R5985 VSS.n161 VSS.n142 0.1445
R5986 VSS.n162 VSS.n161 0.1445
R5987 VSS.n163 VSS.n162 0.1445
R5988 VSS.n164 VSS.n163 0.1445
R5989 VSS.n1055 VSS.n164 0.1445
R5990 VSS.n1056 VSS.n1055 0.1445
R5991 VSS.n1057 VSS.n1056 0.1445
R5992 VSS.n1373 VSS.n30 0.1445
R5993 VSS.n969 VSS.n30 0.1445
R5994 VSS.n977 VSS.n969 0.1445
R5995 VSS.n978 VSS.n977 0.1445
R5996 VSS.n978 VSS.n962 0.1445
R5997 VSS.n986 VSS.n962 0.1445
R5998 VSS.n988 VSS.n986 0.1445
R5999 VSS.n989 VSS.n988 0.1445
R6000 VSS.n989 VSS.n949 0.1445
R6001 VSS.n1003 VSS.n949 0.1445
R6002 VSS.n1005 VSS.n1003 0.1445
R6003 VSS.n1006 VSS.n1005 0.1445
R6004 VSS.n1006 VSS.n944 0.1445
R6005 VSS.n1013 VSS.n944 0.1445
R6006 VSS.n1015 VSS.n1013 0.1445
R6007 VSS.n1018 VSS.n1015 0.1445
R6008 VSS.n1018 VSS.n1017 0.1445
R6009 VSS.n1017 VSS.n937 0.1445
R6010 VSS.n1028 VSS.n937 0.1445
R6011 VSS.n1029 VSS.n1028 0.1445
R6012 VSS.n1029 VSS.n932 0.1445
R6013 VSS.n1037 VSS.n932 0.1445
R6014 VSS.n1039 VSS.n1037 0.1445
R6015 VSS.n1040 VSS.n1039 0.1445
R6016 VSS.n1040 VSS.n923 0.1445
R6017 VSS.n1049 VSS.n923 0.1445
R6018 VSS.n1050 VSS.n1049 0.1445
R6019 VSS.n1141 VSS.n1140 0.1445
R6020 VSS.n1140 VSS.n1139 0.1445
R6021 VSS.n1139 VSS.n245 0.1445
R6022 VSS.n1135 VSS.n245 0.1445
R6023 VSS.n1135 VSS.n1134 0.1445
R6024 VSS.n1134 VSS.n1133 0.1445
R6025 VSS.n1133 VSS.n251 0.1445
R6026 VSS.n1129 VSS.n251 0.1445
R6027 VSS.n1129 VSS.n1128 0.1445
R6028 VSS.n1128 VSS.n1127 0.1445
R6029 VSS.n1127 VSS.n257 0.1445
R6030 VSS.n1123 VSS.n257 0.1445
R6031 VSS.n1123 VSS.n1122 0.1445
R6032 VSS.n1122 VSS.n1121 0.1445
R6033 VSS.n1121 VSS.n263 0.1445
R6034 VSS.n1117 VSS.n263 0.1445
R6035 VSS.n1117 VSS.n1116 0.1445
R6036 VSS.n1116 VSS.n1115 0.1445
R6037 VSS.n1115 VSS.n269 0.1445
R6038 VSS.n1111 VSS.n269 0.1445
R6039 VSS.n1111 VSS.n1110 0.1445
R6040 VSS.n1110 VSS.n1109 0.1445
R6041 VSS.n1109 VSS.n275 0.1445
R6042 VSS.n1105 VSS.n275 0.1445
R6043 VSS.n1105 VSS.n1104 0.1445
R6044 VSS.n1104 VSS.n1103 0.1445
R6045 VSS.n1103 VSS.n281 0.1445
R6046 VSS.n1099 VSS.n281 0.1445
R6047 VSS.n1099 VSS.n1098 0.1445
R6048 VSS.n1098 VSS.n1097 0.1445
R6049 VSS.n1097 VSS.n287 0.1445
R6050 VSS.n1093 VSS.n287 0.1445
R6051 VSS.n1093 VSS.n1092 0.1445
R6052 VSS.n1092 VSS.n1091 0.1445
R6053 VSS.n1091 VSS.n293 0.1445
R6054 VSS.n1087 VSS.n293 0.1445
R6055 VSS.n1087 VSS.n1086 0.1445
R6056 VSS.n1086 VSS.n1085 0.1445
R6057 VSS.n1085 VSS.n299 0.1445
R6058 VSS.n1081 VSS.n299 0.1445
R6059 VSS.n1081 VSS.n1080 0.1445
R6060 VSS.n1080 VSS.n1079 0.1445
R6061 VSS.n1079 VSS.n305 0.1445
R6062 VSS.n1075 VSS.n305 0.1445
R6063 VSS.n1075 VSS.n1074 0.1445
R6064 VSS.n1074 VSS.n1073 0.1445
R6065 VSS.n1073 VSS.n208 0.1445
R6066 VSS.n1289 VSS.n208 0.1445
R6067 VSS.n1142 VSS.n241 0.1445
R6068 VSS.n1138 VSS.n241 0.1445
R6069 VSS.n1138 VSS.n1137 0.1445
R6070 VSS.n1137 VSS.n1136 0.1445
R6071 VSS.n1136 VSS.n246 0.1445
R6072 VSS.n1132 VSS.n246 0.1445
R6073 VSS.n1132 VSS.n1131 0.1445
R6074 VSS.n1131 VSS.n1130 0.1445
R6075 VSS.n1130 VSS.n252 0.1445
R6076 VSS.n1126 VSS.n252 0.1445
R6077 VSS.n1126 VSS.n1125 0.1445
R6078 VSS.n1125 VSS.n1124 0.1445
R6079 VSS.n1124 VSS.n258 0.1445
R6080 VSS.n1120 VSS.n258 0.1445
R6081 VSS.n1120 VSS.n1119 0.1445
R6082 VSS.n1119 VSS.n1118 0.1445
R6083 VSS.n1118 VSS.n264 0.1445
R6084 VSS.n1114 VSS.n264 0.1445
R6085 VSS.n1114 VSS.n1113 0.1445
R6086 VSS.n1113 VSS.n1112 0.1445
R6087 VSS.n1112 VSS.n270 0.1445
R6088 VSS.n1108 VSS.n270 0.1445
R6089 VSS.n1108 VSS.n1107 0.1445
R6090 VSS.n1107 VSS.n1106 0.1445
R6091 VSS.n1106 VSS.n276 0.1445
R6092 VSS.n1102 VSS.n276 0.1445
R6093 VSS.n1102 VSS.n1101 0.1445
R6094 VSS.n1101 VSS.n1100 0.1445
R6095 VSS.n1100 VSS.n282 0.1445
R6096 VSS.n1096 VSS.n282 0.1445
R6097 VSS.n1096 VSS.n1095 0.1445
R6098 VSS.n1095 VSS.n1094 0.1445
R6099 VSS.n1094 VSS.n288 0.1445
R6100 VSS.n1090 VSS.n288 0.1445
R6101 VSS.n1090 VSS.n1089 0.1445
R6102 VSS.n1089 VSS.n1088 0.1445
R6103 VSS.n1088 VSS.n294 0.1445
R6104 VSS.n1084 VSS.n294 0.1445
R6105 VSS.n1084 VSS.n1083 0.1445
R6106 VSS.n1083 VSS.n1082 0.1445
R6107 VSS.n1082 VSS.n300 0.1445
R6108 VSS.n1078 VSS.n1077 0.1445
R6109 VSS.n1077 VSS.n1076 0.1445
R6110 VSS.n1076 VSS.n1067 0.1445
R6111 VSS.n1072 VSS.n1067 0.1445
R6112 VSS.n1072 VSS.n209 0.1445
R6113 VSS.n1288 VSS.n209 0.1445
R6114 VSS.n1279 VSS.n1278 0.1445
R6115 VSS.n1278 VSS.n1277 0.1445
R6116 VSS.n1277 VSS.n1144 0.1445
R6117 VSS.n1273 VSS.n1144 0.1445
R6118 VSS.n1273 VSS.n1272 0.1445
R6119 VSS.n1272 VSS.n1271 0.1445
R6120 VSS.n1271 VSS.n1150 0.1445
R6121 VSS.n1267 VSS.n1150 0.1445
R6122 VSS.n1267 VSS.n1266 0.1445
R6123 VSS.n1266 VSS.n1265 0.1445
R6124 VSS.n1265 VSS.n1156 0.1445
R6125 VSS.n1261 VSS.n1156 0.1445
R6126 VSS.n1261 VSS.n1260 0.1445
R6127 VSS.n1260 VSS.n1259 0.1445
R6128 VSS.n1259 VSS.n1162 0.1445
R6129 VSS.n1255 VSS.n1162 0.1445
R6130 VSS.n1255 VSS.n1254 0.1445
R6131 VSS.n1254 VSS.n1253 0.1445
R6132 VSS.n1253 VSS.n1168 0.1445
R6133 VSS.n1249 VSS.n1168 0.1445
R6134 VSS.n1249 VSS.n1248 0.1445
R6135 VSS.n1248 VSS.n1247 0.1445
R6136 VSS.n1247 VSS.n1174 0.1445
R6137 VSS VSS.n1174 0.1445
R6138 VSS VSS.n1243 0.1445
R6139 VSS.n1243 VSS.n1242 0.1445
R6140 VSS.n1242 VSS.n1180 0.1445
R6141 VSS.n1238 VSS.n1180 0.1445
R6142 VSS.n1238 VSS.n1237 0.1445
R6143 VSS.n1237 VSS.n1236 0.1445
R6144 VSS.n1236 VSS.n1186 0.1445
R6145 VSS.n1232 VSS.n1186 0.1445
R6146 VSS.n1232 VSS.n1231 0.1445
R6147 VSS.n1231 VSS.n1230 0.1445
R6148 VSS.n1230 VSS.n1192 0.1445
R6149 VSS.n1226 VSS.n1192 0.1445
R6150 VSS.n1226 VSS.n1225 0.1445
R6151 VSS.n1225 VSS.n1224 0.1445
R6152 VSS.n1224 VSS.n1198 0.1445
R6153 VSS.n1220 VSS.n1198 0.1445
R6154 VSS.n1220 VSS.n1219 0.1445
R6155 VSS.n1219 VSS.n1218 0.1445
R6156 VSS.n1218 VSS.n1204 0.1445
R6157 VSS.n1214 VSS.n1204 0.1445
R6158 VSS.n1214 VSS.n1213 0.1445
R6159 VSS.n1213 VSS.n1212 0.1445
R6160 VSS.n1212 VSS.n210 0.1445
R6161 VSS.n1286 VSS.n210 0.1445
R6162 VSS.n317 VSS.n316 0.1409
R6163 VSS.n1078 VSS.n1066 0.1265
R6164 VSS.n792 VSS.n791 0.117269
R6165 VSS.n709 VSS.n707 0.117269
R6166 VSS.n1376 VSS.n26 0.107278
R6167 VSS.n1287 VSS.n207 0.1005
R6168 VSS.n1061 VSS.n207 0.1005
R6169 VSS.n1143 VSS.n238 0.1005
R6170 VSS.n1061 VSS.n238 0.1005
R6171 VSS.n377 VSS.n376 0.0950455
R6172 VSS.n482 VSS.n481 0.0950455
R6173 VSS.n1061 VSS.n482 0.0950455
R6174 VSS.n1451 VSS.n2 0.0922644
R6175 VSS.n971 VSS.n27 0.0847125
R6176 VSS.n924 VSS.n3 0.0779226
R6177 VSS.n711 VSS.n710 0.0725
R6178 VSS.n790 VSS.n652 0.0725
R6179 VSS.n1448 VSS.n1447 0.0572937
R6180 VSS.n1381 VSS.n1379 0.0572937
R6181 VSS.n1447 VSS.n1446 0.0552335
R6182 VSS.n1382 VSS.n1381 0.0552335
R6183 VSS.n3 VSS.n2 0.0430846
R6184 VSS.n917 VSS.n916 0.0392827
R6185 VSS.n849 VSS.n307 0.0392827
R6186 VSS.n791 VSS.n651 0.0384533
R6187 VSS.n709 VSS.n708 0.0384533
R6188 VSS.n788 VSS.n787 0.0371923
R6189 VSS.n713 VSS.n712 0.0371923
R6190 VSS.n27 VSS.n26 0.0367015
R6191 VSS.n1448 VSS.n2 0.0277385
R6192 VSS.n1379 VSS.n26 0.0277385
R6193 VSS.n719 VSS.n718 0.0235032
R6194 VSS.n719 VSS.n715 0.0235032
R6195 VSS.n726 VSS.n716 0.0235032
R6196 VSS.n716 VSS.n673 0.0235032
R6197 VSS.n733 VSS.n732 0.0235032
R6198 VSS.n733 VSS.n671 0.0235032
R6199 VSS.n738 VSS.n669 0.0235032
R6200 VSS.n746 VSS.n669 0.0235032
R6201 VSS.n750 VSS.n667 0.0235032
R6202 VSS.n751 VSS.n750 0.0235032
R6203 VSS.n751 VSS.n665 0.0235032
R6204 VSS.n756 VSS.n665 0.0235032
R6205 VSS.n757 VSS.n756 0.0235032
R6206 VSS.n758 VSS.n757 0.0235032
R6207 VSS.n762 VSS.n761 0.0235032
R6208 VSS.n762 VSS.n660 0.0235032
R6209 VSS.n768 VSS.n661 0.0235032
R6210 VSS.n661 VSS.n659 0.0235032
R6211 VSS.n775 VSS.n774 0.0235032
R6212 VSS.n775 VSS.n656 0.0235032
R6213 VSS.n783 VSS.n657 0.0235032
R6214 VSS.n779 VSS.n657 0.0235032
R6215 VSS.n1398 VSS.n24 0.0203347
R6216 VSS.n1399 VSS.n1398 0.0203347
R6217 VSS.n1400 VSS.n1399 0.0203347
R6218 VSS.n1406 VSS.n1405 0.0203347
R6219 VSS.n1407 VSS.n1406 0.0203347
R6220 VSS.n1411 VSS.n1410 0.0203347
R6221 VSS.n1411 VSS.n16 0.0203347
R6222 VSS.n1419 VSS.n17 0.0203347
R6223 VSS.n17 VSS.n14 0.0203347
R6224 VSS.n1426 VSS.n1425 0.0203347
R6225 VSS.n1426 VSS.n10 0.0203347
R6226 VSS.n1434 VSS.n11 0.0203347
R6227 VSS.n11 VSS.n8 0.0203347
R6228 VSS.n1440 VSS.n8 0.0203347
R6229 VSS.n789 VSS.n788 0.0189615
R6230 VSS.n712 VSS.n674 0.0189615
R6231 VSS.n727 VSS.n726 0.0189026
R6232 VSS.n746 VSS.n745 0.0189026
R6233 VSS.n761 VSS.n663 0.0189026
R6234 VSS.n784 VSS.n656 0.0189026
R6235 VSS.n916 VSS.n915 0.0188673
R6236 VSS.n915 VSS.n626 0.0188673
R6237 VSS.n627 VSS.n626 0.0188673
R6238 VSS.n629 VSS.n628 0.0188673
R6239 VSS.n630 VSS.n629 0.0188673
R6240 VSS.n632 VSS.n631 0.0188673
R6241 VSS.n633 VSS.n632 0.0188673
R6242 VSS.n635 VSS.n634 0.0188673
R6243 VSS.n636 VSS.n635 0.0188673
R6244 VSS.n638 VSS.n637 0.0188673
R6245 VSS.n639 VSS.n638 0.0188673
R6246 VSS.n816 VSS.n639 0.0188673
R6247 VSS.n817 VSS.n816 0.0188673
R6248 VSS.n818 VSS.n817 0.0188673
R6249 VSS.n819 VSS.n818 0.0188673
R6250 VSS.n821 VSS.n820 0.0188673
R6251 VSS.n822 VSS.n821 0.0188673
R6252 VSS.n824 VSS.n823 0.0188673
R6253 VSS.n825 VSS.n824 0.0188673
R6254 VSS.n827 VSS.n826 0.0188673
R6255 VSS.n828 VSS.n827 0.0188673
R6256 VSS.n830 VSS.n829 0.0188673
R6257 VSS.n831 VSS.n830 0.0188673
R6258 VSS.n849 VSS.n831 0.0188673
R6259 VSS.n789 VSS.n651 0.0187854
R6260 VSS.n708 VSS.n674 0.0187854
R6261 VSS.n1446 VSS.n5 0.0186975
R6262 VSS.n1382 VSS.n25 0.0186975
R6263 VSS.n1064 VSS.n307 0.0185
R6264 VSS.n1066 VSS.n300 0.0185
R6265 VSS.n1405 VSS.n22 0.0183512
R6266 VSS.n1435 VSS.n10 0.0183512
R6267 VSS.n975 VSS.n974 0.0167896
R6268 VSS.n979 VSS.n963 0.0167896
R6269 VSS.n985 VSS.n963 0.0167896
R6270 VSS.n985 VSS.n956 0.0167896
R6271 VSS.n990 VSS.n950 0.0167896
R6272 VSS.n1002 VSS.n950 0.0167896
R6273 VSS.n1007 VSS.n947 0.0167896
R6274 VSS.n1008 VSS.n1007 0.0167896
R6275 VSS.n1012 VSS.n941 0.0167896
R6276 VSS.n1019 VSS.n941 0.0167896
R6277 VSS.n1025 VSS.n938 0.0167896
R6278 VSS.n1026 VSS.n1025 0.0167896
R6279 VSS.n1030 VSS.n933 0.0167896
R6280 VSS.n1036 VSS.n933 0.0167896
R6281 VSS.n1036 VSS.n926 0.0167896
R6282 VSS.n1041 VSS.n930 0.0167896
R6283 VSS.n832 VSS.n628 0.0151939
R6284 VSS.n838 VSS.n636 0.0151939
R6285 VSS.n841 VSS.n820 0.0151939
R6286 VSS.n847 VSS.n828 0.0151939
R6287 VSS.n975 VSS.n968 0.0151606
R6288 VSS.n991 VSS.n990 0.0151606
R6289 VSS.n1026 VSS.n936 0.0151606
R6290 VSS.n1042 VSS.n1041 0.0151606
R6291 VSS.n971 VSS.n970 0.014448
R6292 VSS.n1046 VSS.n924 0.014448
R6293 VSS.n1410 VSS.n20 0.0143843
R6294 VSS.n1424 VSS.n14 0.0143843
R6295 VSS.n732 VSS.n731 0.0143019
R6296 VSS.n739 VSS.n671 0.0143019
R6297 VSS.n769 VSS.n768 0.0143019
R6298 VSS.n773 VSS.n659 0.0143019
R6299 VSS.n1444 VSS.n5 0.0119263
R6300 VSS.n1391 VSS.n25 0.0119263
R6301 VSS.n1374 VSS.n29 0.0119027
R6302 VSS.n1001 VSS.n947 0.0119027
R6303 VSS.n1019 VSS.n942 0.0119027
R6304 VSS.n1045 VSS.n0 0.0119027
R6305 VSS.n834 VSS.n631 0.0115204
R6306 VSS.n836 VSS.n633 0.0115204
R6307 VSS.n843 VSS.n823 0.0115204
R6308 VSS.n845 VSS.n825 0.0115204
R6309 VSS.n1420 VSS.n16 0.0104174
R6310 VSS.n1420 VSS.n1419 0.0104174
R6311 VSS.n731 VSS.n673 0.00970128
R6312 VSS.n739 VSS.n738 0.00970128
R6313 VSS.n769 VSS.n660 0.00970128
R6314 VSS.n774 VSS.n773 0.00970128
R6315 VSS.n1008 VSS.n945 0.0086448
R6316 VSS.n1012 VSS.n945 0.0086448
R6317 VSS.n834 VSS.n630 0.00784694
R6318 VSS.n836 VSS.n634 0.00784694
R6319 VSS.n843 VSS.n822 0.00784694
R6320 VSS.n845 VSS.n826 0.00784694
R6321 VSS.n1407 VSS.n20 0.00645041
R6322 VSS.n1425 VSS.n1424 0.00645041
R6323 VSS.n970 VSS.n29 0.00538688
R6324 VSS.n1002 VSS.n1001 0.00538688
R6325 VSS.n942 VSS.n938 0.00538688
R6326 VSS.n1046 VSS.n1045 0.00538688
R6327 VSS.n727 VSS.n715 0.00510064
R6328 VSS.n745 VSS.n667 0.00510064
R6329 VSS.n758 VSS.n663 0.00510064
R6330 VSS.n784 VSS.n783 0.00510064
R6331 VSS.n832 VSS.n627 0.00417347
R6332 VSS.n838 VSS.n637 0.00417347
R6333 VSS.n841 VSS.n819 0.00417347
R6334 VSS.n847 VSS.n829 0.00417347
R6335 VSS.n316 VSS.n174 0.0041
R6336 VSS.n974 VSS.n971 0.00284163
R6337 VSS.n930 VSS.n924 0.00284163
R6338 VSS.n1375 VSS.n1374 0.00273982
R6339 VSS.n1387 VSS.n24 0.00248347
R6340 VSS.n1400 VSS.n22 0.00248347
R6341 VSS.n1435 VSS.n1434 0.00248347
R6342 VSS.n1440 VSS.n1439 0.00248347
R6343 VSS.n1453 VSS.n1452 0.00233258
R6344 VSS.n979 VSS.n968 0.00212896
R6345 VSS.n991 VSS.n956 0.00212896
R6346 VSS.n1030 VSS.n936 0.00212896
R6347 VSS.n1042 VSS.n926 0.00212896
R6348 VSS.n1387 VSS.n25 0.00149173
R6349 VSS.n1439 VSS.n5 0.00149173
R6350 VSS.n1453 VSS.n0 0.00090724
C0 Vthr a_4290_5335# 0.86816f
C1 VDD VT 2.79531f
C2 VDD Vthr 1.41927f
C3 Isum a_4290_5335# 2.52008f
C4 Iout a_4290_5335# 5.72871f
C5 VDD Isum 12.1166f
C6 a_4290_5335# a_190_n489# 9.60875f
C7 Isum Vthr 1.43519f
C8 VDD a_190_n489# 2.90782f
C9 VDD a_4290_5335# 3.74867f
C10 VT a_4290_5335# 0.94096f
C11 Vthr VSS 5.03414f
C12 Iout VSS 11.7285f
C13 VT VSS 7.88232f
C14 Isum VSS 30.25393f
C15 VDD VSS 0.11561p
C16 a_190_n489# VSS 16.158f
C17 a_4290_5335# VSS 21.5622f
C18 VDD.t51 VSS 10.4503f
C19 Isum.n119 VSS 2.39299f
C20 Isum.n281 VSS 2.78847f
C21 VT.t0 VSS 3.45205f
C22 Iout.t0 VSS 1.083f
C23 Vthr.t0 VSS 5.21687f
.ends
