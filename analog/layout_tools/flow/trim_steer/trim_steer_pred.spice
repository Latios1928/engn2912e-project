* LVS reference for trim_steer.gds (glayout_floorplan.two_row)
* note: R0: 2 x 150 um n-well resistor drawn as 3 bars in series (50, 50, 50 um; joints R0_j<k>)
* note: M0: m=23 x nf=1 -> nf=23, m=1 (parallel copies as fingers)
* note: MB: m=14 x nf=1 -> nf=14, m=1 (parallel copies as fingers)
* note: M2: m=2 x nf=1 -> nf=2, m=1 (parallel copies as fingers)
* note: M3: m=4 x nf=1 -> nf=4, m=1 (parallel copies as fingers)
* note: M4: m=8 x nf=1 -> nf=8, m=1 (parallel copies as fingers)
.subckt trim_steer VDD VSS Iref Ibias trim[3] trim[2] trim[1] trim[0] cal
XSB net1 VDD Ibias VSS nfet_03v3 L=0.5u W=1u nf=1
XS0 net2 trim[0] Ibias VSS nfet_03v3 L=0.5u W=1u nf=1
XMAUX aux vaux VSS VSS nfet_03v3 L=8u W=10u nf=1
XS0X net2 tb0 aux VSS nfet_03v3 L=0.5u W=1u nf=1
XS1X net3 tb1 aux VSS nfet_03v3 L=0.5u W=1u nf=1
XS1 net3 trim[1] Ibias VSS nfet_03v3 L=0.5u W=1u nf=1
XS2 net4 trim[2] Ibias VSS nfet_03v3 L=0.5u W=1u nf=1
XMCAL aux cal vaux VSS nfet_03v3 L=0.5u W=1u nf=1
XS2X net4 tb2 aux VSS nfet_03v3 L=0.5u W=1u nf=1
XS3X net5 tb3 aux VSS nfet_03v3 L=0.5u W=1u nf=1
XMIN0 tb0 trim[0] VSS VSS nfet_03v3 L=0.28u W=0.5u nf=1
XMIN1 tb1 trim[1] VSS VSS nfet_03v3 L=0.28u W=0.5u nf=1
XMIN2 tb2 trim[2] VSS VSS nfet_03v3 L=0.28u W=0.5u nf=1
XMIN3 tb3 trim[3] VSS VSS nfet_03v3 L=0.28u W=0.5u nf=1
XMINC calb cal VSS VSS nfet_03v3 L=0.28u W=0.5u nf=1
XS3 net5 trim[3] Ibias VSS nfet_03v3 L=0.5u W=1u nf=1
XMDIS vaux calb VSS VSS nfet_03v3 L=45.45u W=0.5u nf=1
XMCAUX VSS vaux VSS VSS nfet_03v3 L=5u W=5u nf=1
XMB_f0 net1 Vgs VDD VDD pfet_03v3 L=6u W=1u nf=1
XMB_f1 net1 Vgs VDD VDD pfet_03v3 L=6u W=1u nf=1
XMB_f2 net1 Vgs VDD VDD pfet_03v3 L=6u W=1u nf=1
XMB_f3 net1 Vgs VDD VDD pfet_03v3 L=6u W=1u nf=1
XMB_f4 net1 Vgs VDD VDD pfet_03v3 L=6u W=1u nf=1
XMB_f5 net1 Vgs VDD VDD pfet_03v3 L=6u W=1u nf=1
XMB_f6 net1 Vgs VDD VDD pfet_03v3 L=6u W=1u nf=1
XMB_f7 net1 Vgs VDD VDD pfet_03v3 L=6u W=1u nf=1
XMB_f8 net1 Vgs VDD VDD pfet_03v3 L=6u W=1u nf=1
XMB_f9 net1 Vgs VDD VDD pfet_03v3 L=6u W=1u nf=1
XMB_f10 net1 Vgs VDD VDD pfet_03v3 L=6u W=1u nf=1
XMB_f11 net1 Vgs VDD VDD pfet_03v3 L=6u W=1u nf=1
XMB_f12 net1 Vgs VDD VDD pfet_03v3 L=6u W=1u nf=1
XMB_f13 net1 Vgs VDD VDD pfet_03v3 L=6u W=1u nf=1
XM1 net2 Vgs VDD VDD pfet_03v3 L=6u W=1u nf=1
XM2_f0 net3 Vgs VDD VDD pfet_03v3 L=6u W=1u nf=1
XM2_f1 net3 Vgs VDD VDD pfet_03v3 L=6u W=1u nf=1
XM3_f0 net4 Vgs VDD VDD pfet_03v3 L=6u W=1u nf=1
XM3_f1 net4 Vgs VDD VDD pfet_03v3 L=6u W=1u nf=1
XM3_f2 net4 Vgs VDD VDD pfet_03v3 L=6u W=1u nf=1
XM3_f3 net4 Vgs VDD VDD pfet_03v3 L=6u W=1u nf=1
XM4_f0 net5 Vgs VDD VDD pfet_03v3 L=6u W=1u nf=1
XM4_f1 net5 Vgs VDD VDD pfet_03v3 L=6u W=1u nf=1
XM4_f2 net5 Vgs VDD VDD pfet_03v3 L=6u W=1u nf=1
XM4_f3 net5 Vgs VDD VDD pfet_03v3 L=6u W=1u nf=1
XM4_f4 net5 Vgs VDD VDD pfet_03v3 L=6u W=1u nf=1
XM4_f5 net5 Vgs VDD VDD pfet_03v3 L=6u W=1u nf=1
XM4_f6 net5 Vgs VDD VDD pfet_03v3 L=6u W=1u nf=1
XM4_f7 net5 Vgs VDD VDD pfet_03v3 L=6u W=1u nf=1
XMIP0 tb0 trim[0] VDD VDD pfet_03v3 L=0.28u W=1u nf=1
XMIP1 tb1 trim[1] VDD VDD pfet_03v3 L=0.28u W=1u nf=1
XMIP2 tb2 trim[2] VDD VDD pfet_03v3 L=0.28u W=1u nf=1
XMIP3 tb3 trim[3] VDD VDD pfet_03v3 L=0.28u W=1u nf=1
XMIPC calb cal VDD VDD pfet_03v3 L=0.28u W=1u nf=1
XM0_f0 Iref Iref VDD VDD pfet_03v3 L=6u W=1u nf=1
XM0_f1 Iref Iref VDD VDD pfet_03v3 L=6u W=1u nf=1
XM0_f2 Iref Iref VDD VDD pfet_03v3 L=6u W=1u nf=1
XM0_f3 Iref Iref VDD VDD pfet_03v3 L=6u W=1u nf=1
XM0_f4 Iref Iref VDD VDD pfet_03v3 L=6u W=1u nf=1
XM0_f5 Iref Iref VDD VDD pfet_03v3 L=6u W=1u nf=1
XM0_f6 Iref Iref VDD VDD pfet_03v3 L=6u W=1u nf=1
XM0_f7 Iref Iref VDD VDD pfet_03v3 L=6u W=1u nf=1
XM0_f8 Iref Iref VDD VDD pfet_03v3 L=6u W=1u nf=1
XM0_f9 Iref Iref VDD VDD pfet_03v3 L=6u W=1u nf=1
XM0_f10 Iref Iref VDD VDD pfet_03v3 L=6u W=1u nf=1
XM0_f11 Iref Iref VDD VDD pfet_03v3 L=6u W=1u nf=1
XM0_f12 Iref Iref VDD VDD pfet_03v3 L=6u W=1u nf=1
XM0_f13 Iref Iref VDD VDD pfet_03v3 L=6u W=1u nf=1
XM0_f14 Iref Iref VDD VDD pfet_03v3 L=6u W=1u nf=1
XM0_f15 Iref Iref VDD VDD pfet_03v3 L=6u W=1u nf=1
XM0_f16 Iref Iref VDD VDD pfet_03v3 L=6u W=1u nf=1
XM0_f17 Iref Iref VDD VDD pfet_03v3 L=6u W=1u nf=1
XM0_f18 Iref Iref VDD VDD pfet_03v3 L=6u W=1u nf=1
XM0_f19 Iref Iref VDD VDD pfet_03v3 L=6u W=1u nf=1
XM0_f20 Iref Iref VDD VDD pfet_03v3 L=6u W=1u nf=1
XM0_f21 Iref Iref VDD VDD pfet_03v3 L=6u W=1u nf=1
XM0_f22 Iref Iref VDD VDD pfet_03v3 L=6u W=1u nf=1
XMCG VDD Vgs VDD VDD pfet_03v3 L=10u W=10u nf=1
XR0_s0 Iref R0_j0 VSS nwell r_width=2e-6 r_length=50e-6
XR0_s1 R0_j0 R0_j1 VSS nwell r_width=2e-6 r_length=50e-6
XR0_s2 R0_j1 Vgs VSS nwell r_width=2e-6 r_length=50e-6
XDNN0 VSS VSS VSS VSS nfet_03v3 L=2u W=0.5u nf=1
XDNN1 VSS VSS VSS VSS nfet_03v3 L=2u W=0.5u nf=1
XDNN2 VSS VSS VSS VSS nfet_03v3 L=2u W=0.5u nf=1
XDNN3 VSS VSS VSS VSS nfet_03v3 L=2u W=0.5u nf=1
XDNN4 VSS VSS VSS VSS nfet_03v3 L=2u W=0.5u nf=1
XDNN5 VSS VSS VSS VSS nfet_03v3 L=2u W=0.5u nf=1
XDNN6 VSS VSS VSS VSS nfet_03v3 L=2u W=0.5u nf=1
XDNN7 VSS VSS VSS VSS nfet_03v3 L=2u W=0.5u nf=1
XDNN8 VSS VSS VSS VSS nfet_03v3 L=2u W=0.5u nf=1
XDNN9 VSS VSS VSS VSS nfet_03v3 L=2u W=0.5u nf=1
XDNN10 VSS VSS VSS VSS nfet_03v3 L=2u W=0.5u nf=1
XDNN11 VSS VSS VSS VSS nfet_03v3 L=2u W=0.5u nf=1
XDNN12 VSS VSS VSS VSS nfet_03v3 L=2u W=0.5u nf=1
XDNN13 VSS VSS VSS VSS nfet_03v3 L=2u W=0.5u nf=1
XDNN14 VSS VSS VSS VSS nfet_03v3 L=2u W=0.5u nf=1
XDNN15 VSS VSS VSS VSS nfet_03v3 L=2u W=0.5u nf=1
XDNN16 VSS VSS VSS VSS nfet_03v3 L=2u W=0.5u nf=1
XDNN17 VSS VSS VSS VSS nfet_03v3 L=2u W=0.5u nf=1
XDNN18 VSS VSS VSS VSS nfet_03v3 L=2u W=0.5u nf=1
XDNN19 VSS VSS VSS VSS nfet_03v3 L=2u W=0.5u nf=1
XDNN20 VSS VSS VSS VSS nfet_03v3 L=2u W=0.5u nf=1
XDNN21 VSS VSS VSS VSS nfet_03v3 L=2u W=0.5u nf=1
XDNN22 VSS VSS VSS VSS nfet_03v3 L=2u W=0.5u nf=1
XDNN23 VSS VSS VSS VSS nfet_03v3 L=2u W=0.5u nf=1
XDNN24 VSS VSS VSS VSS nfet_03v3 L=2u W=0.5u nf=1
XDNN25 VSS VSS VSS VSS nfet_03v3 L=2u W=0.5u nf=1
XDNN26 VSS VSS VSS VSS nfet_03v3 L=2u W=0.5u nf=1
XDNN27 VSS VSS VSS VSS nfet_03v3 L=2u W=0.5u nf=1
XDNN28 VSS VSS VSS VSS nfet_03v3 L=2u W=0.5u nf=1
XDNN29 VSS VSS VSS VSS nfet_03v3 L=2u W=0.5u nf=1
XDNN30 VSS VSS VSS VSS nfet_03v3 L=2u W=0.5u nf=1
XDNN31 VSS VSS VSS VSS nfet_03v3 L=2u W=0.5u nf=1
XDNN32 VSS VSS VSS VSS nfet_03v3 L=2u W=0.5u nf=1
XDNN33 VSS VSS VSS VSS nfet_03v3 L=2u W=0.5u nf=1
XDNN34 VSS VSS VSS VSS nfet_03v3 L=2u W=0.5u nf=1
XDNN35 VSS VSS VSS VSS nfet_03v3 L=2u W=0.5u nf=1
XDNN36 VSS VSS VSS VSS nfet_03v3 L=2u W=0.5u nf=1
XDNN37 VSS VSS VSS VSS nfet_03v3 L=2u W=0.5u nf=1
XDNN38 VSS VSS VSS VSS nfet_03v3 L=2u W=0.5u nf=1
XDNN39 VSS VSS VSS VSS nfet_03v3 L=2u W=0.5u nf=1
XDNN40 VSS VSS VSS VSS nfet_03v3 L=2u W=0.5u nf=1
XDNN41 VSS VSS VSS VSS nfet_03v3 L=2u W=0.5u nf=1
XDNN42 VSS VSS VSS VSS nfet_03v3 L=2u W=0.5u nf=1
XDNN43 VSS VSS VSS VSS nfet_03v3 L=2u W=0.5u nf=1
XDNN44 VSS VSS VSS VSS nfet_03v3 L=2u W=0.5u nf=1
XDNN45 VSS VSS VSS VSS nfet_03v3 L=2u W=0.5u nf=1
XDNS0 VSS VSS VSS VSS nfet_03v3 L=2u W=0.5u nf=1
XDNS1 VSS VSS VSS VSS nfet_03v3 L=2u W=0.5u nf=1
XDNS2 VSS VSS VSS VSS nfet_03v3 L=2u W=0.5u nf=1
XDNS3 VSS VSS VSS VSS nfet_03v3 L=2u W=0.5u nf=1
XDNS4 VSS VSS VSS VSS nfet_03v3 L=2u W=0.5u nf=1
XDNS5 VSS VSS VSS VSS nfet_03v3 L=2u W=0.5u nf=1
XDNS6 VSS VSS VSS VSS nfet_03v3 L=2u W=0.5u nf=1
XDNS7 VSS VSS VSS VSS nfet_03v3 L=2u W=0.5u nf=1
XDNS8 VSS VSS VSS VSS nfet_03v3 L=2u W=0.5u nf=1
XDNS9 VSS VSS VSS VSS nfet_03v3 L=2u W=0.5u nf=1
XDNS10 VSS VSS VSS VSS nfet_03v3 L=2u W=0.5u nf=1
XDNS11 VSS VSS VSS VSS nfet_03v3 L=2u W=0.5u nf=1
XDNS12 VSS VSS VSS VSS nfet_03v3 L=2u W=0.5u nf=1
XDNS13 VSS VSS VSS VSS nfet_03v3 L=2u W=0.5u nf=1
XDNS14 VSS VSS VSS VSS nfet_03v3 L=2u W=0.5u nf=1
XDNS15 VSS VSS VSS VSS nfet_03v3 L=2u W=0.5u nf=1
XDNS16 VSS VSS VSS VSS nfet_03v3 L=2u W=0.5u nf=1
XDNS17 VSS VSS VSS VSS nfet_03v3 L=2u W=0.5u nf=1
XDNS18 VSS VSS VSS VSS nfet_03v3 L=2u W=0.5u nf=1
XDNS19 VSS VSS VSS VSS nfet_03v3 L=2u W=0.5u nf=1
XDNS20 VSS VSS VSS VSS nfet_03v3 L=2u W=0.5u nf=1
XDNS21 VSS VSS VSS VSS nfet_03v3 L=2u W=0.5u nf=1
XDNS22 VSS VSS VSS VSS nfet_03v3 L=2u W=0.5u nf=1
XDNS23 VSS VSS VSS VSS nfet_03v3 L=2u W=0.5u nf=1
XDNS24 VSS VSS VSS VSS nfet_03v3 L=2u W=0.5u nf=1
XDNS25 VSS VSS VSS VSS nfet_03v3 L=2u W=0.5u nf=1
XDNS26 VSS VSS VSS VSS nfet_03v3 L=2u W=0.5u nf=1
XDNS27 VSS VSS VSS VSS nfet_03v3 L=2u W=0.5u nf=1
XDNS28 VSS VSS VSS VSS nfet_03v3 L=2u W=0.5u nf=1
XDNS29 VSS VSS VSS VSS nfet_03v3 L=2u W=0.5u nf=1
XDNS30 VSS VSS VSS VSS nfet_03v3 L=2u W=0.5u nf=1
XDNS31 VSS VSS VSS VSS nfet_03v3 L=2u W=0.5u nf=1
XDNS32 VSS VSS VSS VSS nfet_03v3 L=2u W=0.5u nf=1
XDNS33 VSS VSS VSS VSS nfet_03v3 L=2u W=0.5u nf=1
XDNS34 VSS VSS VSS VSS nfet_03v3 L=2u W=0.5u nf=1
XDNS35 VSS VSS VSS VSS nfet_03v3 L=2u W=0.5u nf=1
XDNS36 VSS VSS VSS VSS nfet_03v3 L=2u W=0.5u nf=1
XDNS37 VSS VSS VSS VSS nfet_03v3 L=2u W=0.5u nf=1
XDNS38 VSS VSS VSS VSS nfet_03v3 L=2u W=0.5u nf=1
XDNS39 VSS VSS VSS VSS nfet_03v3 L=2u W=0.5u nf=1
XDNS40 VSS VSS VSS VSS nfet_03v3 L=2u W=0.5u nf=1
XDNS41 VSS VSS VSS VSS nfet_03v3 L=2u W=0.5u nf=1
XDNS42 VSS VSS VSS VSS nfet_03v3 L=2u W=0.5u nf=1
XDNS43 VSS VSS VSS VSS nfet_03v3 L=2u W=0.5u nf=1
XDNS44 VSS VSS VSS VSS nfet_03v3 L=2u W=0.5u nf=1
XDNS45 VSS VSS VSS VSS nfet_03v3 L=2u W=0.5u nf=1
XDNW0 VSS VSS VSS VSS nfet_03v3 L=2u W=10u nf=1
XDNE0 VSS VSS VSS VSS nfet_03v3 L=2u W=10u nf=1
XDPN0 VDD VDD VDD VDD pfet_03v3 L=2u W=0.5u nf=1
XDPN1 VDD VDD VDD VDD pfet_03v3 L=2u W=0.5u nf=1
XDPN2 VDD VDD VDD VDD pfet_03v3 L=2u W=0.5u nf=1
XDPN3 VDD VDD VDD VDD pfet_03v3 L=2u W=0.5u nf=1
XDPN4 VDD VDD VDD VDD pfet_03v3 L=2u W=0.5u nf=1
XDPN5 VDD VDD VDD VDD pfet_03v3 L=2u W=0.5u nf=1
XDPN6 VDD VDD VDD VDD pfet_03v3 L=2u W=0.5u nf=1
XDPN7 VDD VDD VDD VDD pfet_03v3 L=2u W=0.5u nf=1
XDPN8 VDD VDD VDD VDD pfet_03v3 L=2u W=0.5u nf=1
XDPN9 VDD VDD VDD VDD pfet_03v3 L=2u W=0.5u nf=1
XDPN10 VDD VDD VDD VDD pfet_03v3 L=2u W=0.5u nf=1
XDPN11 VDD VDD VDD VDD pfet_03v3 L=2u W=0.5u nf=1
XDPN12 VDD VDD VDD VDD pfet_03v3 L=2u W=0.5u nf=1
XDPN13 VDD VDD VDD VDD pfet_03v3 L=2u W=0.5u nf=1
XDPN14 VDD VDD VDD VDD pfet_03v3 L=2u W=0.5u nf=1
XDPN15 VDD VDD VDD VDD pfet_03v3 L=2u W=0.5u nf=1
XDPN16 VDD VDD VDD VDD pfet_03v3 L=2u W=0.5u nf=1
XDPN17 VDD VDD VDD VDD pfet_03v3 L=2u W=0.5u nf=1
XDPN18 VDD VDD VDD VDD pfet_03v3 L=2u W=0.5u nf=1
XDPN19 VDD VDD VDD VDD pfet_03v3 L=2u W=0.5u nf=1
XDPN20 VDD VDD VDD VDD pfet_03v3 L=2u W=0.5u nf=1
XDPN21 VDD VDD VDD VDD pfet_03v3 L=2u W=0.5u nf=1
XDPN22 VDD VDD VDD VDD pfet_03v3 L=2u W=0.5u nf=1
XDPN23 VDD VDD VDD VDD pfet_03v3 L=2u W=0.5u nf=1
XDPN24 VDD VDD VDD VDD pfet_03v3 L=2u W=0.5u nf=1
XDPN25 VDD VDD VDD VDD pfet_03v3 L=2u W=0.5u nf=1
XDPN26 VDD VDD VDD VDD pfet_03v3 L=2u W=0.5u nf=1
XDPN27 VDD VDD VDD VDD pfet_03v3 L=2u W=0.5u nf=1
XDPN28 VDD VDD VDD VDD pfet_03v3 L=2u W=0.5u nf=1
XDPN29 VDD VDD VDD VDD pfet_03v3 L=2u W=0.5u nf=1
XDPN30 VDD VDD VDD VDD pfet_03v3 L=2u W=0.5u nf=1
XDPN31 VDD VDD VDD VDD pfet_03v3 L=2u W=0.5u nf=1
XDPN32 VDD VDD VDD VDD pfet_03v3 L=2u W=0.5u nf=1
XDPN33 VDD VDD VDD VDD pfet_03v3 L=2u W=0.5u nf=1
XDPN34 VDD VDD VDD VDD pfet_03v3 L=2u W=0.5u nf=1
XDPN35 VDD VDD VDD VDD pfet_03v3 L=2u W=0.5u nf=1
XDPN36 VDD VDD VDD VDD pfet_03v3 L=2u W=0.5u nf=1
XDPN37 VDD VDD VDD VDD pfet_03v3 L=2u W=0.5u nf=1
XDPN38 VDD VDD VDD VDD pfet_03v3 L=2u W=0.5u nf=1
XDPN39 VDD VDD VDD VDD pfet_03v3 L=2u W=0.5u nf=1
XDPN40 VDD VDD VDD VDD pfet_03v3 L=2u W=0.5u nf=1
XDPN41 VDD VDD VDD VDD pfet_03v3 L=2u W=0.5u nf=1
XDPN42 VDD VDD VDD VDD pfet_03v3 L=2u W=0.5u nf=1
XDPN43 VDD VDD VDD VDD pfet_03v3 L=2u W=0.5u nf=1
XDPN44 VDD VDD VDD VDD pfet_03v3 L=2u W=0.5u nf=1
XDPN45 VDD VDD VDD VDD pfet_03v3 L=2u W=0.5u nf=1
XDPN46 VDD VDD VDD VDD pfet_03v3 L=2u W=0.5u nf=1
XDPN47 VDD VDD VDD VDD pfet_03v3 L=2u W=0.5u nf=1
XDPN48 VDD VDD VDD VDD pfet_03v3 L=2u W=0.5u nf=1
XDPN49 VDD VDD VDD VDD pfet_03v3 L=2u W=0.5u nf=1
XDPN50 VDD VDD VDD VDD pfet_03v3 L=2u W=0.5u nf=1
XDPN51 VDD VDD VDD VDD pfet_03v3 L=2u W=0.5u nf=1
XDPN52 VDD VDD VDD VDD pfet_03v3 L=2u W=0.5u nf=1
XDPN53 VDD VDD VDD VDD pfet_03v3 L=2u W=0.5u nf=1
XDPN54 VDD VDD VDD VDD pfet_03v3 L=2u W=0.5u nf=1
XDPN55 VDD VDD VDD VDD pfet_03v3 L=2u W=0.5u nf=1
XDPN56 VDD VDD VDD VDD pfet_03v3 L=2u W=0.5u nf=1
XDPN57 VDD VDD VDD VDD pfet_03v3 L=2u W=0.5u nf=1
XDPN58 VDD VDD VDD VDD pfet_03v3 L=2u W=0.5u nf=1
XDPN59 VDD VDD VDD VDD pfet_03v3 L=2u W=0.5u nf=1
XDPN60 VDD VDD VDD VDD pfet_03v3 L=2u W=0.5u nf=1
XDPN61 VDD VDD VDD VDD pfet_03v3 L=2u W=0.5u nf=1
XDPN62 VDD VDD VDD VDD pfet_03v3 L=2u W=0.5u nf=1
XDPN63 VDD VDD VDD VDD pfet_03v3 L=2u W=0.5u nf=1
XDPN64 VDD VDD VDD VDD pfet_03v3 L=2u W=0.5u nf=1
XDPN65 VDD VDD VDD VDD pfet_03v3 L=2u W=0.5u nf=1
XDPN66 VDD VDD VDD VDD pfet_03v3 L=2u W=0.5u nf=1
XDPN67 VDD VDD VDD VDD pfet_03v3 L=2u W=0.5u nf=1
XDPN68 VDD VDD VDD VDD pfet_03v3 L=2u W=0.5u nf=1
XDPN69 VDD VDD VDD VDD pfet_03v3 L=2u W=0.5u nf=1
XDPN70 VDD VDD VDD VDD pfet_03v3 L=2u W=0.5u nf=1
XDPN71 VDD VDD VDD VDD pfet_03v3 L=2u W=0.5u nf=1
XDPN72 VDD VDD VDD VDD pfet_03v3 L=2u W=0.5u nf=1
XDPN73 VDD VDD VDD VDD pfet_03v3 L=2u W=0.5u nf=1
XDPN74 VDD VDD VDD VDD pfet_03v3 L=2u W=0.5u nf=1
XDPN75 VDD VDD VDD VDD pfet_03v3 L=2u W=0.5u nf=1
XDPN76 VDD VDD VDD VDD pfet_03v3 L=2u W=0.5u nf=1
XDPN77 VDD VDD VDD VDD pfet_03v3 L=2u W=0.5u nf=1
XDPN78 VDD VDD VDD VDD pfet_03v3 L=2u W=0.5u nf=1
XDPN79 VDD VDD VDD VDD pfet_03v3 L=2u W=0.5u nf=1
XDPN80 VDD VDD VDD VDD pfet_03v3 L=2u W=0.5u nf=1
XDPN81 VDD VDD VDD VDD pfet_03v3 L=2u W=0.5u nf=1
XDPN82 VDD VDD VDD VDD pfet_03v3 L=2u W=0.5u nf=1
XDPN83 VDD VDD VDD VDD pfet_03v3 L=2u W=0.5u nf=1
XDPN84 VDD VDD VDD VDD pfet_03v3 L=2u W=0.5u nf=1
XDPN85 VDD VDD VDD VDD pfet_03v3 L=2u W=0.5u nf=1
XDPN86 VDD VDD VDD VDD pfet_03v3 L=2u W=0.5u nf=1
XDPN87 VDD VDD VDD VDD pfet_03v3 L=2u W=0.5u nf=1
XDPN88 VDD VDD VDD VDD pfet_03v3 L=2u W=0.5u nf=1
XDPN89 VDD VDD VDD VDD pfet_03v3 L=2u W=0.5u nf=1
XDPN90 VDD VDD VDD VDD pfet_03v3 L=2u W=0.5u nf=1
XDPN91 VDD VDD VDD VDD pfet_03v3 L=2u W=0.5u nf=1
XDPN92 VDD VDD VDD VDD pfet_03v3 L=2u W=0.5u nf=1
XDPN93 VDD VDD VDD VDD pfet_03v3 L=2u W=0.5u nf=1
XDPN94 VDD VDD VDD VDD pfet_03v3 L=2u W=0.5u nf=1
XDPN95 VDD VDD VDD VDD pfet_03v3 L=2u W=0.5u nf=1
XDPN96 VDD VDD VDD VDD pfet_03v3 L=2u W=0.5u nf=1
XDPN97 VDD VDD VDD VDD pfet_03v3 L=2u W=0.5u nf=1
XDPN98 VDD VDD VDD VDD pfet_03v3 L=2u W=0.5u nf=1
XDPN99 VDD VDD VDD VDD pfet_03v3 L=2u W=0.5u nf=1
XDPN100 VDD VDD VDD VDD pfet_03v3 L=2u W=0.5u nf=1
XDPN101 VDD VDD VDD VDD pfet_03v3 L=2u W=0.5u nf=1
XDPN102 VDD VDD VDD VDD pfet_03v3 L=2u W=0.5u nf=1
XDPN103 VDD VDD VDD VDD pfet_03v3 L=2u W=0.5u nf=1
XDPN104 VDD VDD VDD VDD pfet_03v3 L=2u W=0.5u nf=1
XDPN105 VDD VDD VDD VDD pfet_03v3 L=2u W=0.5u nf=1
XDPN106 VDD VDD VDD VDD pfet_03v3 L=2u W=0.5u nf=1
XDPN107 VDD VDD VDD VDD pfet_03v3 L=2u W=0.5u nf=1
XDPN108 VDD VDD VDD VDD pfet_03v3 L=2u W=0.5u nf=1
XDPN109 VDD VDD VDD VDD pfet_03v3 L=2u W=0.5u nf=1
XDPN110 VDD VDD VDD VDD pfet_03v3 L=2u W=0.5u nf=1
XDPN111 VDD VDD VDD VDD pfet_03v3 L=2u W=0.5u nf=1
XDPN112 VDD VDD VDD VDD pfet_03v3 L=2u W=0.5u nf=1
XDPN113 VDD VDD VDD VDD pfet_03v3 L=2u W=0.5u nf=1
XDPN114 VDD VDD VDD VDD pfet_03v3 L=2u W=0.5u nf=1
XDPN115 VDD VDD VDD VDD pfet_03v3 L=2u W=0.5u nf=1
XDPN116 VDD VDD VDD VDD pfet_03v3 L=2u W=0.5u nf=1
XDPN117 VDD VDD VDD VDD pfet_03v3 L=2u W=0.5u nf=1
XDPN118 VDD VDD VDD VDD pfet_03v3 L=2u W=0.5u nf=1
XDPN119 VDD VDD VDD VDD pfet_03v3 L=2u W=0.5u nf=1
XDPN120 VDD VDD VDD VDD pfet_03v3 L=2u W=0.5u nf=1
XDPN121 VDD VDD VDD VDD pfet_03v3 L=2u W=0.5u nf=1
XDPN122 VDD VDD VDD VDD pfet_03v3 L=2u W=0.5u nf=1
XDPN123 VDD VDD VDD VDD pfet_03v3 L=2u W=0.5u nf=1
XDPN124 VDD VDD VDD VDD pfet_03v3 L=2u W=0.5u nf=1
XDPN125 VDD VDD VDD VDD pfet_03v3 L=2u W=0.5u nf=1
XDPN126 VDD VDD VDD VDD pfet_03v3 L=2u W=0.5u nf=1
XDPN127 VDD VDD VDD VDD pfet_03v3 L=2u W=0.5u nf=1
XDPN128 VDD VDD VDD VDD pfet_03v3 L=2u W=0.5u nf=1
XDPN129 VDD VDD VDD VDD pfet_03v3 L=2u W=0.5u nf=1
XDPN130 VDD VDD VDD VDD pfet_03v3 L=2u W=0.5u nf=1
XDPN131 VDD VDD VDD VDD pfet_03v3 L=2u W=0.5u nf=1
XDPN132 VDD VDD VDD VDD pfet_03v3 L=2u W=0.5u nf=1
XDPN133 VDD VDD VDD VDD pfet_03v3 L=2u W=0.5u nf=1
XDPN134 VDD VDD VDD VDD pfet_03v3 L=2u W=0.5u nf=1
XDPN135 VDD VDD VDD VDD pfet_03v3 L=2u W=0.5u nf=1
XDPN136 VDD VDD VDD VDD pfet_03v3 L=2u W=0.5u nf=1
XDPN137 VDD VDD VDD VDD pfet_03v3 L=2u W=0.5u nf=1
XDPN138 VDD VDD VDD VDD pfet_03v3 L=2u W=0.5u nf=1
XDPN139 VDD VDD VDD VDD pfet_03v3 L=2u W=0.5u nf=1
XDPN140 VDD VDD VDD VDD pfet_03v3 L=2u W=0.5u nf=1
XDPN141 VDD VDD VDD VDD pfet_03v3 L=2u W=0.5u nf=1
XDPN142 VDD VDD VDD VDD pfet_03v3 L=2u W=0.5u nf=1
XDPN143 VDD VDD VDD VDD pfet_03v3 L=2u W=0.5u nf=1
XDPN144 VDD VDD VDD VDD pfet_03v3 L=2u W=0.5u nf=1
XDPN145 VDD VDD VDD VDD pfet_03v3 L=2u W=0.5u nf=1
XDPN146 VDD VDD VDD VDD pfet_03v3 L=2u W=0.5u nf=1
XDPN147 VDD VDD VDD VDD pfet_03v3 L=2u W=0.5u nf=1
XDPN148 VDD VDD VDD VDD pfet_03v3 L=2u W=0.5u nf=1
XDPN149 VDD VDD VDD VDD pfet_03v3 L=2u W=0.5u nf=1
XDPN150 VDD VDD VDD VDD pfet_03v3 L=2u W=0.5u nf=1
XDPS0 VDD VDD VDD VDD pfet_03v3 L=2u W=0.5u nf=1
XDPS1 VDD VDD VDD VDD pfet_03v3 L=2u W=0.5u nf=1
XDPS2 VDD VDD VDD VDD pfet_03v3 L=2u W=0.5u nf=1
XDPS3 VDD VDD VDD VDD pfet_03v3 L=2u W=0.5u nf=1
XDPS4 VDD VDD VDD VDD pfet_03v3 L=2u W=0.5u nf=1
XDPS5 VDD VDD VDD VDD pfet_03v3 L=2u W=0.5u nf=1
XDPS6 VDD VDD VDD VDD pfet_03v3 L=2u W=0.5u nf=1
XDPS7 VDD VDD VDD VDD pfet_03v3 L=2u W=0.5u nf=1
XDPS8 VDD VDD VDD VDD pfet_03v3 L=2u W=0.5u nf=1
XDPS9 VDD VDD VDD VDD pfet_03v3 L=2u W=0.5u nf=1
XDPS10 VDD VDD VDD VDD pfet_03v3 L=2u W=0.5u nf=1
XDPS11 VDD VDD VDD VDD pfet_03v3 L=2u W=0.5u nf=1
XDPS12 VDD VDD VDD VDD pfet_03v3 L=2u W=0.5u nf=1
XDPS13 VDD VDD VDD VDD pfet_03v3 L=2u W=0.5u nf=1
XDPS14 VDD VDD VDD VDD pfet_03v3 L=2u W=0.5u nf=1
XDPS15 VDD VDD VDD VDD pfet_03v3 L=2u W=0.5u nf=1
XDPS16 VDD VDD VDD VDD pfet_03v3 L=2u W=0.5u nf=1
XDPS17 VDD VDD VDD VDD pfet_03v3 L=2u W=0.5u nf=1
XDPS18 VDD VDD VDD VDD pfet_03v3 L=2u W=0.5u nf=1
XDPS19 VDD VDD VDD VDD pfet_03v3 L=2u W=0.5u nf=1
XDPS20 VDD VDD VDD VDD pfet_03v3 L=2u W=0.5u nf=1
XDPS21 VDD VDD VDD VDD pfet_03v3 L=2u W=0.5u nf=1
XDPS22 VDD VDD VDD VDD pfet_03v3 L=2u W=0.5u nf=1
XDPS23 VDD VDD VDD VDD pfet_03v3 L=2u W=0.5u nf=1
XDPS24 VDD VDD VDD VDD pfet_03v3 L=2u W=0.5u nf=1
XDPS25 VDD VDD VDD VDD pfet_03v3 L=2u W=0.5u nf=1
XDPS26 VDD VDD VDD VDD pfet_03v3 L=2u W=0.5u nf=1
XDPS27 VDD VDD VDD VDD pfet_03v3 L=2u W=0.5u nf=1
XDPS28 VDD VDD VDD VDD pfet_03v3 L=2u W=0.5u nf=1
XDPS29 VDD VDD VDD VDD pfet_03v3 L=2u W=0.5u nf=1
XDPS30 VDD VDD VDD VDD pfet_03v3 L=2u W=0.5u nf=1
XDPS31 VDD VDD VDD VDD pfet_03v3 L=2u W=0.5u nf=1
XDPS32 VDD VDD VDD VDD pfet_03v3 L=2u W=0.5u nf=1
XDPS33 VDD VDD VDD VDD pfet_03v3 L=2u W=0.5u nf=1
XDPS34 VDD VDD VDD VDD pfet_03v3 L=2u W=0.5u nf=1
XDPS35 VDD VDD VDD VDD pfet_03v3 L=2u W=0.5u nf=1
XDPS36 VDD VDD VDD VDD pfet_03v3 L=2u W=0.5u nf=1
XDPS37 VDD VDD VDD VDD pfet_03v3 L=2u W=0.5u nf=1
XDPS38 VDD VDD VDD VDD pfet_03v3 L=2u W=0.5u nf=1
XDPS39 VDD VDD VDD VDD pfet_03v3 L=2u W=0.5u nf=1
XDPS40 VDD VDD VDD VDD pfet_03v3 L=2u W=0.5u nf=1
XDPS41 VDD VDD VDD VDD pfet_03v3 L=2u W=0.5u nf=1
XDPS42 VDD VDD VDD VDD pfet_03v3 L=2u W=0.5u nf=1
XDPS43 VDD VDD VDD VDD pfet_03v3 L=2u W=0.5u nf=1
XDPS44 VDD VDD VDD VDD pfet_03v3 L=2u W=0.5u nf=1
XDPS45 VDD VDD VDD VDD pfet_03v3 L=2u W=0.5u nf=1
XDPS46 VDD VDD VDD VDD pfet_03v3 L=2u W=0.5u nf=1
XDPS47 VDD VDD VDD VDD pfet_03v3 L=2u W=0.5u nf=1
XDPS48 VDD VDD VDD VDD pfet_03v3 L=2u W=0.5u nf=1
XDPS49 VDD VDD VDD VDD pfet_03v3 L=2u W=0.5u nf=1
XDPS50 VDD VDD VDD VDD pfet_03v3 L=2u W=0.5u nf=1
XDPS51 VDD VDD VDD VDD pfet_03v3 L=2u W=0.5u nf=1
XDPS52 VDD VDD VDD VDD pfet_03v3 L=2u W=0.5u nf=1
XDPS53 VDD VDD VDD VDD pfet_03v3 L=2u W=0.5u nf=1
XDPS54 VDD VDD VDD VDD pfet_03v3 L=2u W=0.5u nf=1
XDPS55 VDD VDD VDD VDD pfet_03v3 L=2u W=0.5u nf=1
XDPS56 VDD VDD VDD VDD pfet_03v3 L=2u W=0.5u nf=1
XDPS57 VDD VDD VDD VDD pfet_03v3 L=2u W=0.5u nf=1
XDPS58 VDD VDD VDD VDD pfet_03v3 L=2u W=0.5u nf=1
XDPS59 VDD VDD VDD VDD pfet_03v3 L=2u W=0.5u nf=1
XDPS60 VDD VDD VDD VDD pfet_03v3 L=2u W=0.5u nf=1
XDPS61 VDD VDD VDD VDD pfet_03v3 L=2u W=0.5u nf=1
XDPS62 VDD VDD VDD VDD pfet_03v3 L=2u W=0.5u nf=1
XDPS63 VDD VDD VDD VDD pfet_03v3 L=2u W=0.5u nf=1
XDPS64 VDD VDD VDD VDD pfet_03v3 L=2u W=0.5u nf=1
XDPS65 VDD VDD VDD VDD pfet_03v3 L=2u W=0.5u nf=1
XDPS66 VDD VDD VDD VDD pfet_03v3 L=2u W=0.5u nf=1
XDPS67 VDD VDD VDD VDD pfet_03v3 L=2u W=0.5u nf=1
XDPS68 VDD VDD VDD VDD pfet_03v3 L=2u W=0.5u nf=1
XDPS69 VDD VDD VDD VDD pfet_03v3 L=2u W=0.5u nf=1
XDPS70 VDD VDD VDD VDD pfet_03v3 L=2u W=0.5u nf=1
XDPS71 VDD VDD VDD VDD pfet_03v3 L=2u W=0.5u nf=1
XDPS72 VDD VDD VDD VDD pfet_03v3 L=2u W=0.5u nf=1
XDPS73 VDD VDD VDD VDD pfet_03v3 L=2u W=0.5u nf=1
XDPS74 VDD VDD VDD VDD pfet_03v3 L=2u W=0.5u nf=1
XDPS75 VDD VDD VDD VDD pfet_03v3 L=2u W=0.5u nf=1
XDPS76 VDD VDD VDD VDD pfet_03v3 L=2u W=0.5u nf=1
XDPS77 VDD VDD VDD VDD pfet_03v3 L=2u W=0.5u nf=1
XDPS78 VDD VDD VDD VDD pfet_03v3 L=2u W=0.5u nf=1
XDPS79 VDD VDD VDD VDD pfet_03v3 L=2u W=0.5u nf=1
XDPS80 VDD VDD VDD VDD pfet_03v3 L=2u W=0.5u nf=1
XDPS81 VDD VDD VDD VDD pfet_03v3 L=2u W=0.5u nf=1
XDPS82 VDD VDD VDD VDD pfet_03v3 L=2u W=0.5u nf=1
XDPS83 VDD VDD VDD VDD pfet_03v3 L=2u W=0.5u nf=1
XDPS84 VDD VDD VDD VDD pfet_03v3 L=2u W=0.5u nf=1
XDPS85 VDD VDD VDD VDD pfet_03v3 L=2u W=0.5u nf=1
XDPS86 VDD VDD VDD VDD pfet_03v3 L=2u W=0.5u nf=1
XDPS87 VDD VDD VDD VDD pfet_03v3 L=2u W=0.5u nf=1
XDPS88 VDD VDD VDD VDD pfet_03v3 L=2u W=0.5u nf=1
XDPS89 VDD VDD VDD VDD pfet_03v3 L=2u W=0.5u nf=1
XDPS90 VDD VDD VDD VDD pfet_03v3 L=2u W=0.5u nf=1
XDPS91 VDD VDD VDD VDD pfet_03v3 L=2u W=0.5u nf=1
XDPS92 VDD VDD VDD VDD pfet_03v3 L=2u W=0.5u nf=1
XDPS93 VDD VDD VDD VDD pfet_03v3 L=2u W=0.5u nf=1
XDPS94 VDD VDD VDD VDD pfet_03v3 L=2u W=0.5u nf=1
XDPS95 VDD VDD VDD VDD pfet_03v3 L=2u W=0.5u nf=1
XDPS96 VDD VDD VDD VDD pfet_03v3 L=2u W=0.5u nf=1
XDPS97 VDD VDD VDD VDD pfet_03v3 L=2u W=0.5u nf=1
XDPS98 VDD VDD VDD VDD pfet_03v3 L=2u W=0.5u nf=1
XDPS99 VDD VDD VDD VDD pfet_03v3 L=2u W=0.5u nf=1
XDPS100 VDD VDD VDD VDD pfet_03v3 L=2u W=0.5u nf=1
XDPS101 VDD VDD VDD VDD pfet_03v3 L=2u W=0.5u nf=1
XDPS102 VDD VDD VDD VDD pfet_03v3 L=2u W=0.5u nf=1
XDPS103 VDD VDD VDD VDD pfet_03v3 L=2u W=0.5u nf=1
XDPS104 VDD VDD VDD VDD pfet_03v3 L=2u W=0.5u nf=1
XDPS105 VDD VDD VDD VDD pfet_03v3 L=2u W=0.5u nf=1
XDPS106 VDD VDD VDD VDD pfet_03v3 L=2u W=0.5u nf=1
XDPS107 VDD VDD VDD VDD pfet_03v3 L=2u W=0.5u nf=1
XDPS108 VDD VDD VDD VDD pfet_03v3 L=2u W=0.5u nf=1
XDPS109 VDD VDD VDD VDD pfet_03v3 L=2u W=0.5u nf=1
XDPS110 VDD VDD VDD VDD pfet_03v3 L=2u W=0.5u nf=1
XDPS111 VDD VDD VDD VDD pfet_03v3 L=2u W=0.5u nf=1
XDPS112 VDD VDD VDD VDD pfet_03v3 L=2u W=0.5u nf=1
XDPS113 VDD VDD VDD VDD pfet_03v3 L=2u W=0.5u nf=1
XDPS114 VDD VDD VDD VDD pfet_03v3 L=2u W=0.5u nf=1
XDPS115 VDD VDD VDD VDD pfet_03v3 L=2u W=0.5u nf=1
XDPS116 VDD VDD VDD VDD pfet_03v3 L=2u W=0.5u nf=1
XDPS117 VDD VDD VDD VDD pfet_03v3 L=2u W=0.5u nf=1
XDPS118 VDD VDD VDD VDD pfet_03v3 L=2u W=0.5u nf=1
XDPS119 VDD VDD VDD VDD pfet_03v3 L=2u W=0.5u nf=1
XDPS120 VDD VDD VDD VDD pfet_03v3 L=2u W=0.5u nf=1
XDPS121 VDD VDD VDD VDD pfet_03v3 L=2u W=0.5u nf=1
XDPS122 VDD VDD VDD VDD pfet_03v3 L=2u W=0.5u nf=1
XDPS123 VDD VDD VDD VDD pfet_03v3 L=2u W=0.5u nf=1
XDPS124 VDD VDD VDD VDD pfet_03v3 L=2u W=0.5u nf=1
XDPS125 VDD VDD VDD VDD pfet_03v3 L=2u W=0.5u nf=1
XDPS126 VDD VDD VDD VDD pfet_03v3 L=2u W=0.5u nf=1
XDPS127 VDD VDD VDD VDD pfet_03v3 L=2u W=0.5u nf=1
XDPS128 VDD VDD VDD VDD pfet_03v3 L=2u W=0.5u nf=1
XDPS129 VDD VDD VDD VDD pfet_03v3 L=2u W=0.5u nf=1
XDPS130 VDD VDD VDD VDD pfet_03v3 L=2u W=0.5u nf=1
XDPS131 VDD VDD VDD VDD pfet_03v3 L=2u W=0.5u nf=1
XDPS132 VDD VDD VDD VDD pfet_03v3 L=2u W=0.5u nf=1
XDPS133 VDD VDD VDD VDD pfet_03v3 L=2u W=0.5u nf=1
XDPS134 VDD VDD VDD VDD pfet_03v3 L=2u W=0.5u nf=1
XDPS135 VDD VDD VDD VDD pfet_03v3 L=2u W=0.5u nf=1
XDPS136 VDD VDD VDD VDD pfet_03v3 L=2u W=0.5u nf=1
XDPS137 VDD VDD VDD VDD pfet_03v3 L=2u W=0.5u nf=1
XDPS138 VDD VDD VDD VDD pfet_03v3 L=2u W=0.5u nf=1
XDPS139 VDD VDD VDD VDD pfet_03v3 L=2u W=0.5u nf=1
XDPS140 VDD VDD VDD VDD pfet_03v3 L=2u W=0.5u nf=1
XDPS141 VDD VDD VDD VDD pfet_03v3 L=2u W=0.5u nf=1
XDPS142 VDD VDD VDD VDD pfet_03v3 L=2u W=0.5u nf=1
XDPS143 VDD VDD VDD VDD pfet_03v3 L=2u W=0.5u nf=1
XDPS144 VDD VDD VDD VDD pfet_03v3 L=2u W=0.5u nf=1
XDPS145 VDD VDD VDD VDD pfet_03v3 L=2u W=0.5u nf=1
XDPS146 VDD VDD VDD VDD pfet_03v3 L=2u W=0.5u nf=1
XDPS147 VDD VDD VDD VDD pfet_03v3 L=2u W=0.5u nf=1
XDPS148 VDD VDD VDD VDD pfet_03v3 L=2u W=0.5u nf=1
XDPS149 VDD VDD VDD VDD pfet_03v3 L=2u W=0.5u nf=1
XDPS150 VDD VDD VDD VDD pfet_03v3 L=2u W=0.5u nf=1
XDPW0 VDD VDD VDD VDD pfet_03v3 L=2u W=10u nf=1
XDPE0 VDD VDD VDD VDD pfet_03v3 L=2u W=10u nf=1
Cpred_Ibias Ibias VSS 5.592e-14
Cpred_Iref Iref VSS 2.811e-13
Cpred_R0_j0 R0_j0 VSS 8.026e-16
Cpred_R0_j1 R0_j1 VSS 8.026e-16
Cpred_Vgs Vgs VSS 1.691e-13
Cpred_aux aux VSS 2.353e-14
Cpred_cal cal VSS 5.396e-14
Cpred_calb calb VSS 1.444e-13
Cpred_net1 net1 VSS 3.008e-14
Cpred_net2 net2 VSS 2.619e-14
Cpred_net3 net3 VSS 2.52e-14
Cpred_net4 net4 VSS 1.978e-14
Cpred_net5 net5 VSS 2.138e-14
Cpred_tb0 tb0 VSS 1.418e-13
Cpred_tb1 tb1 VSS 1.45e-13
Cpred_tb2 tb2 VSS 1.428e-13
Cpred_tb3 tb3 VSS 1.287e-13
Cpred_trim[0] trim[0] VSS 5.906e-14
Cpred_trim[1] trim[1] VSS 6.51e-14
Cpred_trim[2] trim[2] VSS 6.498e-14
Cpred_trim[3] trim[3] VSS 8.849e-14
Cpred_vaux vaux VSS 1.214e-13
.ends
