* LVS reference for trim_steer.gds (glayout_floorplan.two_row)
* note: R0: 2 x 150 um n-well resistor drawn as 3 bars in series (50, 50, 50 um; joints R0_j<k>)
* note: M0: m=23 x nf=1 -> nf=23, m=1 (parallel copies as fingers)
* note: MB: m=14 x nf=1 -> nf=14, m=1 (parallel copies as fingers)
* note: M2: m=2 x nf=1 -> nf=2, m=1 (parallel copies as fingers)
* note: M3: m=4 x nf=1 -> nf=4, m=1 (parallel copies as fingers)
* note: M4: m=8 x nf=1 -> nf=8, m=1 (parallel copies as fingers)
.subckt trim_steer VDD VSS Iref Ibias trim[3] trim[2] trim[1] trim[0] cal
MSB net1 VDD Ibias VSS nfet_03v3 L=0.5u W=1u nf=1
MS0 net2 trim[0] Ibias VSS nfet_03v3 L=0.5u W=1u nf=1
MMAUX aux vaux VSS VSS nfet_03v3 L=8u W=10u nf=1
MS0X net2 tb0 aux VSS nfet_03v3 L=0.5u W=1u nf=1
MS1X net3 tb1 aux VSS nfet_03v3 L=0.5u W=1u nf=1
MS1 net3 trim[1] Ibias VSS nfet_03v3 L=0.5u W=1u nf=1
MS2 net4 trim[2] Ibias VSS nfet_03v3 L=0.5u W=1u nf=1
MMCAL aux cal vaux VSS nfet_03v3 L=0.5u W=1u nf=1
MS2X net4 tb2 aux VSS nfet_03v3 L=0.5u W=1u nf=1
MS3X net5 tb3 aux VSS nfet_03v3 L=0.5u W=1u nf=1
MMIN0 tb0 trim[0] VSS VSS nfet_03v3 L=0.28u W=0.5u nf=1
MMIN1 tb1 trim[1] VSS VSS nfet_03v3 L=0.28u W=0.5u nf=1
MMIN2 tb2 trim[2] VSS VSS nfet_03v3 L=0.28u W=0.5u nf=1
MMIN3 tb3 trim[3] VSS VSS nfet_03v3 L=0.28u W=0.5u nf=1
MMINC calb cal VSS VSS nfet_03v3 L=0.28u W=0.5u nf=1
MS3 net5 trim[3] Ibias VSS nfet_03v3 L=0.5u W=1u nf=1
MMDIS vaux calb VSS VSS nfet_03v3 L=45.45u W=0.5u nf=1
MMCAUX VSS vaux VSS VSS nfet_03v3 L=5u W=5u nf=1
MMB_f0 net1 Vgs VDD VDD pfet_03v3 L=6u W=1u nf=1
MMB_f1 net1 Vgs VDD VDD pfet_03v3 L=6u W=1u nf=1
MMB_f2 net1 Vgs VDD VDD pfet_03v3 L=6u W=1u nf=1
MMB_f3 net1 Vgs VDD VDD pfet_03v3 L=6u W=1u nf=1
MMB_f4 net1 Vgs VDD VDD pfet_03v3 L=6u W=1u nf=1
MMB_f5 net1 Vgs VDD VDD pfet_03v3 L=6u W=1u nf=1
MMB_f6 net1 Vgs VDD VDD pfet_03v3 L=6u W=1u nf=1
MMB_f7 net1 Vgs VDD VDD pfet_03v3 L=6u W=1u nf=1
MMB_f8 net1 Vgs VDD VDD pfet_03v3 L=6u W=1u nf=1
MMB_f9 net1 Vgs VDD VDD pfet_03v3 L=6u W=1u nf=1
MMB_f10 net1 Vgs VDD VDD pfet_03v3 L=6u W=1u nf=1
MMB_f11 net1 Vgs VDD VDD pfet_03v3 L=6u W=1u nf=1
MMB_f12 net1 Vgs VDD VDD pfet_03v3 L=6u W=1u nf=1
MMB_f13 net1 Vgs VDD VDD pfet_03v3 L=6u W=1u nf=1
MM1 net2 Vgs VDD VDD pfet_03v3 L=6u W=1u nf=1
MM2_f0 net3 Vgs VDD VDD pfet_03v3 L=6u W=1u nf=1
MM2_f1 net3 Vgs VDD VDD pfet_03v3 L=6u W=1u nf=1
MM3_f0 net4 Vgs VDD VDD pfet_03v3 L=6u W=1u nf=1
MM3_f1 net4 Vgs VDD VDD pfet_03v3 L=6u W=1u nf=1
MM3_f2 net4 Vgs VDD VDD pfet_03v3 L=6u W=1u nf=1
MM3_f3 net4 Vgs VDD VDD pfet_03v3 L=6u W=1u nf=1
MM4_f0 net5 Vgs VDD VDD pfet_03v3 L=6u W=1u nf=1
MM4_f1 net5 Vgs VDD VDD pfet_03v3 L=6u W=1u nf=1
MM4_f2 net5 Vgs VDD VDD pfet_03v3 L=6u W=1u nf=1
MM4_f3 net5 Vgs VDD VDD pfet_03v3 L=6u W=1u nf=1
MM4_f4 net5 Vgs VDD VDD pfet_03v3 L=6u W=1u nf=1
MM4_f5 net5 Vgs VDD VDD pfet_03v3 L=6u W=1u nf=1
MM4_f6 net5 Vgs VDD VDD pfet_03v3 L=6u W=1u nf=1
MM4_f7 net5 Vgs VDD VDD pfet_03v3 L=6u W=1u nf=1
MMIP0 tb0 trim[0] VDD VDD pfet_03v3 L=0.28u W=1u nf=1
MMIP1 tb1 trim[1] VDD VDD pfet_03v3 L=0.28u W=1u nf=1
MMIP2 tb2 trim[2] VDD VDD pfet_03v3 L=0.28u W=1u nf=1
MMIP3 tb3 trim[3] VDD VDD pfet_03v3 L=0.28u W=1u nf=1
MMIPC calb cal VDD VDD pfet_03v3 L=0.28u W=1u nf=1
MM0_f0 Iref Iref VDD VDD pfet_03v3 L=6u W=1u nf=1
MM0_f1 Iref Iref VDD VDD pfet_03v3 L=6u W=1u nf=1
MM0_f2 Iref Iref VDD VDD pfet_03v3 L=6u W=1u nf=1
MM0_f3 Iref Iref VDD VDD pfet_03v3 L=6u W=1u nf=1
MM0_f4 Iref Iref VDD VDD pfet_03v3 L=6u W=1u nf=1
MM0_f5 Iref Iref VDD VDD pfet_03v3 L=6u W=1u nf=1
MM0_f6 Iref Iref VDD VDD pfet_03v3 L=6u W=1u nf=1
MM0_f7 Iref Iref VDD VDD pfet_03v3 L=6u W=1u nf=1
MM0_f8 Iref Iref VDD VDD pfet_03v3 L=6u W=1u nf=1
MM0_f9 Iref Iref VDD VDD pfet_03v3 L=6u W=1u nf=1
MM0_f10 Iref Iref VDD VDD pfet_03v3 L=6u W=1u nf=1
MM0_f11 Iref Iref VDD VDD pfet_03v3 L=6u W=1u nf=1
MM0_f12 Iref Iref VDD VDD pfet_03v3 L=6u W=1u nf=1
MM0_f13 Iref Iref VDD VDD pfet_03v3 L=6u W=1u nf=1
MM0_f14 Iref Iref VDD VDD pfet_03v3 L=6u W=1u nf=1
MM0_f15 Iref Iref VDD VDD pfet_03v3 L=6u W=1u nf=1
MM0_f16 Iref Iref VDD VDD pfet_03v3 L=6u W=1u nf=1
MM0_f17 Iref Iref VDD VDD pfet_03v3 L=6u W=1u nf=1
MM0_f18 Iref Iref VDD VDD pfet_03v3 L=6u W=1u nf=1
MM0_f19 Iref Iref VDD VDD pfet_03v3 L=6u W=1u nf=1
MM0_f20 Iref Iref VDD VDD pfet_03v3 L=6u W=1u nf=1
MM0_f21 Iref Iref VDD VDD pfet_03v3 L=6u W=1u nf=1
MM0_f22 Iref Iref VDD VDD pfet_03v3 L=6u W=1u nf=1
MMCG VDD Vgs VDD VDD pfet_03v3 L=10u W=10u nf=1
R0_s0 Iref R0_j0 VSS nwell W=2e-6 L=50e-6
R0_s1 R0_j0 R0_j1 VSS nwell W=2e-6 L=50e-6
R0_s2 R0_j1 Vgs VSS nwell W=2e-6 L=50e-6
MDNN0 VSS VSS VSS VSS nfet_03v3 L=2u W=0.5u nf=1
MDNN1 VSS VSS VSS VSS nfet_03v3 L=2u W=0.5u nf=1
MDNN2 VSS VSS VSS VSS nfet_03v3 L=2u W=0.5u nf=1
MDNN3 VSS VSS VSS VSS nfet_03v3 L=2u W=0.5u nf=1
MDNN4 VSS VSS VSS VSS nfet_03v3 L=2u W=0.5u nf=1
MDNN5 VSS VSS VSS VSS nfet_03v3 L=2u W=0.5u nf=1
MDNN6 VSS VSS VSS VSS nfet_03v3 L=2u W=0.5u nf=1
MDNN7 VSS VSS VSS VSS nfet_03v3 L=2u W=0.5u nf=1
MDNN8 VSS VSS VSS VSS nfet_03v3 L=2u W=0.5u nf=1
MDNN9 VSS VSS VSS VSS nfet_03v3 L=2u W=0.5u nf=1
MDNN10 VSS VSS VSS VSS nfet_03v3 L=2u W=0.5u nf=1
MDNN11 VSS VSS VSS VSS nfet_03v3 L=2u W=0.5u nf=1
MDNN12 VSS VSS VSS VSS nfet_03v3 L=2u W=0.5u nf=1
MDNN13 VSS VSS VSS VSS nfet_03v3 L=2u W=0.5u nf=1
MDNN14 VSS VSS VSS VSS nfet_03v3 L=2u W=0.5u nf=1
MDNN15 VSS VSS VSS VSS nfet_03v3 L=2u W=0.5u nf=1
MDNN16 VSS VSS VSS VSS nfet_03v3 L=2u W=0.5u nf=1
MDNN17 VSS VSS VSS VSS nfet_03v3 L=2u W=0.5u nf=1
MDNN18 VSS VSS VSS VSS nfet_03v3 L=2u W=0.5u nf=1
MDNN19 VSS VSS VSS VSS nfet_03v3 L=2u W=0.5u nf=1
MDNN20 VSS VSS VSS VSS nfet_03v3 L=2u W=0.5u nf=1
MDNN21 VSS VSS VSS VSS nfet_03v3 L=2u W=0.5u nf=1
MDNN22 VSS VSS VSS VSS nfet_03v3 L=2u W=0.5u nf=1
MDNN23 VSS VSS VSS VSS nfet_03v3 L=2u W=0.5u nf=1
MDNN24 VSS VSS VSS VSS nfet_03v3 L=2u W=0.5u nf=1
MDNN25 VSS VSS VSS VSS nfet_03v3 L=2u W=0.5u nf=1
MDNN26 VSS VSS VSS VSS nfet_03v3 L=2u W=0.5u nf=1
MDNN27 VSS VSS VSS VSS nfet_03v3 L=2u W=0.5u nf=1
MDNN28 VSS VSS VSS VSS nfet_03v3 L=2u W=0.5u nf=1
MDNN29 VSS VSS VSS VSS nfet_03v3 L=2u W=0.5u nf=1
MDNN30 VSS VSS VSS VSS nfet_03v3 L=2u W=0.5u nf=1
MDNN31 VSS VSS VSS VSS nfet_03v3 L=2u W=0.5u nf=1
MDNN32 VSS VSS VSS VSS nfet_03v3 L=2u W=0.5u nf=1
MDNN33 VSS VSS VSS VSS nfet_03v3 L=2u W=0.5u nf=1
MDNN34 VSS VSS VSS VSS nfet_03v3 L=2u W=0.5u nf=1
MDNN35 VSS VSS VSS VSS nfet_03v3 L=2u W=0.5u nf=1
MDNN36 VSS VSS VSS VSS nfet_03v3 L=2u W=0.5u nf=1
MDNN37 VSS VSS VSS VSS nfet_03v3 L=2u W=0.5u nf=1
MDNN38 VSS VSS VSS VSS nfet_03v3 L=2u W=0.5u nf=1
MDNN39 VSS VSS VSS VSS nfet_03v3 L=2u W=0.5u nf=1
MDNN40 VSS VSS VSS VSS nfet_03v3 L=2u W=0.5u nf=1
MDNN41 VSS VSS VSS VSS nfet_03v3 L=2u W=0.5u nf=1
MDNN42 VSS VSS VSS VSS nfet_03v3 L=2u W=0.5u nf=1
MDNN43 VSS VSS VSS VSS nfet_03v3 L=2u W=0.5u nf=1
MDNN44 VSS VSS VSS VSS nfet_03v3 L=2u W=0.5u nf=1
MDNN45 VSS VSS VSS VSS nfet_03v3 L=2u W=0.5u nf=1
MDNS0 VSS VSS VSS VSS nfet_03v3 L=2u W=0.5u nf=1
MDNS1 VSS VSS VSS VSS nfet_03v3 L=2u W=0.5u nf=1
MDNS2 VSS VSS VSS VSS nfet_03v3 L=2u W=0.5u nf=1
MDNS3 VSS VSS VSS VSS nfet_03v3 L=2u W=0.5u nf=1
MDNS4 VSS VSS VSS VSS nfet_03v3 L=2u W=0.5u nf=1
MDNS5 VSS VSS VSS VSS nfet_03v3 L=2u W=0.5u nf=1
MDNS6 VSS VSS VSS VSS nfet_03v3 L=2u W=0.5u nf=1
MDNS7 VSS VSS VSS VSS nfet_03v3 L=2u W=0.5u nf=1
MDNS8 VSS VSS VSS VSS nfet_03v3 L=2u W=0.5u nf=1
MDNS9 VSS VSS VSS VSS nfet_03v3 L=2u W=0.5u nf=1
MDNS10 VSS VSS VSS VSS nfet_03v3 L=2u W=0.5u nf=1
MDNS11 VSS VSS VSS VSS nfet_03v3 L=2u W=0.5u nf=1
MDNS12 VSS VSS VSS VSS nfet_03v3 L=2u W=0.5u nf=1
MDNS13 VSS VSS VSS VSS nfet_03v3 L=2u W=0.5u nf=1
MDNS14 VSS VSS VSS VSS nfet_03v3 L=2u W=0.5u nf=1
MDNS15 VSS VSS VSS VSS nfet_03v3 L=2u W=0.5u nf=1
MDNS16 VSS VSS VSS VSS nfet_03v3 L=2u W=0.5u nf=1
MDNS17 VSS VSS VSS VSS nfet_03v3 L=2u W=0.5u nf=1
MDNS18 VSS VSS VSS VSS nfet_03v3 L=2u W=0.5u nf=1
MDNS19 VSS VSS VSS VSS nfet_03v3 L=2u W=0.5u nf=1
MDNS20 VSS VSS VSS VSS nfet_03v3 L=2u W=0.5u nf=1
MDNS21 VSS VSS VSS VSS nfet_03v3 L=2u W=0.5u nf=1
MDNS22 VSS VSS VSS VSS nfet_03v3 L=2u W=0.5u nf=1
MDNS23 VSS VSS VSS VSS nfet_03v3 L=2u W=0.5u nf=1
MDNS24 VSS VSS VSS VSS nfet_03v3 L=2u W=0.5u nf=1
MDNS25 VSS VSS VSS VSS nfet_03v3 L=2u W=0.5u nf=1
MDNS26 VSS VSS VSS VSS nfet_03v3 L=2u W=0.5u nf=1
MDNS27 VSS VSS VSS VSS nfet_03v3 L=2u W=0.5u nf=1
MDNS28 VSS VSS VSS VSS nfet_03v3 L=2u W=0.5u nf=1
MDNS29 VSS VSS VSS VSS nfet_03v3 L=2u W=0.5u nf=1
MDNS30 VSS VSS VSS VSS nfet_03v3 L=2u W=0.5u nf=1
MDNS31 VSS VSS VSS VSS nfet_03v3 L=2u W=0.5u nf=1
MDNS32 VSS VSS VSS VSS nfet_03v3 L=2u W=0.5u nf=1
MDNS33 VSS VSS VSS VSS nfet_03v3 L=2u W=0.5u nf=1
MDNS34 VSS VSS VSS VSS nfet_03v3 L=2u W=0.5u nf=1
MDNS35 VSS VSS VSS VSS nfet_03v3 L=2u W=0.5u nf=1
MDNS36 VSS VSS VSS VSS nfet_03v3 L=2u W=0.5u nf=1
MDNS37 VSS VSS VSS VSS nfet_03v3 L=2u W=0.5u nf=1
MDNS38 VSS VSS VSS VSS nfet_03v3 L=2u W=0.5u nf=1
MDNS39 VSS VSS VSS VSS nfet_03v3 L=2u W=0.5u nf=1
MDNS40 VSS VSS VSS VSS nfet_03v3 L=2u W=0.5u nf=1
MDNS41 VSS VSS VSS VSS nfet_03v3 L=2u W=0.5u nf=1
MDNS42 VSS VSS VSS VSS nfet_03v3 L=2u W=0.5u nf=1
MDNS43 VSS VSS VSS VSS nfet_03v3 L=2u W=0.5u nf=1
MDNS44 VSS VSS VSS VSS nfet_03v3 L=2u W=0.5u nf=1
MDNS45 VSS VSS VSS VSS nfet_03v3 L=2u W=0.5u nf=1
MDNW0 VSS VSS VSS VSS nfet_03v3 L=2u W=10u nf=1
MDNE0 VSS VSS VSS VSS nfet_03v3 L=2u W=10u nf=1
MDPN0 VDD VDD VDD VDD pfet_03v3 L=2u W=0.5u nf=1
MDPN1 VDD VDD VDD VDD pfet_03v3 L=2u W=0.5u nf=1
MDPN2 VDD VDD VDD VDD pfet_03v3 L=2u W=0.5u nf=1
MDPN3 VDD VDD VDD VDD pfet_03v3 L=2u W=0.5u nf=1
MDPN4 VDD VDD VDD VDD pfet_03v3 L=2u W=0.5u nf=1
MDPN5 VDD VDD VDD VDD pfet_03v3 L=2u W=0.5u nf=1
MDPN6 VDD VDD VDD VDD pfet_03v3 L=2u W=0.5u nf=1
MDPN7 VDD VDD VDD VDD pfet_03v3 L=2u W=0.5u nf=1
MDPN8 VDD VDD VDD VDD pfet_03v3 L=2u W=0.5u nf=1
MDPN9 VDD VDD VDD VDD pfet_03v3 L=2u W=0.5u nf=1
MDPN10 VDD VDD VDD VDD pfet_03v3 L=2u W=0.5u nf=1
MDPN11 VDD VDD VDD VDD pfet_03v3 L=2u W=0.5u nf=1
MDPN12 VDD VDD VDD VDD pfet_03v3 L=2u W=0.5u nf=1
MDPN13 VDD VDD VDD VDD pfet_03v3 L=2u W=0.5u nf=1
MDPN14 VDD VDD VDD VDD pfet_03v3 L=2u W=0.5u nf=1
MDPN15 VDD VDD VDD VDD pfet_03v3 L=2u W=0.5u nf=1
MDPN16 VDD VDD VDD VDD pfet_03v3 L=2u W=0.5u nf=1
MDPN17 VDD VDD VDD VDD pfet_03v3 L=2u W=0.5u nf=1
MDPN18 VDD VDD VDD VDD pfet_03v3 L=2u W=0.5u nf=1
MDPN19 VDD VDD VDD VDD pfet_03v3 L=2u W=0.5u nf=1
MDPN20 VDD VDD VDD VDD pfet_03v3 L=2u W=0.5u nf=1
MDPN21 VDD VDD VDD VDD pfet_03v3 L=2u W=0.5u nf=1
MDPN22 VDD VDD VDD VDD pfet_03v3 L=2u W=0.5u nf=1
MDPN23 VDD VDD VDD VDD pfet_03v3 L=2u W=0.5u nf=1
MDPN24 VDD VDD VDD VDD pfet_03v3 L=2u W=0.5u nf=1
MDPN25 VDD VDD VDD VDD pfet_03v3 L=2u W=0.5u nf=1
MDPN26 VDD VDD VDD VDD pfet_03v3 L=2u W=0.5u nf=1
MDPN27 VDD VDD VDD VDD pfet_03v3 L=2u W=0.5u nf=1
MDPN28 VDD VDD VDD VDD pfet_03v3 L=2u W=0.5u nf=1
MDPN29 VDD VDD VDD VDD pfet_03v3 L=2u W=0.5u nf=1
MDPN30 VDD VDD VDD VDD pfet_03v3 L=2u W=0.5u nf=1
MDPN31 VDD VDD VDD VDD pfet_03v3 L=2u W=0.5u nf=1
MDPN32 VDD VDD VDD VDD pfet_03v3 L=2u W=0.5u nf=1
MDPN33 VDD VDD VDD VDD pfet_03v3 L=2u W=0.5u nf=1
MDPN34 VDD VDD VDD VDD pfet_03v3 L=2u W=0.5u nf=1
MDPN35 VDD VDD VDD VDD pfet_03v3 L=2u W=0.5u nf=1
MDPN36 VDD VDD VDD VDD pfet_03v3 L=2u W=0.5u nf=1
MDPN37 VDD VDD VDD VDD pfet_03v3 L=2u W=0.5u nf=1
MDPN38 VDD VDD VDD VDD pfet_03v3 L=2u W=0.5u nf=1
MDPN39 VDD VDD VDD VDD pfet_03v3 L=2u W=0.5u nf=1
MDPN40 VDD VDD VDD VDD pfet_03v3 L=2u W=0.5u nf=1
MDPN41 VDD VDD VDD VDD pfet_03v3 L=2u W=0.5u nf=1
MDPN42 VDD VDD VDD VDD pfet_03v3 L=2u W=0.5u nf=1
MDPN43 VDD VDD VDD VDD pfet_03v3 L=2u W=0.5u nf=1
MDPN44 VDD VDD VDD VDD pfet_03v3 L=2u W=0.5u nf=1
MDPN45 VDD VDD VDD VDD pfet_03v3 L=2u W=0.5u nf=1
MDPN46 VDD VDD VDD VDD pfet_03v3 L=2u W=0.5u nf=1
MDPN47 VDD VDD VDD VDD pfet_03v3 L=2u W=0.5u nf=1
MDPN48 VDD VDD VDD VDD pfet_03v3 L=2u W=0.5u nf=1
MDPN49 VDD VDD VDD VDD pfet_03v3 L=2u W=0.5u nf=1
MDPN50 VDD VDD VDD VDD pfet_03v3 L=2u W=0.5u nf=1
MDPN51 VDD VDD VDD VDD pfet_03v3 L=2u W=0.5u nf=1
MDPN52 VDD VDD VDD VDD pfet_03v3 L=2u W=0.5u nf=1
MDPN53 VDD VDD VDD VDD pfet_03v3 L=2u W=0.5u nf=1
MDPN54 VDD VDD VDD VDD pfet_03v3 L=2u W=0.5u nf=1
MDPN55 VDD VDD VDD VDD pfet_03v3 L=2u W=0.5u nf=1
MDPN56 VDD VDD VDD VDD pfet_03v3 L=2u W=0.5u nf=1
MDPN57 VDD VDD VDD VDD pfet_03v3 L=2u W=0.5u nf=1
MDPN58 VDD VDD VDD VDD pfet_03v3 L=2u W=0.5u nf=1
MDPN59 VDD VDD VDD VDD pfet_03v3 L=2u W=0.5u nf=1
MDPN60 VDD VDD VDD VDD pfet_03v3 L=2u W=0.5u nf=1
MDPN61 VDD VDD VDD VDD pfet_03v3 L=2u W=0.5u nf=1
MDPN62 VDD VDD VDD VDD pfet_03v3 L=2u W=0.5u nf=1
MDPN63 VDD VDD VDD VDD pfet_03v3 L=2u W=0.5u nf=1
MDPN64 VDD VDD VDD VDD pfet_03v3 L=2u W=0.5u nf=1
MDPN65 VDD VDD VDD VDD pfet_03v3 L=2u W=0.5u nf=1
MDPN66 VDD VDD VDD VDD pfet_03v3 L=2u W=0.5u nf=1
MDPN67 VDD VDD VDD VDD pfet_03v3 L=2u W=0.5u nf=1
MDPN68 VDD VDD VDD VDD pfet_03v3 L=2u W=0.5u nf=1
MDPN69 VDD VDD VDD VDD pfet_03v3 L=2u W=0.5u nf=1
MDPN70 VDD VDD VDD VDD pfet_03v3 L=2u W=0.5u nf=1
MDPN71 VDD VDD VDD VDD pfet_03v3 L=2u W=0.5u nf=1
MDPN72 VDD VDD VDD VDD pfet_03v3 L=2u W=0.5u nf=1
MDPN73 VDD VDD VDD VDD pfet_03v3 L=2u W=0.5u nf=1
MDPN74 VDD VDD VDD VDD pfet_03v3 L=2u W=0.5u nf=1
MDPN75 VDD VDD VDD VDD pfet_03v3 L=2u W=0.5u nf=1
MDPN76 VDD VDD VDD VDD pfet_03v3 L=2u W=0.5u nf=1
MDPN77 VDD VDD VDD VDD pfet_03v3 L=2u W=0.5u nf=1
MDPN78 VDD VDD VDD VDD pfet_03v3 L=2u W=0.5u nf=1
MDPN79 VDD VDD VDD VDD pfet_03v3 L=2u W=0.5u nf=1
MDPN80 VDD VDD VDD VDD pfet_03v3 L=2u W=0.5u nf=1
MDPN81 VDD VDD VDD VDD pfet_03v3 L=2u W=0.5u nf=1
MDPN82 VDD VDD VDD VDD pfet_03v3 L=2u W=0.5u nf=1
MDPN83 VDD VDD VDD VDD pfet_03v3 L=2u W=0.5u nf=1
MDPN84 VDD VDD VDD VDD pfet_03v3 L=2u W=0.5u nf=1
MDPN85 VDD VDD VDD VDD pfet_03v3 L=2u W=0.5u nf=1
MDPN86 VDD VDD VDD VDD pfet_03v3 L=2u W=0.5u nf=1
MDPN87 VDD VDD VDD VDD pfet_03v3 L=2u W=0.5u nf=1
MDPN88 VDD VDD VDD VDD pfet_03v3 L=2u W=0.5u nf=1
MDPN89 VDD VDD VDD VDD pfet_03v3 L=2u W=0.5u nf=1
MDPN90 VDD VDD VDD VDD pfet_03v3 L=2u W=0.5u nf=1
MDPN91 VDD VDD VDD VDD pfet_03v3 L=2u W=0.5u nf=1
MDPN92 VDD VDD VDD VDD pfet_03v3 L=2u W=0.5u nf=1
MDPN93 VDD VDD VDD VDD pfet_03v3 L=2u W=0.5u nf=1
MDPN94 VDD VDD VDD VDD pfet_03v3 L=2u W=0.5u nf=1
MDPN95 VDD VDD VDD VDD pfet_03v3 L=2u W=0.5u nf=1
MDPN96 VDD VDD VDD VDD pfet_03v3 L=2u W=0.5u nf=1
MDPN97 VDD VDD VDD VDD pfet_03v3 L=2u W=0.5u nf=1
MDPN98 VDD VDD VDD VDD pfet_03v3 L=2u W=0.5u nf=1
MDPN99 VDD VDD VDD VDD pfet_03v3 L=2u W=0.5u nf=1
MDPN100 VDD VDD VDD VDD pfet_03v3 L=2u W=0.5u nf=1
MDPN101 VDD VDD VDD VDD pfet_03v3 L=2u W=0.5u nf=1
MDPN102 VDD VDD VDD VDD pfet_03v3 L=2u W=0.5u nf=1
MDPN103 VDD VDD VDD VDD pfet_03v3 L=2u W=0.5u nf=1
MDPN104 VDD VDD VDD VDD pfet_03v3 L=2u W=0.5u nf=1
MDPN105 VDD VDD VDD VDD pfet_03v3 L=2u W=0.5u nf=1
MDPN106 VDD VDD VDD VDD pfet_03v3 L=2u W=0.5u nf=1
MDPN107 VDD VDD VDD VDD pfet_03v3 L=2u W=0.5u nf=1
MDPN108 VDD VDD VDD VDD pfet_03v3 L=2u W=0.5u nf=1
MDPN109 VDD VDD VDD VDD pfet_03v3 L=2u W=0.5u nf=1
MDPN110 VDD VDD VDD VDD pfet_03v3 L=2u W=0.5u nf=1
MDPN111 VDD VDD VDD VDD pfet_03v3 L=2u W=0.5u nf=1
MDPN112 VDD VDD VDD VDD pfet_03v3 L=2u W=0.5u nf=1
MDPN113 VDD VDD VDD VDD pfet_03v3 L=2u W=0.5u nf=1
MDPN114 VDD VDD VDD VDD pfet_03v3 L=2u W=0.5u nf=1
MDPN115 VDD VDD VDD VDD pfet_03v3 L=2u W=0.5u nf=1
MDPN116 VDD VDD VDD VDD pfet_03v3 L=2u W=0.5u nf=1
MDPN117 VDD VDD VDD VDD pfet_03v3 L=2u W=0.5u nf=1
MDPN118 VDD VDD VDD VDD pfet_03v3 L=2u W=0.5u nf=1
MDPN119 VDD VDD VDD VDD pfet_03v3 L=2u W=0.5u nf=1
MDPN120 VDD VDD VDD VDD pfet_03v3 L=2u W=0.5u nf=1
MDPN121 VDD VDD VDD VDD pfet_03v3 L=2u W=0.5u nf=1
MDPN122 VDD VDD VDD VDD pfet_03v3 L=2u W=0.5u nf=1
MDPN123 VDD VDD VDD VDD pfet_03v3 L=2u W=0.5u nf=1
MDPN124 VDD VDD VDD VDD pfet_03v3 L=2u W=0.5u nf=1
MDPN125 VDD VDD VDD VDD pfet_03v3 L=2u W=0.5u nf=1
MDPN126 VDD VDD VDD VDD pfet_03v3 L=2u W=0.5u nf=1
MDPN127 VDD VDD VDD VDD pfet_03v3 L=2u W=0.5u nf=1
MDPN128 VDD VDD VDD VDD pfet_03v3 L=2u W=0.5u nf=1
MDPN129 VDD VDD VDD VDD pfet_03v3 L=2u W=0.5u nf=1
MDPN130 VDD VDD VDD VDD pfet_03v3 L=2u W=0.5u nf=1
MDPN131 VDD VDD VDD VDD pfet_03v3 L=2u W=0.5u nf=1
MDPN132 VDD VDD VDD VDD pfet_03v3 L=2u W=0.5u nf=1
MDPN133 VDD VDD VDD VDD pfet_03v3 L=2u W=0.5u nf=1
MDPN134 VDD VDD VDD VDD pfet_03v3 L=2u W=0.5u nf=1
MDPN135 VDD VDD VDD VDD pfet_03v3 L=2u W=0.5u nf=1
MDPN136 VDD VDD VDD VDD pfet_03v3 L=2u W=0.5u nf=1
MDPN137 VDD VDD VDD VDD pfet_03v3 L=2u W=0.5u nf=1
MDPN138 VDD VDD VDD VDD pfet_03v3 L=2u W=0.5u nf=1
MDPN139 VDD VDD VDD VDD pfet_03v3 L=2u W=0.5u nf=1
MDPN140 VDD VDD VDD VDD pfet_03v3 L=2u W=0.5u nf=1
MDPN141 VDD VDD VDD VDD pfet_03v3 L=2u W=0.5u nf=1
MDPN142 VDD VDD VDD VDD pfet_03v3 L=2u W=0.5u nf=1
MDPN143 VDD VDD VDD VDD pfet_03v3 L=2u W=0.5u nf=1
MDPN144 VDD VDD VDD VDD pfet_03v3 L=2u W=0.5u nf=1
MDPN145 VDD VDD VDD VDD pfet_03v3 L=2u W=0.5u nf=1
MDPN146 VDD VDD VDD VDD pfet_03v3 L=2u W=0.5u nf=1
MDPN147 VDD VDD VDD VDD pfet_03v3 L=2u W=0.5u nf=1
MDPN148 VDD VDD VDD VDD pfet_03v3 L=2u W=0.5u nf=1
MDPN149 VDD VDD VDD VDD pfet_03v3 L=2u W=0.5u nf=1
MDPN150 VDD VDD VDD VDD pfet_03v3 L=2u W=0.5u nf=1
MDPS0 VDD VDD VDD VDD pfet_03v3 L=2u W=0.5u nf=1
MDPS1 VDD VDD VDD VDD pfet_03v3 L=2u W=0.5u nf=1
MDPS2 VDD VDD VDD VDD pfet_03v3 L=2u W=0.5u nf=1
MDPS3 VDD VDD VDD VDD pfet_03v3 L=2u W=0.5u nf=1
MDPS4 VDD VDD VDD VDD pfet_03v3 L=2u W=0.5u nf=1
MDPS5 VDD VDD VDD VDD pfet_03v3 L=2u W=0.5u nf=1
MDPS6 VDD VDD VDD VDD pfet_03v3 L=2u W=0.5u nf=1
MDPS7 VDD VDD VDD VDD pfet_03v3 L=2u W=0.5u nf=1
MDPS8 VDD VDD VDD VDD pfet_03v3 L=2u W=0.5u nf=1
MDPS9 VDD VDD VDD VDD pfet_03v3 L=2u W=0.5u nf=1
MDPS10 VDD VDD VDD VDD pfet_03v3 L=2u W=0.5u nf=1
MDPS11 VDD VDD VDD VDD pfet_03v3 L=2u W=0.5u nf=1
MDPS12 VDD VDD VDD VDD pfet_03v3 L=2u W=0.5u nf=1
MDPS13 VDD VDD VDD VDD pfet_03v3 L=2u W=0.5u nf=1
MDPS14 VDD VDD VDD VDD pfet_03v3 L=2u W=0.5u nf=1
MDPS15 VDD VDD VDD VDD pfet_03v3 L=2u W=0.5u nf=1
MDPS16 VDD VDD VDD VDD pfet_03v3 L=2u W=0.5u nf=1
MDPS17 VDD VDD VDD VDD pfet_03v3 L=2u W=0.5u nf=1
MDPS18 VDD VDD VDD VDD pfet_03v3 L=2u W=0.5u nf=1
MDPS19 VDD VDD VDD VDD pfet_03v3 L=2u W=0.5u nf=1
MDPS20 VDD VDD VDD VDD pfet_03v3 L=2u W=0.5u nf=1
MDPS21 VDD VDD VDD VDD pfet_03v3 L=2u W=0.5u nf=1
MDPS22 VDD VDD VDD VDD pfet_03v3 L=2u W=0.5u nf=1
MDPS23 VDD VDD VDD VDD pfet_03v3 L=2u W=0.5u nf=1
MDPS24 VDD VDD VDD VDD pfet_03v3 L=2u W=0.5u nf=1
MDPS25 VDD VDD VDD VDD pfet_03v3 L=2u W=0.5u nf=1
MDPS26 VDD VDD VDD VDD pfet_03v3 L=2u W=0.5u nf=1
MDPS27 VDD VDD VDD VDD pfet_03v3 L=2u W=0.5u nf=1
MDPS28 VDD VDD VDD VDD pfet_03v3 L=2u W=0.5u nf=1
MDPS29 VDD VDD VDD VDD pfet_03v3 L=2u W=0.5u nf=1
MDPS30 VDD VDD VDD VDD pfet_03v3 L=2u W=0.5u nf=1
MDPS31 VDD VDD VDD VDD pfet_03v3 L=2u W=0.5u nf=1
MDPS32 VDD VDD VDD VDD pfet_03v3 L=2u W=0.5u nf=1
MDPS33 VDD VDD VDD VDD pfet_03v3 L=2u W=0.5u nf=1
MDPS34 VDD VDD VDD VDD pfet_03v3 L=2u W=0.5u nf=1
MDPS35 VDD VDD VDD VDD pfet_03v3 L=2u W=0.5u nf=1
MDPS36 VDD VDD VDD VDD pfet_03v3 L=2u W=0.5u nf=1
MDPS37 VDD VDD VDD VDD pfet_03v3 L=2u W=0.5u nf=1
MDPS38 VDD VDD VDD VDD pfet_03v3 L=2u W=0.5u nf=1
MDPS39 VDD VDD VDD VDD pfet_03v3 L=2u W=0.5u nf=1
MDPS40 VDD VDD VDD VDD pfet_03v3 L=2u W=0.5u nf=1
MDPS41 VDD VDD VDD VDD pfet_03v3 L=2u W=0.5u nf=1
MDPS42 VDD VDD VDD VDD pfet_03v3 L=2u W=0.5u nf=1
MDPS43 VDD VDD VDD VDD pfet_03v3 L=2u W=0.5u nf=1
MDPS44 VDD VDD VDD VDD pfet_03v3 L=2u W=0.5u nf=1
MDPS45 VDD VDD VDD VDD pfet_03v3 L=2u W=0.5u nf=1
MDPS46 VDD VDD VDD VDD pfet_03v3 L=2u W=0.5u nf=1
MDPS47 VDD VDD VDD VDD pfet_03v3 L=2u W=0.5u nf=1
MDPS48 VDD VDD VDD VDD pfet_03v3 L=2u W=0.5u nf=1
MDPS49 VDD VDD VDD VDD pfet_03v3 L=2u W=0.5u nf=1
MDPS50 VDD VDD VDD VDD pfet_03v3 L=2u W=0.5u nf=1
MDPS51 VDD VDD VDD VDD pfet_03v3 L=2u W=0.5u nf=1
MDPS52 VDD VDD VDD VDD pfet_03v3 L=2u W=0.5u nf=1
MDPS53 VDD VDD VDD VDD pfet_03v3 L=2u W=0.5u nf=1
MDPS54 VDD VDD VDD VDD pfet_03v3 L=2u W=0.5u nf=1
MDPS55 VDD VDD VDD VDD pfet_03v3 L=2u W=0.5u nf=1
MDPS56 VDD VDD VDD VDD pfet_03v3 L=2u W=0.5u nf=1
MDPS57 VDD VDD VDD VDD pfet_03v3 L=2u W=0.5u nf=1
MDPS58 VDD VDD VDD VDD pfet_03v3 L=2u W=0.5u nf=1
MDPS59 VDD VDD VDD VDD pfet_03v3 L=2u W=0.5u nf=1
MDPS60 VDD VDD VDD VDD pfet_03v3 L=2u W=0.5u nf=1
MDPS61 VDD VDD VDD VDD pfet_03v3 L=2u W=0.5u nf=1
MDPS62 VDD VDD VDD VDD pfet_03v3 L=2u W=0.5u nf=1
MDPS63 VDD VDD VDD VDD pfet_03v3 L=2u W=0.5u nf=1
MDPS64 VDD VDD VDD VDD pfet_03v3 L=2u W=0.5u nf=1
MDPS65 VDD VDD VDD VDD pfet_03v3 L=2u W=0.5u nf=1
MDPS66 VDD VDD VDD VDD pfet_03v3 L=2u W=0.5u nf=1
MDPS67 VDD VDD VDD VDD pfet_03v3 L=2u W=0.5u nf=1
MDPS68 VDD VDD VDD VDD pfet_03v3 L=2u W=0.5u nf=1
MDPS69 VDD VDD VDD VDD pfet_03v3 L=2u W=0.5u nf=1
MDPS70 VDD VDD VDD VDD pfet_03v3 L=2u W=0.5u nf=1
MDPS71 VDD VDD VDD VDD pfet_03v3 L=2u W=0.5u nf=1
MDPS72 VDD VDD VDD VDD pfet_03v3 L=2u W=0.5u nf=1
MDPS73 VDD VDD VDD VDD pfet_03v3 L=2u W=0.5u nf=1
MDPS74 VDD VDD VDD VDD pfet_03v3 L=2u W=0.5u nf=1
MDPS75 VDD VDD VDD VDD pfet_03v3 L=2u W=0.5u nf=1
MDPS76 VDD VDD VDD VDD pfet_03v3 L=2u W=0.5u nf=1
MDPS77 VDD VDD VDD VDD pfet_03v3 L=2u W=0.5u nf=1
MDPS78 VDD VDD VDD VDD pfet_03v3 L=2u W=0.5u nf=1
MDPS79 VDD VDD VDD VDD pfet_03v3 L=2u W=0.5u nf=1
MDPS80 VDD VDD VDD VDD pfet_03v3 L=2u W=0.5u nf=1
MDPS81 VDD VDD VDD VDD pfet_03v3 L=2u W=0.5u nf=1
MDPS82 VDD VDD VDD VDD pfet_03v3 L=2u W=0.5u nf=1
MDPS83 VDD VDD VDD VDD pfet_03v3 L=2u W=0.5u nf=1
MDPS84 VDD VDD VDD VDD pfet_03v3 L=2u W=0.5u nf=1
MDPS85 VDD VDD VDD VDD pfet_03v3 L=2u W=0.5u nf=1
MDPS86 VDD VDD VDD VDD pfet_03v3 L=2u W=0.5u nf=1
MDPS87 VDD VDD VDD VDD pfet_03v3 L=2u W=0.5u nf=1
MDPS88 VDD VDD VDD VDD pfet_03v3 L=2u W=0.5u nf=1
MDPS89 VDD VDD VDD VDD pfet_03v3 L=2u W=0.5u nf=1
MDPS90 VDD VDD VDD VDD pfet_03v3 L=2u W=0.5u nf=1
MDPS91 VDD VDD VDD VDD pfet_03v3 L=2u W=0.5u nf=1
MDPS92 VDD VDD VDD VDD pfet_03v3 L=2u W=0.5u nf=1
MDPS93 VDD VDD VDD VDD pfet_03v3 L=2u W=0.5u nf=1
MDPS94 VDD VDD VDD VDD pfet_03v3 L=2u W=0.5u nf=1
MDPS95 VDD VDD VDD VDD pfet_03v3 L=2u W=0.5u nf=1
MDPS96 VDD VDD VDD VDD pfet_03v3 L=2u W=0.5u nf=1
MDPS97 VDD VDD VDD VDD pfet_03v3 L=2u W=0.5u nf=1
MDPS98 VDD VDD VDD VDD pfet_03v3 L=2u W=0.5u nf=1
MDPS99 VDD VDD VDD VDD pfet_03v3 L=2u W=0.5u nf=1
MDPS100 VDD VDD VDD VDD pfet_03v3 L=2u W=0.5u nf=1
MDPS101 VDD VDD VDD VDD pfet_03v3 L=2u W=0.5u nf=1
MDPS102 VDD VDD VDD VDD pfet_03v3 L=2u W=0.5u nf=1
MDPS103 VDD VDD VDD VDD pfet_03v3 L=2u W=0.5u nf=1
MDPS104 VDD VDD VDD VDD pfet_03v3 L=2u W=0.5u nf=1
MDPS105 VDD VDD VDD VDD pfet_03v3 L=2u W=0.5u nf=1
MDPS106 VDD VDD VDD VDD pfet_03v3 L=2u W=0.5u nf=1
MDPS107 VDD VDD VDD VDD pfet_03v3 L=2u W=0.5u nf=1
MDPS108 VDD VDD VDD VDD pfet_03v3 L=2u W=0.5u nf=1
MDPS109 VDD VDD VDD VDD pfet_03v3 L=2u W=0.5u nf=1
MDPS110 VDD VDD VDD VDD pfet_03v3 L=2u W=0.5u nf=1
MDPS111 VDD VDD VDD VDD pfet_03v3 L=2u W=0.5u nf=1
MDPS112 VDD VDD VDD VDD pfet_03v3 L=2u W=0.5u nf=1
MDPS113 VDD VDD VDD VDD pfet_03v3 L=2u W=0.5u nf=1
MDPS114 VDD VDD VDD VDD pfet_03v3 L=2u W=0.5u nf=1
MDPS115 VDD VDD VDD VDD pfet_03v3 L=2u W=0.5u nf=1
MDPS116 VDD VDD VDD VDD pfet_03v3 L=2u W=0.5u nf=1
MDPS117 VDD VDD VDD VDD pfet_03v3 L=2u W=0.5u nf=1
MDPS118 VDD VDD VDD VDD pfet_03v3 L=2u W=0.5u nf=1
MDPS119 VDD VDD VDD VDD pfet_03v3 L=2u W=0.5u nf=1
MDPS120 VDD VDD VDD VDD pfet_03v3 L=2u W=0.5u nf=1
MDPS121 VDD VDD VDD VDD pfet_03v3 L=2u W=0.5u nf=1
MDPS122 VDD VDD VDD VDD pfet_03v3 L=2u W=0.5u nf=1
MDPS123 VDD VDD VDD VDD pfet_03v3 L=2u W=0.5u nf=1
MDPS124 VDD VDD VDD VDD pfet_03v3 L=2u W=0.5u nf=1
MDPS125 VDD VDD VDD VDD pfet_03v3 L=2u W=0.5u nf=1
MDPS126 VDD VDD VDD VDD pfet_03v3 L=2u W=0.5u nf=1
MDPS127 VDD VDD VDD VDD pfet_03v3 L=2u W=0.5u nf=1
MDPS128 VDD VDD VDD VDD pfet_03v3 L=2u W=0.5u nf=1
MDPS129 VDD VDD VDD VDD pfet_03v3 L=2u W=0.5u nf=1
MDPS130 VDD VDD VDD VDD pfet_03v3 L=2u W=0.5u nf=1
MDPS131 VDD VDD VDD VDD pfet_03v3 L=2u W=0.5u nf=1
MDPS132 VDD VDD VDD VDD pfet_03v3 L=2u W=0.5u nf=1
MDPS133 VDD VDD VDD VDD pfet_03v3 L=2u W=0.5u nf=1
MDPS134 VDD VDD VDD VDD pfet_03v3 L=2u W=0.5u nf=1
MDPS135 VDD VDD VDD VDD pfet_03v3 L=2u W=0.5u nf=1
MDPS136 VDD VDD VDD VDD pfet_03v3 L=2u W=0.5u nf=1
MDPS137 VDD VDD VDD VDD pfet_03v3 L=2u W=0.5u nf=1
MDPS138 VDD VDD VDD VDD pfet_03v3 L=2u W=0.5u nf=1
MDPS139 VDD VDD VDD VDD pfet_03v3 L=2u W=0.5u nf=1
MDPS140 VDD VDD VDD VDD pfet_03v3 L=2u W=0.5u nf=1
MDPS141 VDD VDD VDD VDD pfet_03v3 L=2u W=0.5u nf=1
MDPS142 VDD VDD VDD VDD pfet_03v3 L=2u W=0.5u nf=1
MDPS143 VDD VDD VDD VDD pfet_03v3 L=2u W=0.5u nf=1
MDPS144 VDD VDD VDD VDD pfet_03v3 L=2u W=0.5u nf=1
MDPS145 VDD VDD VDD VDD pfet_03v3 L=2u W=0.5u nf=1
MDPS146 VDD VDD VDD VDD pfet_03v3 L=2u W=0.5u nf=1
MDPS147 VDD VDD VDD VDD pfet_03v3 L=2u W=0.5u nf=1
MDPS148 VDD VDD VDD VDD pfet_03v3 L=2u W=0.5u nf=1
MDPS149 VDD VDD VDD VDD pfet_03v3 L=2u W=0.5u nf=1
MDPS150 VDD VDD VDD VDD pfet_03v3 L=2u W=0.5u nf=1
MDPW0 VDD VDD VDD VDD pfet_03v3 L=2u W=10u nf=1
MDPE0 VDD VDD VDD VDD pfet_03v3 L=2u W=10u nf=1
.ends
