* Extracted by KLayout with GF180MCU LVS runset on : 17/11/2026 16:40

.SUBCKT row_111
M$1 VDD VDD VDD VDD pfet_03v3 L=2U W=0.5U AS=0.3P AD=0.14P PS=2.2U PD=1.06U
M$2 VDD VDD VDD VDD pfet_03v3 L=2U W=0.5U AS=0.14P AD=0.14P PS=1.06U PD=1.06U
M$3 VDD VDD VDD VDD pfet_03v3 L=2U W=0.5U AS=0.14P AD=0.3P PS=1.06U PD=2.2U
M$4 VDD VDD VDD VDD pfet_03v3 L=2U W=0.5U AS=0.3P AD=0.3P PS=2.2U PD=2.2U
M$5 VDD s \$6 VDD pfet_03v3 L=0.32U W=0.5U AS=0.3P AD=0.3P PS=2.2U PD=2.2U
M$6 VDD VDD VDD VDD pfet_03v3 L=2U W=0.5U AS=0.3P AD=0.3P PS=2.2U PD=2.2U
M$7 VDD VDD VDD VDD pfet_03v3 L=2U W=0.5U AS=0.3P AD=0.14P PS=2.2U PD=1.06U
M$8 VDD VDD VDD VDD pfet_03v3 L=2U W=0.5U AS=0.14P AD=0.14P PS=1.06U PD=1.06U
M$9 VDD VDD VDD VDD pfet_03v3 L=2U W=0.5U AS=0.14P AD=0.3P PS=1.06U PD=2.2U
M$10 VDD VDD VDD VDD pfet_03v3 L=0.64U W=0.5U AS=0.3P AD=0.14P PS=2.2U PD=1.06U
M$11 VDD VDD VDD VDD pfet_03v3 L=0.64U W=0.5U AS=0.14P AD=0.14P PS=1.06U
+ PD=1.06U
M$12 VDD VDD VDD VDD pfet_03v3 L=0.64U W=0.5U AS=0.14P AD=0.14P PS=1.06U
+ PD=1.06U
M$13 VDD VDD VDD VDD pfet_03v3 L=0.64U W=0.5U AS=0.14P AD=0.14P PS=1.06U
+ PD=1.06U
M$14 VDD VDD VDD VDD pfet_03v3 L=0.64U W=0.5U AS=0.14P AD=0.14P PS=1.06U
+ PD=1.06U
M$15 VDD VDD VDD VDD pfet_03v3 L=0.64U W=0.5U AS=0.14P AD=0.14P PS=1.06U
+ PD=1.06U
M$16 VDD VDD VDD VDD pfet_03v3 L=0.64U W=0.5U AS=0.14P AD=0.14P PS=1.06U
+ PD=1.06U
M$17 VDD VDD VDD VDD pfet_03v3 L=0.64U W=0.5U AS=0.14P AD=0.3P PS=1.06U PD=2.2U
M$18 VDD VDD VDD VDD pfet_03v3 L=0.64U W=0.5U AS=0.3P AD=0.3P PS=2.2U PD=2.2U
M$19 VDD VDD VDD VDD pfet_03v3 L=0.64U W=0.5U AS=0.3P AD=0.14P PS=2.2U PD=1.06U
M$20 VDD VDD VDD VDD pfet_03v3 L=0.64U W=0.5U AS=0.14P AD=0.14P PS=1.06U
+ PD=1.06U
M$21 VDD VDD VDD VDD pfet_03v3 L=0.64U W=0.5U AS=0.14P AD=0.14P PS=1.06U
+ PD=1.06U
M$22 VDD VDD VDD VDD pfet_03v3 L=0.64U W=0.5U AS=0.14P AD=0.14P PS=1.06U
+ PD=1.06U
M$23 VDD VDD VDD VDD pfet_03v3 L=0.64U W=0.5U AS=0.14P AD=0.14P PS=1.06U
+ PD=1.06U
M$24 VDD VDD VDD VDD pfet_03v3 L=0.64U W=0.5U AS=0.14P AD=0.14P PS=1.06U
+ PD=1.06U
M$25 VDD VDD VDD VDD pfet_03v3 L=0.64U W=0.5U AS=0.14P AD=0.14P PS=1.06U
+ PD=1.06U
M$26 VDD VDD VDD VDD pfet_03v3 L=0.64U W=0.5U AS=0.14P AD=0.3P PS=1.06U PD=2.2U
M$27 VDD VT_dpi \$302 VDD pfet_03v3 L=0.64U W=0.5U AS=0.3P AD=0.3P PS=2.2U
+ PD=2.2U
M$28 VDD \$302 \$1021 VDD pfet_03v3 L=0.64U W=0.5U AS=0.3P AD=0.3P PS=2.2U
+ PD=2.2U
M$29 VDD VDD VDD VDD pfet_03v3 L=0.64U W=0.5U AS=0.3P AD=0.3P PS=2.2U PD=2.2U
M$30 VDD VDD VDD VDD pfet_03v3 L=2U W=0.5U AS=0.3P AD=0.14P PS=2.2U PD=1.06U
M$31 VDD VDD VDD VDD pfet_03v3 L=2U W=0.5U AS=0.14P AD=0.14P PS=1.06U PD=1.06U
M$32 VDD VDD VDD VDD pfet_03v3 L=2U W=0.5U AS=0.14P AD=0.14P PS=1.06U PD=1.06U
M$33 VDD VDD VDD VDD pfet_03v3 L=2U W=0.5U AS=0.14P AD=0.14P PS=1.06U PD=1.06U
M$34 VDD VDD VDD VDD pfet_03v3 L=2U W=0.5U AS=0.14P AD=0.14P PS=1.06U PD=1.06U
M$35 VDD VDD VDD VDD pfet_03v3 L=2U W=0.5U AS=0.14P AD=0.14P PS=1.06U PD=1.06U
M$36 VDD VDD VDD VDD pfet_03v3 L=2U W=0.5U AS=0.14P AD=0.14P PS=1.06U PD=1.06U
M$37 VDD VDD VDD VDD pfet_03v3 L=2U W=0.5U AS=0.14P AD=0.14P PS=1.06U PD=1.06U
M$38 VDD VDD VDD VDD pfet_03v3 L=2U W=0.5U AS=0.14P AD=0.14P PS=1.06U PD=1.06U
M$39 VDD VDD VDD VDD pfet_03v3 L=2U W=0.5U AS=0.14P AD=0.14P PS=1.06U PD=1.06U
M$40 VDD VDD VDD VDD pfet_03v3 L=2U W=0.5U AS=0.14P AD=0.14P PS=1.06U PD=1.06U
M$41 VDD VDD VDD VDD pfet_03v3 L=2U W=0.5U AS=0.14P AD=0.14P PS=1.06U PD=1.06U
M$42 VDD VDD VDD VDD pfet_03v3 L=2U W=0.5U AS=0.14P AD=0.14P PS=1.06U PD=1.06U
M$43 VDD VDD VDD VDD pfet_03v3 L=2U W=0.5U AS=0.14P AD=0.14P PS=1.06U PD=1.06U
M$44 VDD VDD VDD VDD pfet_03v3 L=2U W=0.5U AS=0.14P AD=0.14P PS=1.06U PD=1.06U
M$45 VDD VDD VDD VDD pfet_03v3 L=2U W=0.5U AS=0.14P AD=0.14P PS=1.06U PD=1.06U
M$46 VDD VDD VDD VDD pfet_03v3 L=2U W=0.5U AS=0.14P AD=0.3P PS=1.06U PD=2.2U
M$47 VDD VDD VDD VDD pfet_03v3 L=2U W=1U AS=0.6P AD=0.6P PS=3.2U PD=3.2U
M$48 VDD VDD VDD VDD pfet_03v3 L=2U W=0.5U AS=0.3P AD=0.14P PS=2.2U PD=1.06U
M$49 VDD VDD VDD VDD pfet_03v3 L=2U W=0.5U AS=0.14P AD=0.14P PS=1.06U PD=1.06U
M$50 VDD VDD VDD VDD pfet_03v3 L=2U W=0.5U AS=0.14P AD=0.14P PS=1.06U PD=1.06U
M$51 VDD VDD VDD VDD pfet_03v3 L=2U W=0.5U AS=0.14P AD=0.14P PS=1.06U PD=1.06U
M$52 VDD VDD VDD VDD pfet_03v3 L=2U W=0.5U AS=0.14P AD=0.14P PS=1.06U PD=1.06U
M$53 VDD VDD VDD VDD pfet_03v3 L=2U W=0.5U AS=0.14P AD=0.14P PS=1.06U PD=1.06U
M$54 VDD VDD VDD VDD pfet_03v3 L=2U W=0.5U AS=0.14P AD=0.14P PS=1.06U PD=1.06U
M$55 VDD VDD VDD VDD pfet_03v3 L=2U W=0.5U AS=0.14P AD=0.14P PS=1.06U PD=1.06U
M$56 VDD VDD VDD VDD pfet_03v3 L=2U W=0.5U AS=0.14P AD=0.14P PS=1.06U PD=1.06U
M$57 VDD VDD VDD VDD pfet_03v3 L=2U W=0.5U AS=0.14P AD=0.14P PS=1.06U PD=1.06U
M$58 VDD VDD VDD VDD pfet_03v3 L=2U W=0.5U AS=0.14P AD=0.14P PS=1.06U PD=1.06U
M$59 VDD VDD VDD VDD pfet_03v3 L=2U W=0.5U AS=0.14P AD=0.14P PS=1.06U PD=1.06U
M$60 VDD VDD VDD VDD pfet_03v3 L=2U W=0.5U AS=0.14P AD=0.14P PS=1.06U PD=1.06U
M$61 VDD VDD VDD VDD pfet_03v3 L=2U W=0.5U AS=0.14P AD=0.14P PS=1.06U PD=1.06U
M$62 VDD VDD VDD VDD pfet_03v3 L=2U W=0.5U AS=0.14P AD=0.14P PS=1.06U PD=1.06U
M$63 VDD VDD VDD VDD pfet_03v3 L=2U W=0.5U AS=0.14P AD=0.14P PS=1.06U PD=1.06U
M$64 VDD VDD VDD VDD pfet_03v3 L=2U W=0.5U AS=0.14P AD=0.3P PS=1.06U PD=2.2U
M$65 VDD \$1228 \$1228 VDD pfet_03v3 L=8U W=0.5U AS=0.3P AD=0.3P PS=2.2U PD=2.2U
M$66 VDD \$1228 \$1229 VDD pfet_03v3 L=8U W=0.5U AS=0.3P AD=0.3P PS=2.2U PD=2.2U
M$67 VDD \$1229 \$1020 VDD pfet_03v3 L=0.64U W=0.5U AS=0.3P AD=0.3P PS=2.2U
+ PD=2.2U
M$68 \$1777 \$1020 spike VDD pfet_03v3 L=0.64U W=0.5U AS=0.3P AD=0.3P PS=2.2U
+ PD=2.2U
M$69 \$1779 \$1020 \$1021 VDD pfet_03v3 L=0.64U W=0.5U AS=0.3P AD=0.3P PS=2.2U
+ PD=2.2U
M$70 VDD VNA \$1779 VDD pfet_03v3 L=1U W=1U AS=0.6P AD=0.6P PS=3.2U PD=3.2U
M$71 VDD VKup \$1777 VDD pfet_03v3 L=1U W=1U AS=0.6P AD=0.6P PS=3.2U PD=3.2U
M$72 VDD VDD VDD VDD pfet_03v3 L=2U W=1U AS=0.6P AD=0.6P PS=3.2U PD=3.2U
M$73 VSS VSS VSS VSS nfet_03v3 L=2U W=0.5U AS=0.3P AD=0.14P PS=2.2U PD=1.06U
M$74 VSS VSS VSS VSS nfet_03v3 L=2U W=0.5U AS=0.14P AD=0.14P PS=1.06U PD=1.06U
M$75 VSS VSS VSS VSS nfet_03v3 L=2U W=0.5U AS=0.14P AD=0.14P PS=1.06U PD=1.06U
M$76 VSS VSS VSS VSS nfet_03v3 L=2U W=0.5U AS=0.14P AD=0.14P PS=1.06U PD=1.06U
M$77 VSS VSS VSS VSS nfet_03v3 L=2U W=0.5U AS=0.14P AD=0.14P PS=1.06U PD=1.06U
M$78 VSS VSS VSS VSS nfet_03v3 L=2U W=0.5U AS=0.14P AD=0.14P PS=1.06U PD=1.06U
M$79 VSS VSS VSS VSS nfet_03v3 L=2U W=0.5U AS=0.14P AD=0.14P PS=1.06U PD=1.06U
M$80 VSS VSS VSS VSS nfet_03v3 L=2U W=0.5U AS=0.14P AD=0.14P PS=1.06U PD=1.06U
M$81 VSS VSS VSS VSS nfet_03v3 L=2U W=0.5U AS=0.14P AD=0.14P PS=1.06U PD=1.06U
M$82 VSS VSS VSS VSS nfet_03v3 L=2U W=0.5U AS=0.14P AD=0.14P PS=1.06U PD=1.06U
M$83 VSS VSS VSS VSS nfet_03v3 L=2U W=0.5U AS=0.14P AD=0.14P PS=1.06U PD=1.06U
M$84 VSS VSS VSS VSS nfet_03v3 L=2U W=0.5U AS=0.14P AD=0.14P PS=1.06U PD=1.06U
M$85 VSS VSS VSS VSS nfet_03v3 L=2U W=0.5U AS=0.14P AD=0.14P PS=1.06U PD=1.06U
M$86 VSS VSS VSS VSS nfet_03v3 L=2U W=0.5U AS=0.14P AD=0.14P PS=1.06U PD=1.06U
M$87 VSS VSS VSS VSS nfet_03v3 L=2U W=0.5U AS=0.14P AD=0.14P PS=1.06U PD=1.06U
M$88 VSS VSS VSS VSS nfet_03v3 L=2U W=0.5U AS=0.14P AD=0.14P PS=1.06U PD=1.06U
M$89 VSS VSS VSS VSS nfet_03v3 L=2U W=0.5U AS=0.14P AD=0.14P PS=1.06U PD=1.06U
M$90 VSS VSS VSS VSS nfet_03v3 L=2U W=0.5U AS=0.14P AD=0.14P PS=1.06U PD=1.06U
M$91 VSS VSS VSS VSS nfet_03v3 L=2U W=0.5U AS=0.14P AD=0.14P PS=1.06U PD=1.06U
M$92 VSS VSS VSS VSS nfet_03v3 L=2U W=0.5U AS=0.14P AD=0.14P PS=1.06U PD=1.06U
M$93 VSS VSS VSS VSS nfet_03v3 L=2U W=0.5U AS=0.14P AD=0.14P PS=1.06U PD=1.06U
M$94 VSS VSS VSS VSS nfet_03v3 L=2U W=0.5U AS=0.14P AD=0.14P PS=1.06U PD=1.06U
M$95 VSS VSS VSS VSS nfet_03v3 L=2U W=0.5U AS=0.14P AD=0.14P PS=1.06U PD=1.06U
M$96 VSS VSS VSS VSS nfet_03v3 L=2U W=0.5U AS=0.14P AD=0.14P PS=1.06U PD=1.06U
M$97 VSS VSS VSS VSS nfet_03v3 L=2U W=0.5U AS=0.14P AD=0.14P PS=1.06U PD=1.06U
M$98 VSS VSS VSS VSS nfet_03v3 L=2U W=0.5U AS=0.14P AD=0.14P PS=1.06U PD=1.06U
M$99 VSS VSS VSS VSS nfet_03v3 L=2U W=0.5U AS=0.14P AD=0.14P PS=1.06U PD=1.06U
M$100 VSS VSS VSS VSS nfet_03v3 L=2U W=0.5U AS=0.14P AD=0.14P PS=1.06U PD=1.06U
M$101 VSS VSS VSS VSS nfet_03v3 L=2U W=0.5U AS=0.14P AD=0.14P PS=1.06U PD=1.06U
M$102 VSS VSS VSS VSS nfet_03v3 L=2U W=0.5U AS=0.14P AD=0.14P PS=1.06U PD=1.06U
M$103 VSS VSS VSS VSS nfet_03v3 L=2U W=0.5U AS=0.14P AD=0.14P PS=1.06U PD=1.06U
M$104 VSS VSS VSS VSS nfet_03v3 L=2U W=0.5U AS=0.14P AD=0.14P PS=1.06U PD=1.06U
M$105 VSS VSS VSS VSS nfet_03v3 L=2U W=0.5U AS=0.14P AD=0.14P PS=1.06U PD=1.06U
M$106 VSS VSS VSS VSS nfet_03v3 L=2U W=0.5U AS=0.14P AD=0.14P PS=1.06U PD=1.06U
M$107 VSS VSS VSS VSS nfet_03v3 L=2U W=0.5U AS=0.14P AD=0.14P PS=1.06U PD=1.06U
M$108 VSS VSS VSS VSS nfet_03v3 L=2U W=0.5U AS=0.14P AD=0.14P PS=1.06U PD=1.06U
M$109 VSS VSS VSS VSS nfet_03v3 L=2U W=0.5U AS=0.14P AD=0.14P PS=1.06U PD=1.06U
M$110 VSS VSS VSS VSS nfet_03v3 L=2U W=0.5U AS=0.14P AD=0.14P PS=1.06U PD=1.06U
M$111 VSS VSS VSS VSS nfet_03v3 L=2U W=0.5U AS=0.14P AD=0.14P PS=1.06U PD=1.06U
M$112 VSS VSS VSS VSS nfet_03v3 L=2U W=0.5U AS=0.14P AD=0.14P PS=1.06U PD=1.06U
M$113 VSS VSS VSS VSS nfet_03v3 L=2U W=0.5U AS=0.14P AD=0.14P PS=1.06U PD=1.06U
M$114 VSS VSS VSS VSS nfet_03v3 L=2U W=0.5U AS=0.14P AD=0.14P PS=1.06U PD=1.06U
M$115 VSS VSS VSS VSS nfet_03v3 L=2U W=0.5U AS=0.14P AD=0.14P PS=1.06U PD=1.06U
M$116 VSS VSS VSS VSS nfet_03v3 L=2U W=0.5U AS=0.14P AD=0.14P PS=1.06U PD=1.06U
M$117 VSS VSS VSS VSS nfet_03v3 L=2U W=0.5U AS=0.14P AD=0.14P PS=1.06U PD=1.06U
M$118 VSS VSS VSS VSS nfet_03v3 L=2U W=0.5U AS=0.14P AD=0.14P PS=1.06U PD=1.06U
M$119 VSS VSS VSS VSS nfet_03v3 L=2U W=0.5U AS=0.14P AD=0.14P PS=1.06U PD=1.06U
M$120 VSS VSS VSS VSS nfet_03v3 L=2U W=0.5U AS=0.14P AD=0.14P PS=1.06U PD=1.06U
M$121 VSS VSS VSS VSS nfet_03v3 L=2U W=0.5U AS=0.14P AD=0.14P PS=1.06U PD=1.06U
M$122 VSS VSS VSS VSS nfet_03v3 L=2U W=0.5U AS=0.14P AD=0.14P PS=1.06U PD=1.06U
M$123 VSS VSS VSS VSS nfet_03v3 L=2U W=0.5U AS=0.14P AD=0.14P PS=1.06U PD=1.06U
M$124 VSS VSS VSS VSS nfet_03v3 L=2U W=0.5U AS=0.14P AD=0.14P PS=1.06U PD=1.06U
M$125 VSS VSS VSS VSS nfet_03v3 L=2U W=0.5U AS=0.14P AD=0.14P PS=1.06U PD=1.06U
M$126 VSS VSS VSS VSS nfet_03v3 L=2U W=0.5U AS=0.14P AD=0.14P PS=1.06U PD=1.06U
M$127 VSS VSS VSS VSS nfet_03v3 L=2U W=0.5U AS=0.14P AD=0.14P PS=1.06U PD=1.06U
M$128 VSS VSS VSS VSS nfet_03v3 L=2U W=0.5U AS=0.14P AD=0.14P PS=1.06U PD=1.06U
M$129 VSS VSS VSS VSS nfet_03v3 L=2U W=0.5U AS=0.14P AD=0.14P PS=1.06U PD=1.06U
M$130 VSS VSS VSS VSS nfet_03v3 L=2U W=0.5U AS=0.14P AD=0.14P PS=1.06U PD=1.06U
M$131 VSS VSS VSS VSS nfet_03v3 L=2U W=0.5U AS=0.14P AD=0.14P PS=1.06U PD=1.06U
M$132 VSS VSS VSS VSS nfet_03v3 L=2U W=0.5U AS=0.14P AD=0.14P PS=1.06U PD=1.06U
M$133 VSS VSS VSS VSS nfet_03v3 L=2U W=0.5U AS=0.14P AD=0.14P PS=1.06U PD=1.06U
M$134 VSS VSS VSS VSS nfet_03v3 L=2U W=0.5U AS=0.14P AD=0.14P PS=1.06U PD=1.06U
M$135 VSS VSS VSS VSS nfet_03v3 L=2U W=0.5U AS=0.14P AD=0.14P PS=1.06U PD=1.06U
M$136 VSS VSS VSS VSS nfet_03v3 L=2U W=0.5U AS=0.14P AD=0.14P PS=1.06U PD=1.06U
M$137 VSS VSS VSS VSS nfet_03v3 L=2U W=0.5U AS=0.14P AD=0.14P PS=1.06U PD=1.06U
M$138 VSS VSS VSS VSS nfet_03v3 L=2U W=0.5U AS=0.14P AD=0.14P PS=1.06U PD=1.06U
M$139 VSS VSS VSS VSS nfet_03v3 L=2U W=0.5U AS=0.14P AD=0.14P PS=1.06U PD=1.06U
M$140 VSS VSS VSS VSS nfet_03v3 L=2U W=0.5U AS=0.14P AD=0.14P PS=1.06U PD=1.06U
M$141 VSS VSS VSS VSS nfet_03v3 L=2U W=0.5U AS=0.14P AD=0.3P PS=1.06U PD=2.2U
M$142 VSS VSS VSS VSS nfet_03v3 L=2U W=1U AS=0.6P AD=0.6P PS=3.2U PD=3.2U
M$143 \$114 pulse \$113 VSS nfet_03v3 L=0.64U W=0.5U AS=0.3P AD=0.3P PS=2.2U
+ PD=2.2U
M$144 \$304 \$6 \$114 VSS nfet_03v3 L=0.64U W=0.5U AS=0.3P AD=0.3P PS=2.2U
+ PD=2.2U
M$145 VDD s \$114 VSS nfet_03v3 L=0.64U W=0.5U AS=0.3P AD=0.3P PS=2.2U PD=2.2U
M$146 \$17 Vb VSS VSS nfet_03v3 L=8U W=1U AS=0.6P AD=0.6P PS=3.2U PD=3.2U
M$147 \$16 Vb VSS VSS nfet_03v3 L=8U W=1U AS=0.6P AD=0.6P PS=3.2U PD=3.2U
M$148 \$17 Vb VSS VSS nfet_03v3 L=8U W=1U AS=0.6P AD=0.6P PS=3.2U PD=3.2U
M$149 \$15 Vb VSS VSS nfet_03v3 L=8U W=1U AS=0.6P AD=0.6P PS=3.2U PD=3.2U
M$150 \$17 Vb VSS VSS nfet_03v3 L=8U W=1U AS=0.6P AD=0.6P PS=3.2U PD=3.2U
M$151 \$16 Vb VSS VSS nfet_03v3 L=8U W=1U AS=0.6P AD=0.6P PS=3.2U PD=3.2U
M$152 \$17 Vb VSS VSS nfet_03v3 L=8U W=1U AS=0.6P AD=0.6P PS=3.2U PD=3.2U
M$153 \$14 Vb VSS VSS nfet_03v3 L=8U W=1U AS=0.6P AD=0.6P PS=3.2U PD=3.2U
M$154 \$17 Vb VSS VSS nfet_03v3 L=8U W=1U AS=0.6P AD=0.6P PS=3.2U PD=3.2U
M$155 \$16 Vb VSS VSS nfet_03v3 L=8U W=1U AS=0.6P AD=0.6P PS=3.2U PD=3.2U
M$156 \$17 Vb VSS VSS nfet_03v3 L=8U W=1U AS=0.6P AD=0.6P PS=3.2U PD=3.2U
M$157 \$15 Vb VSS VSS nfet_03v3 L=8U W=1U AS=0.6P AD=0.6P PS=3.2U PD=3.2U
M$158 \$17 Vb VSS VSS nfet_03v3 L=8U W=1U AS=0.6P AD=0.6P PS=3.2U PD=3.2U
M$159 \$16 Vb VSS VSS nfet_03v3 L=8U W=1U AS=0.6P AD=0.6P PS=3.2U PD=3.2U
M$160 \$17 Vb VSS VSS nfet_03v3 L=8U W=1U AS=0.6P AD=0.6P PS=3.2U PD=3.2U
M$161 \$6 s VSS VSS nfet_03v3 L=0.64U W=0.5U AS=0.3P AD=0.3P PS=2.2U PD=2.2U
M$162 VSS VSS VSS VSS nfet_03v3 L=2U W=1U AS=0.6P AD=0.6P PS=3.2U PD=3.2U
M$163 \$14 \$14 \$14 \$14 nfet_03v3 L=2U W=0.5U AS=0.3P AD=0.3P PS=2.2U PD=2.2U
M$164 \$14 \$14 \$14 \$14 nfet_03v3 L=2U W=0.5U AS=0.3P AD=0.14P PS=2.2U
+ PD=1.06U
M$165 \$14 \$14 \$14 \$14 nfet_03v3 L=2U W=0.5U AS=0.14P AD=0.14P PS=1.06U
+ PD=1.06U
M$166 \$14 \$14 \$14 \$14 nfet_03v3 L=2U W=0.5U AS=0.14P AD=0.3P PS=1.06U
+ PD=2.2U
M$167 \$113 w[0] \$14 \$14 nfet_03v3 L=0.64U W=0.5U AS=0.3P AD=0.3P PS=2.2U
+ PD=2.2U
M$168 \$14 \$14 \$14 \$14 nfet_03v3 L=2U W=0.5U AS=0.3P AD=0.3P PS=2.2U PD=2.2U
M$169 \$15 \$15 \$15 \$15 nfet_03v3 L=2U W=0.5U AS=0.3P AD=0.3P PS=2.2U PD=2.2U
M$170 \$15 \$15 \$15 \$15 nfet_03v3 L=2U W=0.5U AS=0.3P AD=0.14P PS=2.2U
+ PD=1.06U
M$171 \$15 \$15 \$15 \$15 nfet_03v3 L=2U W=0.5U AS=0.14P AD=0.14P PS=1.06U
+ PD=1.06U
M$172 \$15 \$15 \$15 \$15 nfet_03v3 L=2U W=0.5U AS=0.14P AD=0.14P PS=1.06U
+ PD=1.06U
M$173 \$15 \$15 \$15 \$15 nfet_03v3 L=2U W=0.5U AS=0.14P AD=0.3P PS=1.06U
+ PD=2.2U
M$174 \$113 w[1] \$15 \$15 nfet_03v3 L=0.64U W=0.5U AS=0.3P AD=0.14P PS=2.2U
+ PD=1.06U
M$175 \$15 w[1] \$113 \$15 nfet_03v3 L=0.64U W=0.5U AS=0.14P AD=0.3P PS=1.06U
+ PD=2.2U
M$176 \$15 \$15 \$15 \$15 nfet_03v3 L=2U W=0.5U AS=0.3P AD=0.3P PS=2.2U PD=2.2U
M$177 \$16 \$16 \$16 \$16 nfet_03v3 L=2U W=0.5U AS=0.3P AD=0.3P PS=2.2U PD=2.2U
M$178 \$16 \$16 \$16 \$16 nfet_03v3 L=2U W=0.5U AS=0.3P AD=0.14P PS=2.2U
+ PD=1.06U
M$179 \$16 \$16 \$16 \$16 nfet_03v3 L=2U W=0.5U AS=0.14P AD=0.14P PS=1.06U
+ PD=1.06U
M$180 \$16 \$16 \$16 \$16 nfet_03v3 L=2U W=0.5U AS=0.14P AD=0.14P PS=1.06U
+ PD=1.06U
M$181 \$16 \$16 \$16 \$16 nfet_03v3 L=2U W=0.5U AS=0.14P AD=0.14P PS=1.06U
+ PD=1.06U
M$182 \$16 \$16 \$16 \$16 nfet_03v3 L=2U W=0.5U AS=0.14P AD=0.3P PS=1.06U
+ PD=2.2U
M$183 \$113 w[2] \$16 \$16 nfet_03v3 L=0.64U W=0.5U AS=0.3P AD=0.14P PS=2.2U
+ PD=1.06U
M$184 \$16 w[2] \$113 \$16 nfet_03v3 L=0.64U W=0.5U AS=0.14P AD=0.14P PS=1.06U
+ PD=1.06U
M$185 \$113 w[2] \$16 \$16 nfet_03v3 L=0.64U W=0.5U AS=0.14P AD=0.14P PS=1.06U
+ PD=1.06U
M$186 \$16 w[2] \$113 \$16 nfet_03v3 L=0.64U W=0.5U AS=0.14P AD=0.3P PS=1.06U
+ PD=2.2U
M$187 \$16 \$16 \$16 \$16 nfet_03v3 L=2U W=0.5U AS=0.3P AD=0.3P PS=2.2U PD=2.2U
M$188 \$17 \$17 \$17 \$17 nfet_03v3 L=2U W=0.5U AS=0.3P AD=0.3P PS=2.2U PD=2.2U
M$189 \$17 \$17 \$17 \$17 nfet_03v3 L=2U W=0.5U AS=0.3P AD=0.14P PS=2.2U
+ PD=1.06U
M$190 \$17 \$17 \$17 \$17 nfet_03v3 L=2U W=0.5U AS=0.14P AD=0.14P PS=1.06U
+ PD=1.06U
M$191 \$17 \$17 \$17 \$17 nfet_03v3 L=2U W=0.5U AS=0.14P AD=0.14P PS=1.06U
+ PD=1.06U
M$192 \$17 \$17 \$17 \$17 nfet_03v3 L=2U W=0.5U AS=0.14P AD=0.14P PS=1.06U
+ PD=1.06U
M$193 \$17 \$17 \$17 \$17 nfet_03v3 L=2U W=0.5U AS=0.14P AD=0.14P PS=1.06U
+ PD=1.06U
M$194 \$17 \$17 \$17 \$17 nfet_03v3 L=2U W=0.5U AS=0.14P AD=0.14P PS=1.06U
+ PD=1.06U
M$195 \$17 \$17 \$17 \$17 nfet_03v3 L=2U W=0.5U AS=0.14P AD=0.3P PS=1.06U
+ PD=2.2U
M$196 \$113 w[3] \$17 \$17 nfet_03v3 L=0.64U W=0.5U AS=0.3P AD=0.14P PS=2.2U
+ PD=1.06U
M$197 \$17 w[3] \$113 \$17 nfet_03v3 L=0.64U W=0.5U AS=0.14P AD=0.14P PS=1.06U
+ PD=1.06U
M$198 \$113 w[3] \$17 \$17 nfet_03v3 L=0.64U W=0.5U AS=0.14P AD=0.14P PS=1.06U
+ PD=1.06U
M$199 \$17 w[3] \$113 \$17 nfet_03v3 L=0.64U W=0.5U AS=0.14P AD=0.14P PS=1.06U
+ PD=1.06U
M$200 \$113 w[3] \$17 \$17 nfet_03v3 L=0.64U W=0.5U AS=0.14P AD=0.14P PS=1.06U
+ PD=1.06U
M$201 \$17 w[3] \$113 \$17 nfet_03v3 L=0.64U W=0.5U AS=0.14P AD=0.14P PS=1.06U
+ PD=1.06U
M$202 \$113 w[3] \$17 \$17 nfet_03v3 L=0.64U W=0.5U AS=0.14P AD=0.14P PS=1.06U
+ PD=1.06U
M$203 \$17 w[3] \$113 \$17 nfet_03v3 L=0.64U W=0.5U AS=0.14P AD=0.3P PS=1.06U
+ PD=2.2U
M$204 \$17 \$17 \$17 \$17 nfet_03v3 L=2U W=0.5U AS=0.3P AD=0.3P PS=2.2U PD=2.2U
M$205 VSS VSS VSS VSS nfet_03v3 L=2U W=0.5U AS=0.3P AD=0.14P PS=2.2U PD=1.06U
M$206 VSS VSS VSS VSS nfet_03v3 L=2U W=0.5U AS=0.14P AD=0.14P PS=1.06U PD=1.06U
M$207 VSS VSS VSS VSS nfet_03v3 L=2U W=0.5U AS=0.14P AD=0.14P PS=1.06U PD=1.06U
M$208 VSS VSS VSS VSS nfet_03v3 L=2U W=0.5U AS=0.14P AD=0.14P PS=1.06U PD=1.06U
M$209 VSS VSS VSS VSS nfet_03v3 L=2U W=0.5U AS=0.14P AD=0.14P PS=1.06U PD=1.06U
M$210 VSS VSS VSS VSS nfet_03v3 L=2U W=0.5U AS=0.14P AD=0.14P PS=1.06U PD=1.06U
M$211 VSS VSS VSS VSS nfet_03v3 L=2U W=0.5U AS=0.14P AD=0.14P PS=1.06U PD=1.06U
M$212 VSS VSS VSS VSS nfet_03v3 L=2U W=0.5U AS=0.14P AD=0.14P PS=1.06U PD=1.06U
M$213 VSS VSS VSS VSS nfet_03v3 L=2U W=0.5U AS=0.14P AD=0.14P PS=1.06U PD=1.06U
M$214 VSS VSS VSS VSS nfet_03v3 L=2U W=0.5U AS=0.14P AD=0.14P PS=1.06U PD=1.06U
M$215 VSS VSS VSS VSS nfet_03v3 L=2U W=0.5U AS=0.14P AD=0.14P PS=1.06U PD=1.06U
M$216 VSS VSS VSS VSS nfet_03v3 L=2U W=0.5U AS=0.14P AD=0.14P PS=1.06U PD=1.06U
M$217 VSS VSS VSS VSS nfet_03v3 L=2U W=0.5U AS=0.14P AD=0.14P PS=1.06U PD=1.06U
M$218 VSS VSS VSS VSS nfet_03v3 L=2U W=0.5U AS=0.14P AD=0.14P PS=1.06U PD=1.06U
M$219 VSS VSS VSS VSS nfet_03v3 L=2U W=0.5U AS=0.14P AD=0.14P PS=1.06U PD=1.06U
M$220 VSS VSS VSS VSS nfet_03v3 L=2U W=0.5U AS=0.14P AD=0.14P PS=1.06U PD=1.06U
M$221 VSS VSS VSS VSS nfet_03v3 L=2U W=0.5U AS=0.14P AD=0.14P PS=1.06U PD=1.06U
M$222 VSS VSS VSS VSS nfet_03v3 L=2U W=0.5U AS=0.14P AD=0.14P PS=1.06U PD=1.06U
M$223 VSS VSS VSS VSS nfet_03v3 L=2U W=0.5U AS=0.14P AD=0.14P PS=1.06U PD=1.06U
M$224 VSS VSS VSS VSS nfet_03v3 L=2U W=0.5U AS=0.14P AD=0.14P PS=1.06U PD=1.06U
M$225 VSS VSS VSS VSS nfet_03v3 L=2U W=0.5U AS=0.14P AD=0.14P PS=1.06U PD=1.06U
M$226 VSS VSS VSS VSS nfet_03v3 L=2U W=0.5U AS=0.14P AD=0.14P PS=1.06U PD=1.06U
M$227 VSS VSS VSS VSS nfet_03v3 L=2U W=0.5U AS=0.14P AD=0.14P PS=1.06U PD=1.06U
M$228 VSS VSS VSS VSS nfet_03v3 L=2U W=0.5U AS=0.14P AD=0.14P PS=1.06U PD=1.06U
M$229 VSS VSS VSS VSS nfet_03v3 L=2U W=0.5U AS=0.14P AD=0.14P PS=1.06U PD=1.06U
M$230 VSS VSS VSS VSS nfet_03v3 L=2U W=0.5U AS=0.14P AD=0.14P PS=1.06U PD=1.06U
M$231 VSS VSS VSS VSS nfet_03v3 L=2U W=0.5U AS=0.14P AD=0.14P PS=1.06U PD=1.06U
M$232 VSS VSS VSS VSS nfet_03v3 L=2U W=0.5U AS=0.14P AD=0.14P PS=1.06U PD=1.06U
M$233 VSS VSS VSS VSS nfet_03v3 L=2U W=0.5U AS=0.14P AD=0.14P PS=1.06U PD=1.06U
M$234 VSS VSS VSS VSS nfet_03v3 L=2U W=0.5U AS=0.14P AD=0.14P PS=1.06U PD=1.06U
M$235 VSS VSS VSS VSS nfet_03v3 L=2U W=0.5U AS=0.14P AD=0.14P PS=1.06U PD=1.06U
M$236 VSS VSS VSS VSS nfet_03v3 L=2U W=0.5U AS=0.14P AD=0.14P PS=1.06U PD=1.06U
M$237 VSS VSS VSS VSS nfet_03v3 L=2U W=0.5U AS=0.14P AD=0.14P PS=1.06U PD=1.06U
M$238 VSS VSS VSS VSS nfet_03v3 L=2U W=0.5U AS=0.14P AD=0.14P PS=1.06U PD=1.06U
M$239 VSS VSS VSS VSS nfet_03v3 L=2U W=0.5U AS=0.14P AD=0.14P PS=1.06U PD=1.06U
M$240 VSS VSS VSS VSS nfet_03v3 L=2U W=0.5U AS=0.14P AD=0.14P PS=1.06U PD=1.06U
M$241 VSS VSS VSS VSS nfet_03v3 L=2U W=0.5U AS=0.14P AD=0.14P PS=1.06U PD=1.06U
M$242 VSS VSS VSS VSS nfet_03v3 L=2U W=0.5U AS=0.14P AD=0.14P PS=1.06U PD=1.06U
M$243 VSS VSS VSS VSS nfet_03v3 L=2U W=0.5U AS=0.14P AD=0.14P PS=1.06U PD=1.06U
M$244 VSS VSS VSS VSS nfet_03v3 L=2U W=0.5U AS=0.14P AD=0.14P PS=1.06U PD=1.06U
M$245 VSS VSS VSS VSS nfet_03v3 L=2U W=0.5U AS=0.14P AD=0.14P PS=1.06U PD=1.06U
M$246 VSS VSS VSS VSS nfet_03v3 L=2U W=0.5U AS=0.14P AD=0.14P PS=1.06U PD=1.06U
M$247 VSS VSS VSS VSS nfet_03v3 L=2U W=0.5U AS=0.14P AD=0.14P PS=1.06U PD=1.06U
M$248 VSS VSS VSS VSS nfet_03v3 L=2U W=0.5U AS=0.14P AD=0.14P PS=1.06U PD=1.06U
M$249 VSS VSS VSS VSS nfet_03v3 L=2U W=0.5U AS=0.14P AD=0.14P PS=1.06U PD=1.06U
M$250 VSS VSS VSS VSS nfet_03v3 L=2U W=0.5U AS=0.14P AD=0.14P PS=1.06U PD=1.06U
M$251 VSS VSS VSS VSS nfet_03v3 L=2U W=0.5U AS=0.14P AD=0.14P PS=1.06U PD=1.06U
M$252 VSS VSS VSS VSS nfet_03v3 L=2U W=0.5U AS=0.14P AD=0.14P PS=1.06U PD=1.06U
M$253 VSS VSS VSS VSS nfet_03v3 L=2U W=0.5U AS=0.14P AD=0.14P PS=1.06U PD=1.06U
M$254 VSS VSS VSS VSS nfet_03v3 L=2U W=0.5U AS=0.14P AD=0.14P PS=1.06U PD=1.06U
M$255 VSS VSS VSS VSS nfet_03v3 L=2U W=0.5U AS=0.14P AD=0.14P PS=1.06U PD=1.06U
M$256 VSS VSS VSS VSS nfet_03v3 L=2U W=0.5U AS=0.14P AD=0.14P PS=1.06U PD=1.06U
M$257 VSS VSS VSS VSS nfet_03v3 L=2U W=0.5U AS=0.14P AD=0.14P PS=1.06U PD=1.06U
M$258 VSS VSS VSS VSS nfet_03v3 L=2U W=0.5U AS=0.14P AD=0.14P PS=1.06U PD=1.06U
M$259 VSS VSS VSS VSS nfet_03v3 L=2U W=0.5U AS=0.14P AD=0.14P PS=1.06U PD=1.06U
M$260 VSS VSS VSS VSS nfet_03v3 L=2U W=0.5U AS=0.14P AD=0.14P PS=1.06U PD=1.06U
M$261 VSS VSS VSS VSS nfet_03v3 L=2U W=0.5U AS=0.14P AD=0.14P PS=1.06U PD=1.06U
M$262 VSS VSS VSS VSS nfet_03v3 L=2U W=0.5U AS=0.14P AD=0.14P PS=1.06U PD=1.06U
M$263 VSS VSS VSS VSS nfet_03v3 L=2U W=0.5U AS=0.14P AD=0.14P PS=1.06U PD=1.06U
M$264 VSS VSS VSS VSS nfet_03v3 L=2U W=0.5U AS=0.14P AD=0.14P PS=1.06U PD=1.06U
M$265 VSS VSS VSS VSS nfet_03v3 L=2U W=0.5U AS=0.14P AD=0.14P PS=1.06U PD=1.06U
M$266 VSS VSS VSS VSS nfet_03v3 L=2U W=0.5U AS=0.14P AD=0.14P PS=1.06U PD=1.06U
M$267 VSS VSS VSS VSS nfet_03v3 L=2U W=0.5U AS=0.14P AD=0.14P PS=1.06U PD=1.06U
M$268 VSS VSS VSS VSS nfet_03v3 L=2U W=0.5U AS=0.14P AD=0.14P PS=1.06U PD=1.06U
M$269 VSS VSS VSS VSS nfet_03v3 L=2U W=0.5U AS=0.14P AD=0.14P PS=1.06U PD=1.06U
M$270 VSS VSS VSS VSS nfet_03v3 L=2U W=0.5U AS=0.14P AD=0.14P PS=1.06U PD=1.06U
M$271 VSS VSS VSS VSS nfet_03v3 L=2U W=0.5U AS=0.14P AD=0.14P PS=1.06U PD=1.06U
M$272 VSS VSS VSS VSS nfet_03v3 L=2U W=0.5U AS=0.14P AD=0.14P PS=1.06U PD=1.06U
M$273 VSS VSS VSS VSS nfet_03v3 L=2U W=0.5U AS=0.14P AD=0.3P PS=1.06U PD=2.2U
M$274 \$14 \$14 \$14 \$14 nfet_03v3 L=2U W=0.5U AS=0.3P AD=0.14P PS=2.2U
+ PD=1.06U
M$275 \$14 \$14 \$14 \$14 nfet_03v3 L=2U W=0.5U AS=0.14P AD=0.14P PS=1.06U
+ PD=1.06U
M$276 \$14 \$14 \$14 \$14 nfet_03v3 L=2U W=0.5U AS=0.14P AD=0.3P PS=1.06U
+ PD=2.2U
M$277 \$15 \$15 \$15 \$15 nfet_03v3 L=2U W=0.5U AS=0.3P AD=0.14P PS=2.2U
+ PD=1.06U
M$278 \$15 \$15 \$15 \$15 nfet_03v3 L=2U W=0.5U AS=0.14P AD=0.14P PS=1.06U
+ PD=1.06U
M$279 \$15 \$15 \$15 \$15 nfet_03v3 L=2U W=0.5U AS=0.14P AD=0.14P PS=1.06U
+ PD=1.06U
M$280 \$15 \$15 \$15 \$15 nfet_03v3 L=2U W=0.5U AS=0.14P AD=0.3P PS=1.06U
+ PD=2.2U
M$281 \$16 \$16 \$16 \$16 nfet_03v3 L=2U W=0.5U AS=0.3P AD=0.14P PS=2.2U
+ PD=1.06U
M$282 \$16 \$16 \$16 \$16 nfet_03v3 L=2U W=0.5U AS=0.14P AD=0.14P PS=1.06U
+ PD=1.06U
M$283 \$16 \$16 \$16 \$16 nfet_03v3 L=2U W=0.5U AS=0.14P AD=0.14P PS=1.06U
+ PD=1.06U
M$284 \$16 \$16 \$16 \$16 nfet_03v3 L=2U W=0.5U AS=0.14P AD=0.14P PS=1.06U
+ PD=1.06U
M$285 \$16 \$16 \$16 \$16 nfet_03v3 L=2U W=0.5U AS=0.14P AD=0.3P PS=1.06U
+ PD=2.2U
M$286 \$17 \$17 \$17 \$17 nfet_03v3 L=2U W=0.5U AS=0.3P AD=0.14P PS=2.2U
+ PD=1.06U
M$287 \$17 \$17 \$17 \$17 nfet_03v3 L=2U W=0.5U AS=0.14P AD=0.14P PS=1.06U
+ PD=1.06U
M$288 \$17 \$17 \$17 \$17 nfet_03v3 L=2U W=0.5U AS=0.14P AD=0.14P PS=1.06U
+ PD=1.06U
M$289 \$17 \$17 \$17 \$17 nfet_03v3 L=2U W=0.5U AS=0.14P AD=0.14P PS=1.06U
+ PD=1.06U
M$290 \$17 \$17 \$17 \$17 nfet_03v3 L=2U W=0.5U AS=0.14P AD=0.14P PS=1.06U
+ PD=1.06U
M$291 \$17 \$17 \$17 \$17 nfet_03v3 L=2U W=0.5U AS=0.14P AD=0.14P PS=1.06U
+ PD=1.06U
M$292 \$17 \$17 \$17 \$17 nfet_03v3 L=2U W=0.5U AS=0.14P AD=0.3P PS=1.06U
+ PD=2.2U
M$293 \$304 \$304 \$304 \$304 nfet_03v3 L=0.64U W=0.5U AS=0.3P AD=0.3P PS=2.2U
+ PD=2.2U
M$294 \$304 \$304 \$304 \$304 nfet_03v3 L=0.64U W=0.5U AS=0.3P AD=0.14P PS=2.2U
+ PD=1.06U
M$295 \$304 \$304 \$304 \$304 nfet_03v3 L=0.64U W=0.5U AS=0.14P AD=0.14P
+ PS=1.06U PD=1.06U
M$296 \$304 \$304 \$304 \$304 nfet_03v3 L=0.64U W=0.5U AS=0.14P AD=0.14P
+ PS=1.06U PD=1.06U
M$297 \$304 \$304 \$304 \$304 nfet_03v3 L=0.64U W=0.5U AS=0.14P AD=0.14P
+ PS=1.06U PD=1.06U
M$298 \$304 \$304 \$304 \$304 nfet_03v3 L=0.64U W=0.5U AS=0.14P AD=0.14P
+ PS=1.06U PD=1.06U
M$299 \$304 \$304 \$304 \$304 nfet_03v3 L=0.64U W=0.5U AS=0.14P AD=0.14P
+ PS=1.06U PD=1.06U
M$300 \$304 \$304 \$304 \$304 nfet_03v3 L=0.64U W=0.5U AS=0.14P AD=0.14P
+ PS=1.06U PD=1.06U
M$301 \$304 \$304 \$304 \$304 nfet_03v3 L=0.64U W=0.5U AS=0.14P AD=0.3P
+ PS=1.06U PD=2.2U
M$302 \$304 \$304 \$304 \$304 nfet_03v3 L=0.64U W=0.5U AS=0.3P AD=0.14P PS=2.2U
+ PD=1.06U
M$303 \$304 \$304 \$304 \$304 nfet_03v3 L=0.64U W=0.5U AS=0.14P AD=0.14P
+ PS=1.06U PD=1.06U
M$304 \$304 \$304 \$304 \$304 nfet_03v3 L=0.64U W=0.5U AS=0.14P AD=0.14P
+ PS=1.06U PD=1.06U
M$305 \$304 \$304 \$304 \$304 nfet_03v3 L=0.64U W=0.5U AS=0.14P AD=0.14P
+ PS=1.06U PD=1.06U
M$306 \$304 \$304 \$304 \$304 nfet_03v3 L=0.64U W=0.5U AS=0.14P AD=0.14P
+ PS=1.06U PD=1.06U
M$307 \$304 \$304 \$304 \$304 nfet_03v3 L=0.64U W=0.5U AS=0.14P AD=0.14P
+ PS=1.06U PD=1.06U
M$308 \$304 \$304 \$304 \$304 nfet_03v3 L=0.64U W=0.5U AS=0.14P AD=0.14P
+ PS=1.06U PD=1.06U
M$309 \$304 \$304 \$304 \$304 nfet_03v3 L=0.64U W=0.5U AS=0.14P AD=0.3P
+ PS=1.06U PD=2.2U
M$310 VDD Vthr \$304 \$304 nfet_03v3 L=0.64U W=0.5U AS=0.3P AD=0.3P PS=2.2U
+ PD=2.2U
M$311 VSS VSS VSS VSS nfet_03v3 L=2U W=4U AS=2.4P AD=2.4P PS=9.2U PD=9.2U
M$312 VSS VSS VSS VSS nfet_03v3 L=2U W=0.5U AS=0.3P AD=0.14P PS=2.2U PD=1.06U
M$313 VSS VSS VSS VSS nfet_03v3 L=2U W=0.5U AS=0.14P AD=0.14P PS=1.06U PD=1.06U
M$314 VSS VSS VSS VSS nfet_03v3 L=2U W=0.5U AS=0.14P AD=0.14P PS=1.06U PD=1.06U
M$315 VSS VSS VSS VSS nfet_03v3 L=2U W=0.5U AS=0.14P AD=0.14P PS=1.06U PD=1.06U
M$316 VSS VSS VSS VSS nfet_03v3 L=2U W=0.5U AS=0.14P AD=0.14P PS=1.06U PD=1.06U
M$317 VSS VSS VSS VSS nfet_03v3 L=2U W=0.5U AS=0.14P AD=0.14P PS=1.06U PD=1.06U
M$318 VSS VSS VSS VSS nfet_03v3 L=2U W=0.5U AS=0.14P AD=0.14P PS=1.06U PD=1.06U
M$319 VSS VSS VSS VSS nfet_03v3 L=2U W=0.5U AS=0.14P AD=0.14P PS=1.06U PD=1.06U
M$320 VSS VSS VSS VSS nfet_03v3 L=2U W=0.5U AS=0.14P AD=0.14P PS=1.06U PD=1.06U
M$321 VSS VSS VSS VSS nfet_03v3 L=2U W=0.5U AS=0.14P AD=0.14P PS=1.06U PD=1.06U
M$322 VSS VSS VSS VSS nfet_03v3 L=2U W=0.5U AS=0.14P AD=0.14P PS=1.06U PD=1.06U
M$323 VSS VSS VSS VSS nfet_03v3 L=2U W=0.5U AS=0.14P AD=0.14P PS=1.06U PD=1.06U
M$324 VSS VSS VSS VSS nfet_03v3 L=2U W=0.5U AS=0.14P AD=0.14P PS=1.06U PD=1.06U
M$325 VSS VSS VSS VSS nfet_03v3 L=2U W=0.5U AS=0.14P AD=0.14P PS=1.06U PD=1.06U
M$326 VSS VSS VSS VSS nfet_03v3 L=2U W=0.5U AS=0.14P AD=0.14P PS=1.06U PD=1.06U
M$327 VSS VSS VSS VSS nfet_03v3 L=2U W=0.5U AS=0.14P AD=0.14P PS=1.06U PD=1.06U
M$328 VSS VSS VSS VSS nfet_03v3 L=2U W=0.5U AS=0.14P AD=0.14P PS=1.06U PD=1.06U
M$329 VSS VSS VSS VSS nfet_03v3 L=2U W=0.5U AS=0.14P AD=0.14P PS=1.06U PD=1.06U
M$330 VSS VSS VSS VSS nfet_03v3 L=2U W=0.5U AS=0.14P AD=0.14P PS=1.06U PD=1.06U
M$331 VSS VSS VSS VSS nfet_03v3 L=2U W=0.5U AS=0.14P AD=0.3P PS=1.06U PD=2.2U
M$332 VSS VSS VSS VSS nfet_03v3 L=2U W=0.5U AS=0.3P AD=0.14P PS=2.2U PD=1.06U
M$333 VSS VSS VSS VSS nfet_03v3 L=2U W=0.5U AS=0.14P AD=0.14P PS=1.06U PD=1.06U
M$334 VSS VSS VSS VSS nfet_03v3 L=2U W=0.5U AS=0.14P AD=0.14P PS=1.06U PD=1.06U
M$335 VSS VSS VSS VSS nfet_03v3 L=2U W=0.5U AS=0.14P AD=0.14P PS=1.06U PD=1.06U
M$336 VSS VSS VSS VSS nfet_03v3 L=2U W=0.5U AS=0.14P AD=0.14P PS=1.06U PD=1.06U
M$337 VSS VSS VSS VSS nfet_03v3 L=2U W=0.5U AS=0.14P AD=0.14P PS=1.06U PD=1.06U
M$338 VSS VSS VSS VSS nfet_03v3 L=2U W=0.5U AS=0.14P AD=0.14P PS=1.06U PD=1.06U
M$339 VSS VSS VSS VSS nfet_03v3 L=2U W=0.5U AS=0.14P AD=0.14P PS=1.06U PD=1.06U
M$340 VSS VSS VSS VSS nfet_03v3 L=2U W=0.5U AS=0.14P AD=0.14P PS=1.06U PD=1.06U
M$341 VSS VSS VSS VSS nfet_03v3 L=2U W=0.5U AS=0.14P AD=0.14P PS=1.06U PD=1.06U
M$342 VSS VSS VSS VSS nfet_03v3 L=2U W=0.5U AS=0.14P AD=0.14P PS=1.06U PD=1.06U
M$343 VSS VSS VSS VSS nfet_03v3 L=2U W=0.5U AS=0.14P AD=0.14P PS=1.06U PD=1.06U
M$344 VSS VSS VSS VSS nfet_03v3 L=2U W=0.5U AS=0.14P AD=0.14P PS=1.06U PD=1.06U
M$345 VSS VSS VSS VSS nfet_03v3 L=2U W=0.5U AS=0.14P AD=0.14P PS=1.06U PD=1.06U
M$346 VSS VSS VSS VSS nfet_03v3 L=2U W=0.5U AS=0.14P AD=0.14P PS=1.06U PD=1.06U
M$347 VSS VSS VSS VSS nfet_03v3 L=2U W=0.5U AS=0.14P AD=0.14P PS=1.06U PD=1.06U
M$348 VSS VSS VSS VSS nfet_03v3 L=2U W=0.5U AS=0.14P AD=0.14P PS=1.06U PD=1.06U
M$349 VSS VSS VSS VSS nfet_03v3 L=2U W=0.5U AS=0.14P AD=0.14P PS=1.06U PD=1.06U
M$350 VSS VSS VSS VSS nfet_03v3 L=2U W=0.5U AS=0.14P AD=0.14P PS=1.06U PD=1.06U
M$351 VSS VSS VSS VSS nfet_03v3 L=2U W=0.5U AS=0.14P AD=0.3P PS=1.06U PD=2.2U
M$352 \$302 \$302 \$304 \$304 nfet_03v3 L=0.64U W=0.5U AS=0.3P AD=0.3P PS=2.2U
+ PD=2.2U
M$353 \$1227 Vamp_bias VSS VSS nfet_03v3 L=0.64U W=0.5U AS=0.3P AD=0.3P PS=2.2U
+ PD=2.2U
M$354 \$304 \$304 \$304 \$304 nfet_03v3 L=0.64U W=0.5U AS=0.3P AD=0.3P PS=2.2U
+ PD=2.2U
M$355 \$1228 \$1021 \$1227 VSS nfet_03v3 L=2U W=4U AS=2.4P AD=2.4P PS=9.2U
+ PD=9.2U
M$356 \$1229 VT \$1227 VSS nfet_03v3 L=2U W=4U AS=2.4P AD=2.4P PS=9.2U PD=9.2U
M$357 \$1020 \$1229 \$1283 VSS nfet_03v3 L=0.64U W=0.5U AS=0.3P AD=0.3P PS=2.2U
+ PD=2.2U
M$358 spike \$1020 \$1284 VSS nfet_03v3 L=0.64U W=0.5U AS=0.3P AD=0.3P PS=2.2U
+ PD=2.2U
M$359 \$1021 spike \$1285 VSS nfet_03v3 L=11.36U W=0.5U AS=0.3P AD=0.3P PS=2.2U
+ PD=2.2U
M$360 \$1284 VKdn VSS VSS nfet_03v3 L=1U W=1U AS=0.6P AD=0.6P PS=3.2U PD=3.2U
M$361 \$1283 VIp VSS VSS nfet_03v3 L=1U W=1U AS=0.6P AD=0.6P PS=3.2U PD=3.2U
M$362 \$1285 VK VSS VSS nfet_03v3 L=1U W=1U AS=0.6P AD=0.6P PS=3.2U PD=3.2U
M$363 \$1021 Vlk VSS VSS nfet_03v3 L=1U W=1U AS=0.6P AD=0.6P PS=3.2U PD=3.2U
M$364 VSS VSS VSS VSS nfet_03v3 L=2U W=4U AS=2.4P AD=2.4P PS=9.2U PD=9.2U
C$365 VSS \$1021 9.839048e-13 cap_mim_2f0fF A=491.9524P P=88.72U
C$366 VSS spike 2e-13 cap_mim_2f0fF A=100P P=40U
C$367 \$302 VDD 9.839048e-13 cap_mim_2f0fF A=491.9524P P=88.72U
.ENDS row_111
