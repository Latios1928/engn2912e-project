* NGSPICE file created from SNN_signed_flat__ext - technology: gf180mcuD

.subckt SNN_signed_flat w[31] w[30] w[29] w[28] w[27] w[26] w[25] w[24] w[23] w[22]  w[21] w[20] w[19] w[18] w[17] w[16] w[15] w[14] w[13] w[12] w[11] w[10] w[9] w[8]  w[7] w[6] w[5] w[4] w[3] w[2] w[1] w[0] s[7] s[6] s[5] s[4] s[3] s[2] s[1] s[0]  pulse[1] pulse[0] VDD VSS Iref VT spike[4] spike[3] spike[2] spike[1] spike[0]
X5 VDD a_38446_142736# a_38446_142736# VDD pfet_03v3 ad=6p pd=21.2u as=6p ps=21.2u w=10u l=8u
X8 VDD a_103440_118168# a_103440_118168# VDD pfet_03v3 ad=0.3p pd=2.2u as=0.3p ps=2.2u w=0.5u l=8u
X11 bias_0__VT_inh bias_0__VT_inh VDD VDD pfet_03v3 ad=0.2464p pd=1.44u as=0.2464p ps=1.44u w=0.88u l=1.12u
X15 a_109144_57760# a_105330_51444# VMEM_2 VDD pfet_03v3 ad=0.3p pd=2.2u as=0.3p ps=2.2u w=0.5u l=0.64u
X18 a_79938_88056# a_79938_88056# VSS VSS nfet_03v3 ad=1.2p pd=5.2u as=1.2p ps=5.2u w=2u l=8u
X23 bias_0__VT_inh bias_0__VT_inh VDD VDD pfet_03v3 ad=0.2464p pd=1.44u as=0.2464p ps=1.44u w=0.88u l=1.12u
X28 VMEM_0 neuron_4__Vlk VSS VSS nfet_03v3 ad=0.6p pd=3.2u as=0.6p ps=3.2u w=1u l=1u
X29 VDD DPI_4__VT DPI_4__VT VDD pfet_03v3 ad=0.14p pd=1.06u as=0.14p ps=1.06u w=0.5u l=0.64u
X31 VDD s[6] a_17058_110704# VDD pfet_03v3 ad=0.3p pd=2.2u as=0.3p ps=2.2u w=0.5u l=0.32u
X34 DPI_4__VT DPI_4__VT VDD VDD pfet_03v3 ad=0.14p pd=1.06u as=0.14p ps=1.06u w=0.5u l=0.64u
X38 VDD s[1] a_16558_32028# VSS nfet_03v3 ad=0.3p pd=2.2u as=0.3p ps=2.2u w=0.5u l=0.64u
X56 w_68520_48790# DAC_7__Vb VSS VSS nfet_03v3 ad=0.6p pd=3.2u as=0.6p ps=3.2u w=1u l=8u
X63 w_68520_78994# w[19] a_16310_80708# w_68520_78994# nfet_03v3 ad=0.14p pd=1.06u as=0.14p ps=1.06u w=0.5u l=0.64u
X70 spike[1] VSS cap_mim_2f0_m4m5_noshield c_width=10u c_length=10u
X71 w_68520_78994# DAC_7__Vb VSS VSS nfet_03v3 ad=0.6p pd=3.2u as=0.6p ps=3.2u w=1u l=8u
X81 a_102902_111852# neuron_4__Vamp_bias VSS VSS nfet_03v3 ad=0.3p pd=2.2u as=0.3p ps=2.2u w=0.5u l=0.64u
X85 VDD a_84038_63516# a_79938_57852# VDD pfet_03v3 ad=0.3p pd=2.2u as=0.3p ps=2.2u w=0.5u l=0.64u
X94 a_102902_81648# neuron_4__Vamp_bias VSS VSS nfet_03v3 ad=0.3p pd=2.2u as=0.3p ps=2.2u w=0.5u l=0.64u
X99 VDD DPI_4__Vthr DPI_4__Vthr VDD pfet_03v3 ad=0.14p pd=1.06u as=0.14p ps=1.06u w=0.5u l=0.64u
X106 neuron_4__Vlk neuron_4__Vlk VSS VSS nfet_03v3 ad=0.28p pd=1.56u as=0.6p ps=3.2u w=1u l=1u
X107 w_68520_62978# w[15] a_16310_64692# w_68520_62978# nfet_03v3 ad=0.14p pd=1.06u as=0.14p ps=1.06u w=0.5u l=0.64u
X109 VMEM_1 spike[1] a_106338_32968# VSS nfet_03v3 ad=0.3p pd=2.2u as=0.3p ps=2.2u w=0.5u l=11.36u
X110 spike[0] VSS cap_mim_2f0_m4m5_noshield c_width=10u c_length=10u
X111 a_106338_51444# neuron_4__VK VSS VSS nfet_03v3 ad=0.6p pd=3.2u as=0.6p ps=3.2u w=1u l=1u
X113 w_62932_30314# DAC_7__Vb VSS VSS nfet_03v3 ad=0.6p pd=3.2u as=0.6p ps=3.2u w=1u l=8u
X122 w_68520_123386# DAC_7__Vb VSS VSS nfet_03v3 ad=0.6p pd=3.2u as=0.6p ps=3.2u w=1u l=8u
X123 spike[3] a_105330_81648# a_105710_81648# VSS nfet_03v3 ad=0.3p pd=2.2u as=0.3p ps=2.2u w=0.5u l=0.64u
X145 w_62932_62978# DAC_7__Vb VSS VSS nfet_03v3 ad=0.6p pd=3.2u as=0.6p ps=3.2u w=1u l=8u
X147 VDD DPI_4__Vthr DAC_1__Isum_i DAC_1__Isum_i nfet_03v3 ad=0.3p pd=2.2u as=0.3p ps=2.2u w=0.5u l=0.64u
X148 w_62932_78994# DAC_7__Vb VSS VSS nfet_03v3 ad=0.6p pd=3.2u as=0.6p ps=3.2u w=1u l=8u
X155 w_68520_109198# w[27] a_16310_110912# w_68520_109198# nfet_03v3 ad=0.14p pd=1.06u as=0.14p ps=1.06u w=0.5u l=0.64u
X169 DPI_4__Vthr DPI_4__Vthr VDD VDD pfet_03v3 ad=0.14p pd=1.06u as=0.14p ps=1.06u w=0.5u l=0.64u
X174 a_16310_125100# w[31] w_68520_123386# w_68520_123386# nfet_03v3 ad=0.14p pd=1.06u as=0.14p ps=1.06u w=0.5u l=0.64u
X181 a_16310_125100# w[28] w_52956_123386# w_52956_123386# nfet_03v3 ad=0.3p pd=2.2u as=0.3p ps=2.2u w=0.5u l=0.64u
X195 w_68520_62978# DAC_7__Vb VSS VSS nfet_03v3 ad=0.6p pd=3.2u as=0.6p ps=3.2u w=1u l=8u
X206 VDD neuron_4__VNA a_109144_20808# VDD pfet_03v3 ad=0.6p pd=3.2u as=0.6p ps=3.2u w=1u l=1u
X210 w_68520_93182# DAC_7__Vb VSS VSS nfet_03v3 ad=0.6p pd=3.2u as=0.6p ps=3.2u w=1u l=8u
X212 a_104702_51094# VT a_102902_51444# VSS nfet_03v3 ad=2.4p pd=9.2u as=2.4p ps=9.2u w=4u l=2u
X220 a_16310_94896# w[23] w_68520_93182# w_68520_93182# nfet_03v3 ad=0.14p pd=1.06u as=0.14p ps=1.06u w=0.5u l=0.64u
X226 w_62932_30314# w[6] a_16310_32028# w_62932_30314# nfet_03v3 ad=0.14p pd=1.06u as=0.14p ps=1.06u w=0.5u l=0.64u
X229 w_68520_109198# DAC_7__Vb VSS VSS nfet_03v3 ad=0.6p pd=3.2u as=0.6p ps=3.2u w=1u l=8u
X233 DPI_4__VT DPI_4__VT VDD VDD pfet_03v3 ad=0.14p pd=1.06u as=0.14p ps=1.06u w=0.5u l=0.64u
X240 DAC_1__Isum_i s[6] a_16558_110912# VSS nfet_03v3 ad=0.3p pd=2.2u as=0.3p ps=2.2u w=0.5u l=0.64u
X242 w_52956_30314# DAC_7__Vb VSS VSS nfet_03v3 ad=0.6p pd=3.2u as=0.6p ps=3.2u w=1u l=8u
X246 VDD DPI_4__VT DPI_4__VT VDD pfet_03v3 ad=0.14p pd=1.06u as=0.14p ps=1.06u w=0.5u l=0.64u
X250 neuron_4__Vlk neuron_4__Vlk VSS VSS nfet_03v3 ad=0.28p pd=1.56u as=0.28p ps=1.56u w=1u l=1u
X251 a_105082_14492# neuron_4__VIp VSS VSS nfet_03v3 ad=0.6p pd=3.2u as=0.6p ps=3.2u w=1u l=1u
X271 w_68520_11838# DAC_7__Vb VSS VSS nfet_03v3 ad=0.6p pd=3.2u as=0.6p ps=3.2u w=1u l=8u
X275 a_16310_32028# w[4] w_52956_30314# w_52956_30314# nfet_03v3 ad=0.3p pd=2.2u as=0.3p ps=2.2u w=0.5u l=0.64u
X283 w_57824_123386# DAC_7__Vb VSS VSS nfet_03v3 ad=0.6p pd=3.2u as=0.6p ps=3.2u w=1u l=8u
X285 w_62932_93182# DAC_7__Vb VSS VSS nfet_03v3 ad=0.6p pd=3.2u as=0.6p ps=3.2u w=1u l=8u
X287 a_16310_80708# w[19] w_68520_78994# w_68520_78994# nfet_03v3 ad=0.14p pd=1.06u as=0.14p ps=1.06u w=0.5u l=0.64u
X291 VDD a_103440_20808# a_104702_14142# VDD pfet_03v3 ad=0.3p pd=2.2u as=0.3p ps=2.2u w=0.5u l=8u
X292 w_62932_123386# w[30] a_16310_125100# w_62932_123386# nfet_03v3 ad=0.14p pd=1.06u as=0.14p ps=1.06u w=0.5u l=0.64u
X294 VDD a_79226_82612# VMEM_3 VDD pfet_03v3 ad=0.3p pd=2.2u as=0.3p ps=2.2u w=0.5u l=0.64u
X297 DAC_1__Isum_e a_17058_124892# a_16558_125100# VSS nfet_03v3 ad=0.3p pd=2.2u as=0.3p ps=2.2u w=0.5u l=0.64u
X304 VDD DPI_4__Vthr DPI_4__Vthr VDD pfet_03v3 ad=0.14p pd=1.06u as=0.14p ps=1.06u w=0.5u l=0.64u
X308 w_62932_11838# w[2] a_16310_13552# w_62932_11838# nfet_03v3 ad=0.3p pd=2.2u as=0.14p ps=1.06u w=0.5u l=0.64u
X312 DPI_4__VT DPI_4__VT VDD VDD pfet_03v3 ad=0.14p pd=1.06u as=0.14p ps=1.06u w=0.5u l=0.64u
X319 a_16310_94896# w[21] w_57824_93182# w_57824_93182# nfet_03v3 ad=0.14p pd=1.06u as=0.3p ps=2.2u w=0.5u l=0.64u
X325 a_16310_64692# w[15] w_68520_62978# w_68520_62978# nfet_03v3 ad=0.14p pd=1.06u as=0.14p ps=1.06u w=0.5u l=0.64u
X328 VDD neuron_4__VKup neuron_4__VKup VDD pfet_03v3 ad=0.6p pd=3.2u as=0.6p ps=3.2u w=1u l=8u
X329 a_104702_111502# VT a_102902_111852# VSS nfet_03v3 ad=2.4p pd=9.2u as=2.4p ps=9.2u w=4u l=2u
X334 DAC_3__Isum_e a_17058_80500# a_16558_80708# VSS nfet_03v3 ad=0.3p pd=2.2u as=0.3p ps=2.2u w=0.5u l=0.64u
X349 a_17058_80500# s[4] VSS VSS nfet_03v3 ad=0.3p pd=2.2u as=0.3p ps=2.2u w=0.5u l=0.64u
X364 VMEM_4 spike[4] a_106338_111852# VSS nfet_03v3 ad=0.3p pd=2.2u as=0.3p ps=2.2u w=0.5u l=11.36u
X365 DAC_5__Isum_e a_17058_64484# a_16558_64692# VSS nfet_03v3 ad=0.3p pd=2.2u as=0.3p ps=2.2u w=0.5u l=0.64u
X374 w_68520_109198# w[27] a_16310_110912# w_68520_109198# nfet_03v3 ad=0.3p pd=2.2u as=0.14p ps=1.06u w=0.5u l=0.64u
X378 VDD s[0] a_16558_13552# VSS nfet_03v3 ad=0.3p pd=2.2u as=0.3p ps=2.2u w=0.5u l=0.64u
X385 DPI_4__Vthr DPI_4__Vthr VDD VDD pfet_03v3 ad=0.14p pd=1.06u as=0.14p ps=1.06u w=0.5u l=0.64u
X387 a_17058_64484# s[3] VSS VSS nfet_03v3 ad=0.3p pd=2.2u as=0.3p ps=2.2u w=0.5u l=0.64u
X391 DPI_4__Vthr DPI_4__Vthr VDD VDD pfet_03v3 ad=0.14p pd=1.06u as=0.14p ps=1.06u w=0.5u l=0.64u
X394 VDD s[0] a_17058_13344# VDD pfet_03v3 ad=0.3p pd=2.2u as=0.3p ps=2.2u w=0.5u l=0.32u
X399 VDD a_103440_39284# a_103440_39284# VDD pfet_03v3 ad=0.3p pd=2.2u as=0.3p ps=2.2u w=0.5u l=8u
X412 VDD a_103440_57760# a_104702_51094# VDD pfet_03v3 ad=0.3p pd=2.2u as=0.3p ps=2.2u w=0.5u l=8u
X421 w_62932_48790# w[10] a_16310_50504# w_62932_48790# nfet_03v3 ad=0.3p pd=2.2u as=0.14p ps=1.06u w=0.5u l=0.64u
X422 w_68520_48790# DAC_7__Vb VSS VSS nfet_03v3 ad=0.6p pd=3.2u as=0.6p ps=3.2u w=1u l=8u
X438 w_68520_78994# DAC_7__Vb VSS VSS nfet_03v3 ad=0.6p pd=3.2u as=0.6p ps=3.2u w=1u l=8u
X440 VMEM_2 a_79938_57852# VSS VSS nfet_03v3 ad=1.44p pd=6u as=1.44p ps=6u w=2.4u l=8u
X446 a_79226_33932# a_79226_33932# DAC_6__Isum_e DAC_6__Isum_e nfet_03v3 ad=0.3p pd=2.2u as=0.3p ps=2.2u w=0.5u l=0.64u
X450 a_106338_111852# neuron_4__VK VSS VSS nfet_03v3 ad=0.6p pd=3.2u as=0.6p ps=3.2u w=1u l=1u
X451 VDD neuron_4__VNA a_109144_87964# VDD pfet_03v3 ad=0.6p pd=3.2u as=0.6p ps=3.2u w=1u l=1u
X455 VDD DPI_4__Vthr DAC_7__Isum_e DAC_7__Isum_e nfet_03v3 ad=0.3p pd=2.2u as=0.3p ps=2.2u w=0.5u l=0.64u
X458 a_16310_80708# w[19] w_68520_78994# w_68520_78994# nfet_03v3 ad=0.14p pd=1.06u as=0.3p ps=2.2u w=0.5u l=0.64u
X461 w_68520_123386# w[31] a_16310_125100# w_68520_123386# nfet_03v3 ad=0.14p pd=1.06u as=0.14p ps=1.06u w=0.5u l=0.64u
X463 a_16310_32028# w[6] w_62932_30314# w_62932_30314# nfet_03v3 ad=0.14p pd=1.06u as=0.14p ps=1.06u w=0.5u l=0.64u
X464 neuron_4__VIp neuron_4__VIp VSS VSS nfet_03v3 ad=0.6p pd=3.2u as=0.6p ps=3.2u w=1u l=1u
X473 bias_0__VT_inh bias_0__VT_inh VDD VDD pfet_03v3 ad=0.2464p pd=1.44u as=0.2464p ps=1.44u w=0.88u l=1.12u
X486 DAC_5__Isum_i s[2] a_16558_50504# VSS nfet_03v3 ad=0.3p pd=2.2u as=0.3p ps=2.2u w=0.5u l=0.64u
X490 w_57824_48790# DAC_7__Vb VSS VSS nfet_03v3 ad=0.6p pd=3.2u as=0.6p ps=3.2u w=1u l=8u
X491 a_16310_64692# w[15] w_68520_62978# w_68520_62978# nfet_03v3 ad=0.14p pd=1.06u as=0.3p ps=2.2u w=0.5u l=0.64u
X505 w_62932_78994# DAC_7__Vb VSS VSS nfet_03v3 ad=0.6p pd=3.2u as=0.6p ps=3.2u w=1u l=8u
X529 VDD DPI_4__VT a_79226_15456# VDD pfet_03v3 ad=0.3p pd=2.2u as=0.3p ps=2.2u w=0.5u l=0.64u
X530 VSS neuron_4__VKdn neuron_4__VKdn VSS nfet_03v3 ad=0.28p pd=1.56u as=0.28p ps=1.56u w=1u l=1u
X540 DPI_4__VT DPI_4__VT VDD VDD pfet_03v3 ad=0.14p pd=1.06u as=0.14p ps=1.06u w=0.5u l=0.64u
X546 VDD DPI_4__VT DPI_4__VT VDD pfet_03v3 ad=0.14p pd=1.06u as=0.14p ps=1.06u w=0.5u l=0.64u
X548 w_68520_30314# DAC_7__Vb VSS VSS nfet_03v3 ad=0.6p pd=3.2u as=0.6p ps=3.2u w=1u l=8u
X551 DPI_4__VT DPI_4__VT VDD VDD pfet_03v3 ad=0.14p pd=1.06u as=0.14p ps=1.06u w=0.5u l=0.64u
X552 w_68520_123386# DAC_7__Vb VSS VSS nfet_03v3 ad=0.6p pd=3.2u as=0.6p ps=3.2u w=1u l=8u
X558 a_16310_80708# w[19] w_68520_78994# w_68520_78994# nfet_03v3 ad=0.14p pd=1.06u as=0.14p ps=1.06u w=0.5u l=0.64u
X559 DAC_1__Isum_i s[7] a_16558_125100# VSS nfet_03v3 ad=0.3p pd=2.2u as=0.3p ps=2.2u w=0.5u l=0.64u
X576 w_68520_62978# DAC_7__Vb VSS VSS nfet_03v3 ad=0.6p pd=3.2u as=0.6p ps=3.2u w=1u l=8u
X578 w_62932_11838# w[2] a_16310_13552# w_62932_11838# nfet_03v3 ad=0.14p pd=1.06u as=0.14p ps=1.06u w=0.5u l=0.64u
X590 w_68520_93182# DAC_7__Vb VSS VSS nfet_03v3 ad=0.6p pd=3.2u as=0.6p ps=3.2u w=1u l=8u
X592 a_16310_64692# w[15] w_68520_62978# w_68520_62978# nfet_03v3 ad=0.14p pd=1.06u as=0.14p ps=1.06u w=0.5u l=0.64u
X607 VMEM_0 spike[0] a_106338_14492# VSS nfet_03v3 ad=0.3p pd=2.2u as=0.3p ps=2.2u w=0.5u l=11.36u
X629 a_16310_13552# w[0] w_52956_11838# w_52956_11838# nfet_03v3 ad=0.3p pd=2.2u as=0.3p ps=2.2u w=0.5u l=0.64u
X630 VDD DPI_4__VT a_79226_52408# VDD pfet_03v3 ad=0.3p pd=2.2u as=0.3p ps=2.2u w=0.5u l=0.64u
X637 w_57824_62978# DAC_7__Vb VSS VSS nfet_03v3 ad=0.6p pd=3.2u as=0.6p ps=3.2u w=1u l=8u
X644 w_68520_11838# DAC_7__Vb VSS VSS nfet_03v3 ad=0.6p pd=3.2u as=0.6p ps=3.2u w=1u l=8u
X651 w_62932_93182# DAC_7__Vb VSS VSS nfet_03v3 ad=0.6p pd=3.2u as=0.6p ps=3.2u w=1u l=8u
X655 bias_0__VT_inh bias_0__VT_inh VDD VDD pfet_03v3 ad=0.2464p pd=1.44u as=0.2464p ps=1.44u w=0.88u l=1.12u
X671 DPI_4__Vthr DPI_4__Vthr VDD VDD pfet_03v3 ad=0.14p pd=1.06u as=0.14p ps=1.06u w=0.5u l=0.64u
X678 VDD DPI_4__Vthr DPI_4__Vthr VDD pfet_03v3 ad=0.14p pd=1.06u as=0.14p ps=1.06u w=0.5u l=0.64u
X683 w_62932_48790# w[10] a_16310_50504# w_62932_48790# nfet_03v3 ad=0.14p pd=1.06u as=0.14p ps=1.06u w=0.5u l=0.64u
X684 w_68520_123386# w[31] a_16310_125100# w_68520_123386# nfet_03v3 ad=0.3p pd=2.2u as=0.14p ps=1.06u w=0.5u l=0.64u
X696 DAC_7__Vb DAC_7__Vb VSS VSS nfet_03v3 ad=0.6p pd=3.2u as=0.6p ps=3.2u w=1u l=8u
X703 neuron_4__Vlk neuron_4__Vlk VSS VSS nfet_03v3 ad=0.28p pd=1.56u as=0.28p ps=1.56u w=1u l=1u
X711 w_57824_11838# DAC_7__Vb VSS VSS nfet_03v3 ad=0.6p pd=3.2u as=0.6p ps=3.2u w=1u l=8u
X713 VMEM_2 spike[2] a_106338_51444# VSS nfet_03v3 ad=0.3p pd=2.2u as=0.3p ps=2.2u w=0.5u l=11.36u
X718 w_68520_93182# w[23] a_16310_94896# w_68520_93182# nfet_03v3 ad=0.14p pd=1.06u as=0.14p ps=1.06u w=0.5u l=0.64u
X719 w_62932_109198# DAC_7__Vb VSS VSS nfet_03v3 ad=0.6p pd=3.2u as=0.6p ps=3.2u w=1u l=8u
X721 w_62932_48790# DAC_7__Vb VSS VSS nfet_03v3 ad=0.6p pd=3.2u as=0.6p ps=3.2u w=1u l=8u
X724 a_16558_32028# pulse[1] a_16310_32028# VSS nfet_03v3 ad=0.3p pd=2.2u as=0.3p ps=2.2u w=0.5u l=0.64u
X726 a_16310_32028# w[6] w_62932_30314# w_62932_30314# nfet_03v3 ad=0.14p pd=1.06u as=0.3p ps=2.2u w=0.5u l=0.64u
X730 VDD a_103440_20808# a_103440_20808# VDD pfet_03v3 ad=0.3p pd=2.2u as=0.3p ps=2.2u w=0.5u l=8u
X738 a_16310_50504# w[8] w_52956_48790# w_52956_48790# nfet_03v3 ad=0.3p pd=2.2u as=0.3p ps=2.2u w=0.5u l=0.64u
X758 VDD bias_0__VT_inh bias_0__VT_inh VDD pfet_03v3 ad=0.2464p pd=1.44u as=0.2464p ps=1.44u w=0.88u l=1.12u
X764 w_57824_30314# w[5] a_16310_32028# w_57824_30314# nfet_03v3 ad=0.3p pd=2.2u as=0.14p ps=1.06u w=0.5u l=0.64u
X768 w_68520_11838# DAC_7__Vb VSS VSS nfet_03v3 ad=0.6p pd=3.2u as=0.6p ps=3.2u w=1u l=8u
X772 w_68520_109198# DAC_7__Vb VSS VSS nfet_03v3 ad=0.6p pd=3.2u as=0.6p ps=3.2u w=1u l=8u
X781 a_105330_32968# a_104702_32618# a_105082_32968# VSS nfet_03v3 ad=0.3p pd=2.2u as=0.3p ps=2.2u w=0.5u l=0.64u
X791 VDD DPI_4__VT a_84038_123924# VDD pfet_03v3 ad=0.3p pd=2.2u as=0.3p ps=2.2u w=0.5u l=0.64u
X795 a_16310_13552# w[2] w_62932_11838# w_62932_11838# nfet_03v3 ad=0.14p pd=1.06u as=0.14p ps=1.06u w=0.5u l=0.64u
X809 w_68520_93182# w[23] a_16310_94896# w_68520_93182# nfet_03v3 ad=0.3p pd=2.2u as=0.14p ps=1.06u w=0.5u l=0.64u
X823 VDD DPI_4__VT DPI_4__VT VDD pfet_03v3 ad=0.14p pd=1.06u as=0.14p ps=1.06u w=0.5u l=0.64u
X828 DPI_4__VT DPI_4__VT VDD VDD pfet_03v3 ad=0.14p pd=1.06u as=0.14p ps=1.06u w=0.5u l=0.64u
X837 VDD s[1] a_17058_31820# VDD pfet_03v3 ad=0.3p pd=2.2u as=0.3p ps=2.2u w=0.5u l=0.32u
X840 VDD a_103440_57760# a_103440_57760# VDD pfet_03v3 ad=0.3p pd=2.2u as=0.3p ps=2.2u w=0.5u l=8u
X844 a_105710_81648# neuron_4__VKdn VSS VSS nfet_03v3 ad=0.6p pd=3.2u as=0.6p ps=3.2u w=1u l=1u
X846 w_52956_48790# DAC_7__Vb VSS VSS nfet_03v3 ad=0.6p pd=3.2u as=0.6p ps=3.2u w=1u l=8u
X852 VDD a_104702_81298# a_105330_81648# VDD pfet_03v3 ad=0.3p pd=2.2u as=0.3p ps=2.2u w=0.5u l=0.64u
X854 w_62932_62978# DAC_7__Vb VSS VSS nfet_03v3 ad=0.6p pd=3.2u as=0.6p ps=3.2u w=1u l=8u
X855 neuron_4__VKup Iref VSS VSS nfet_03v3 ad=3.606p pd=13.22u as=3.606p ps=13.22u w=6.01u l=8u
X864 w_62932_78994# DAC_7__Vb VSS VSS nfet_03v3 ad=0.6p pd=3.2u as=0.6p ps=3.2u w=1u l=8u
X866 a_84038_93720# a_84038_93720# DAC_3__Isum_i DAC_3__Isum_i nfet_03v3 ad=0.3p pd=2.2u as=0.3p ps=2.2u w=0.5u l=0.64u
X869 a_105082_111852# neuron_4__VIp VSS VSS nfet_03v3 ad=0.6p pd=3.2u as=0.6p ps=3.2u w=1u l=1u
X872 w_68520_93182# w[23] a_16310_94896# w_68520_93182# nfet_03v3 ad=0.14p pd=1.06u as=0.14p ps=1.06u w=0.5u l=0.64u
X873 VDD DPI_4__VT a_84038_93720# VDD pfet_03v3 ad=0.3p pd=2.2u as=0.3p ps=2.2u w=0.5u l=0.64u
X879 a_103440_87964# VMEM_3 a_102902_81648# VSS nfet_03v3 ad=2.4p pd=9.2u as=2.4p ps=9.2u w=4u l=2u
X886 a_38446_142736# Iref VSS VSS nfet_03v3 ad=6p pd=21.2u as=6p ps=21.2u w=10u l=8u
X889 a_79226_52408# a_79226_52408# DAC_5__Isum_e DAC_5__Isum_e nfet_03v3 ad=0.3p pd=2.2u as=0.3p ps=2.2u w=0.5u l=0.64u
X891 DPI_4__Vthr DPI_4__Vthr VDD VDD pfet_03v3 ad=0.14p pd=1.06u as=0.14p ps=1.06u w=0.5u l=0.64u
X895 a_109144_87964# a_105330_81648# VMEM_3 VDD pfet_03v3 ad=0.3p pd=2.2u as=0.3p ps=2.2u w=0.5u l=0.64u
X897 VDD DPI_4__Vthr DPI_4__Vthr VDD pfet_03v3 ad=0.14p pd=1.06u as=0.14p ps=1.06u w=0.5u l=0.64u
X900 VMEM_2 neuron_4__Vlk VSS VSS nfet_03v3 ad=0.6p pd=3.2u as=0.6p ps=3.2u w=1u l=1u
X902 w_68520_30314# DAC_7__Vb VSS VSS nfet_03v3 ad=0.6p pd=3.2u as=0.6p ps=3.2u w=1u l=8u
X903 a_16310_50504# w[10] w_62932_48790# w_62932_48790# nfet_03v3 ad=0.14p pd=1.06u as=0.14p ps=1.06u w=0.5u l=0.64u
X907 spike[3] VSS cap_mim_2f0_m4m5_noshield c_width=10u c_length=10u
X930 w_68520_78994# DAC_7__Vb VSS VSS nfet_03v3 ad=0.6p pd=3.2u as=0.6p ps=3.2u w=1u l=8u
X951 DPI_4__Vthr DPI_4__Vthr VDD VDD pfet_03v3 ad=0.14p pd=1.06u as=0.14p ps=1.06u w=0.5u l=0.64u
X961 VDD DPI_4__VT a_79226_33932# VDD pfet_03v3 ad=0.3p pd=2.2u as=0.3p ps=2.2u w=0.5u l=0.64u
X965 VDD DPI_4__Vthr DPI_4__Vthr VDD pfet_03v3 ad=0.14p pd=1.06u as=0.14p ps=1.06u w=0.5u l=0.64u
X968 w_57824_30314# DAC_7__Vb VSS VSS nfet_03v3 ad=0.6p pd=3.2u as=0.6p ps=3.2u w=1u l=8u
X970 w_68520_93182# w[23] a_16310_94896# w_68520_93182# nfet_03v3 ad=0.14p pd=1.06u as=0.14p ps=1.06u w=0.5u l=0.64u
X976 a_106338_81648# neuron_4__VK VSS VSS nfet_03v3 ad=0.6p pd=3.2u as=0.6p ps=3.2u w=1u l=1u
X992 w_52956_62978# DAC_7__Vb VSS VSS nfet_03v3 ad=0.6p pd=3.2u as=0.6p ps=3.2u w=1u l=8u
X995 a_108516_39284# a_105330_32968# spike[1] VDD pfet_03v3 ad=0.3p pd=2.2u as=0.3p ps=2.2u w=0.5u l=0.64u
X997 VDD s[5] a_17058_94688# VDD pfet_03v3 ad=0.3p pd=2.2u as=0.3p ps=2.2u w=0.5u l=0.32u
X1011 w_62932_93182# DAC_7__Vb VSS VSS nfet_03v3 ad=0.6p pd=3.2u as=0.6p ps=3.2u w=1u l=8u
X1017 VDD DPI_4__VT a_79226_112816# VDD pfet_03v3 ad=0.3p pd=2.2u as=0.3p ps=2.2u w=0.5u l=0.64u
X1018 w_62932_123386# DAC_7__Vb VSS VSS nfet_03v3 ad=0.6p pd=3.2u as=0.6p ps=3.2u w=1u l=8u
X1027 w_62932_109198# DAC_7__Vb VSS VSS nfet_03v3 ad=0.6p pd=3.2u as=0.6p ps=3.2u w=1u l=8u
X1031 w_68520_30314# DAC_7__Vb VSS VSS nfet_03v3 ad=0.6p pd=3.2u as=0.6p ps=3.2u w=1u l=8u
X1040 VDD a_84038_123924# a_79938_118260# VDD pfet_03v3 ad=0.3p pd=2.2u as=0.3p ps=2.2u w=0.5u l=0.64u
X1042 VDD DPI_4__VT DPI_4__VT VDD pfet_03v3 ad=0.14p pd=1.06u as=0.14p ps=1.06u w=0.5u l=0.64u
X1048 DPI_4__VT DPI_4__VT VDD VDD pfet_03v3 ad=0.14p pd=1.06u as=0.14p ps=1.06u w=0.5u l=0.64u
X1056 a_16558_13552# pulse[0] a_16310_13552# VSS nfet_03v3 ad=0.3p pd=2.2u as=0.3p ps=2.2u w=0.5u l=0.64u
X1058 a_109144_118168# a_105330_111852# VMEM_4 VDD pfet_03v3 ad=0.3p pd=2.2u as=0.3p ps=2.2u w=0.5u l=0.64u
X1059 a_16310_13552# w[2] w_62932_11838# w_62932_11838# nfet_03v3 ad=0.14p pd=1.06u as=0.3p ps=2.2u w=0.5u l=0.64u
X1076 w_68520_93182# DAC_7__Vb VSS VSS nfet_03v3 ad=0.6p pd=3.2u as=0.6p ps=3.2u w=1u l=8u
X1080 w_68520_123386# DAC_7__Vb VSS VSS nfet_03v3 ad=0.6p pd=3.2u as=0.6p ps=3.2u w=1u l=8u
X1087 a_104702_81298# VT a_102902_81648# VSS nfet_03v3 ad=2.4p pd=9.2u as=2.4p ps=9.2u w=4u l=2u
X1088 VDD DPI_4__Vthr DAC_1__Isum_e DAC_1__Isum_e nfet_03v3 ad=0.3p pd=2.2u as=0.3p ps=2.2u w=0.5u l=0.64u
X1096 w_57824_11838# w[1] a_16310_13552# w_57824_11838# nfet_03v3 ad=0.3p pd=2.2u as=0.14p ps=1.06u w=0.5u l=0.64u
X1102 w_57824_109198# w[25] a_16310_110912# w_57824_109198# nfet_03v3 ad=0.3p pd=2.2u as=0.14p ps=1.06u w=0.5u l=0.64u
X1111 DPI_4__VT DPI_4__VT VDD VDD pfet_03v3 ad=0.14p pd=1.06u as=0.14p ps=1.06u w=0.5u l=0.64u
X1112 spike[2] VSS cap_mim_2f0_m4m5_noshield c_width=10u c_length=10u
X1115 a_105082_51444# neuron_4__VIp VSS VSS nfet_03v3 ad=0.6p pd=3.2u as=0.6p ps=3.2u w=1u l=1u
X1120 bias_0__VT_inh Iref VSS VSS nfet_03v3 ad=0.378p pd=2.46u as=0.378p ps=2.46u w=0.63u l=32u
X1125 w_68520_11838# DAC_7__Vb VSS VSS nfet_03v3 ad=0.6p pd=3.2u as=0.6p ps=3.2u w=1u l=8u
X1132 w_68520_48790# DAC_7__Vb VSS VSS nfet_03v3 ad=0.6p pd=3.2u as=0.6p ps=3.2u w=1u l=8u
X1152 a_16310_32028# w[7] w_68520_30314# w_68520_30314# nfet_03v3 ad=0.14p pd=1.06u as=0.14p ps=1.06u w=0.5u l=0.64u
X1153 a_16558_50504# spike[0] a_16310_50504# VSS nfet_03v3 ad=0.3p pd=2.2u as=0.3p ps=2.2u w=0.5u l=0.64u
X1154 a_16310_50504# w[10] w_62932_48790# w_62932_48790# nfet_03v3 ad=0.14p pd=1.06u as=0.3p ps=2.2u w=0.5u l=0.64u
X1159 VDD DPI_4__Vthr DPI_4__Vthr VDD pfet_03v3 ad=0.14p pd=1.06u as=0.14p ps=1.06u w=0.5u l=0.64u
X1164 VDD a_38446_142736# neuron_4__VK VDD pfet_03v3 ad=6.27p pd=22.1u as=6.27p ps=22.1u w=10.45u l=8u
X1165 DPI_4__Vthr DPI_4__Vthr VDD VDD pfet_03v3 ad=0.14p pd=1.06u as=0.14p ps=1.06u w=0.5u l=0.64u
X1191 VDD bias_0__VT_inh bias_0__VT_inh VDD pfet_03v3 ad=0.2464p pd=1.44u as=0.2464p ps=1.44u w=0.88u l=1.12u
X1192 a_16310_94896# w[23] w_68520_93182# w_68520_93182# nfet_03v3 ad=0.14p pd=1.06u as=0.14p ps=1.06u w=0.5u l=0.64u
X1194 w_68520_109198# DAC_7__Vb VSS VSS nfet_03v3 ad=0.6p pd=3.2u as=0.6p ps=3.2u w=1u l=8u
X1196 neuron_4__VKdn neuron_4__VKdn VSS VSS nfet_03v3 ad=0.28p pd=1.56u as=0.6p ps=3.2u w=1u l=1u
X1211 w_57824_48790# w[9] a_16310_50504# w_57824_48790# nfet_03v3 ad=0.3p pd=2.2u as=0.14p ps=1.06u w=0.5u l=0.64u
X1215 VSS neuron_4__Vlk neuron_4__Vlk VSS nfet_03v3 ad=0.28p pd=1.56u as=0.28p ps=1.56u w=1u l=1u
X1226 VDD a_103440_118168# a_104702_111502# VDD pfet_03v3 ad=0.3p pd=2.2u as=0.3p ps=2.2u w=0.5u l=8u
X1235 DAC_3__Isum_e a_17058_94688# a_16558_94896# VSS nfet_03v3 ad=0.3p pd=2.2u as=0.3p ps=2.2u w=0.5u l=0.64u
X1251 a_16310_32028# w[5] w_57824_30314# w_57824_30314# nfet_03v3 ad=0.14p pd=1.06u as=0.3p ps=2.2u w=0.5u l=0.64u
X1260 a_17058_94688# s[5] VSS VSS nfet_03v3 ad=0.3p pd=2.2u as=0.3p ps=2.2u w=0.5u l=0.64u
X1267 VDD a_79226_112816# VMEM_4 VDD pfet_03v3 ad=0.3p pd=2.2u as=0.3p ps=2.2u w=0.5u l=0.64u
X1273 VDD neuron_4__VKup a_108516_39284# VDD pfet_03v3 ad=0.6p pd=3.2u as=0.6p ps=3.2u w=1u l=1u
X1278 a_105330_14492# a_104702_14142# a_105082_14492# VSS nfet_03v3 ad=0.3p pd=2.2u as=0.3p ps=2.2u w=0.5u l=0.64u
X1281 a_16310_110912# w[26] w_62932_109198# w_62932_109198# nfet_03v3 ad=0.14p pd=1.06u as=0.3p ps=2.2u w=0.5u l=0.64u
X1287 VDD a_103440_87964# a_104702_81298# VDD pfet_03v3 ad=0.3p pd=2.2u as=0.3p ps=2.2u w=0.5u l=8u
X1289 VDD bias_0__VT_inh bias_0__VT_inh VDD pfet_03v3 ad=0.2464p pd=1.44u as=0.2464p ps=1.44u w=0.88u l=1.12u
X1291 w_68520_62978# DAC_7__Vb VSS VSS nfet_03v3 ad=0.6p pd=3.2u as=0.6p ps=3.2u w=1u l=8u
X1294 w_62932_78994# w[18] a_16310_80708# w_62932_78994# nfet_03v3 ad=0.3p pd=2.2u as=0.14p ps=1.06u w=0.5u l=0.64u
X1297 w_68520_78994# DAC_7__Vb VSS VSS nfet_03v3 ad=0.6p pd=3.2u as=0.6p ps=3.2u w=1u l=8u
X1300 VDD bias_0__VT_inh bias_0__VT_inh VDD pfet_03v3 ad=0.2464p pd=1.44u as=0.2464p ps=1.44u w=0.88u l=1.12u
X1304 VMEM_4 neuron_4__Vlk VSS VSS nfet_03v3 ad=0.6p pd=3.2u as=0.6p ps=3.2u w=1u l=1u
X1313 VMEM_3 a_79938_88056# VSS VSS nfet_03v3 ad=1.44p pd=6u as=1.44p ps=6u w=2.4u l=8u
X1324 DPI_4__VT DPI_4__VT VDD VDD pfet_03v3 ad=0.14p pd=1.06u as=0.14p ps=1.06u w=0.5u l=0.64u
X1327 a_108516_20808# a_105330_14492# spike[0] VDD pfet_03v3 ad=0.3p pd=2.2u as=0.3p ps=2.2u w=0.5u l=0.64u
X1328 w_62932_62978# w[14] a_16310_64692# w_62932_62978# nfet_03v3 ad=0.3p pd=2.2u as=0.14p ps=1.06u w=0.5u l=0.64u
X1331 VDD DPI_4__VT DPI_4__VT VDD pfet_03v3 ad=0.14p pd=1.06u as=0.14p ps=1.06u w=0.5u l=0.64u
X1338 w_62932_123386# DAC_7__Vb VSS VSS nfet_03v3 ad=0.6p pd=3.2u as=0.6p ps=3.2u w=1u l=8u
X1349 DPI_4__VT Iref VSS VSS nfet_03v3 ad=0.702p pd=3.54u as=0.702p ps=3.54u w=1.17u l=32u
X1357 DAC_3__Isum_i s[4] a_16558_80708# VSS nfet_03v3 ad=0.3p pd=2.2u as=0.3p ps=2.2u w=0.5u l=0.64u
X1361 a_16310_94896# w[23] w_68520_93182# w_68520_93182# nfet_03v3 ad=0.14p pd=1.06u as=0.3p ps=2.2u w=0.5u l=0.64u
X1362 w_57824_78994# DAC_7__Vb VSS VSS nfet_03v3 ad=0.6p pd=3.2u as=0.6p ps=3.2u w=1u l=8u
X1365 a_105710_111852# neuron_4__VKdn VSS VSS nfet_03v3 ad=0.6p pd=3.2u as=0.6p ps=3.2u w=1u l=1u
X1372 VDD bias_0__VT_inh bias_0__VT_inh VDD pfet_03v3 ad=0.528p pd=2.96u as=0.2464p ps=1.44u w=0.88u l=1.12u
X1380 VSS neuron_4__Vlk neuron_4__Vlk VSS nfet_03v3 ad=0.28p pd=1.56u as=0.28p ps=1.56u w=1u l=1u
X1386 a_105330_51444# a_104702_51094# a_105082_51444# VSS nfet_03v3 ad=0.3p pd=2.2u as=0.3p ps=2.2u w=0.5u l=0.64u
X1390 a_84038_123924# a_84038_123924# DAC_1__Isum_i DAC_1__Isum_i nfet_03v3 ad=0.3p pd=2.2u as=0.3p ps=2.2u w=0.5u l=0.64u
X1397 DAC_5__Isum_i s[3] a_16558_64692# VSS nfet_03v3 ad=0.3p pd=2.2u as=0.3p ps=2.2u w=0.5u l=0.64u
X1398 VDD DPI_4__Vthr DPI_4__Vthr VDD pfet_03v3 ad=0.14p pd=1.06u as=0.14p ps=1.06u w=0.5u l=0.64u
X1406 w_68520_30314# DAC_7__Vb VSS VSS nfet_03v3 ad=0.6p pd=3.2u as=0.6p ps=3.2u w=1u l=8u
X1424 a_79226_112816# a_79226_112816# DAC_1__Isum_e DAC_1__Isum_e nfet_03v3 ad=0.3p pd=2.2u as=0.3p ps=2.2u w=0.5u l=0.64u
X1425 w_57824_123386# w[29] a_16310_125100# w_57824_123386# nfet_03v3 ad=0.3p pd=2.2u as=0.14p ps=1.06u w=0.5u l=0.64u
X1429 VDD DPI_4__Vthr DAC_5__Isum_i DAC_5__Isum_i nfet_03v3 ad=0.3p pd=2.2u as=0.3p ps=2.2u w=0.5u l=0.64u
X1436 VMEM_0 VSS cap_mim_2f0_m4m5_noshield c_width=22.18u c_length=22.18u
X1445 a_17058_110704# s[6] VSS VSS nfet_03v3 ad=0.3p pd=2.2u as=0.3p ps=2.2u w=0.5u l=0.64u
X1450 w_68520_93182# DAC_7__Vb VSS VSS nfet_03v3 ad=0.6p pd=3.2u as=0.6p ps=3.2u w=1u l=8u
X1453 a_108516_57760# a_105330_51444# spike[2] VDD pfet_03v3 ad=0.3p pd=2.2u as=0.3p ps=2.2u w=0.5u l=0.64u
X1454 VDD s[2] a_17058_50296# VDD pfet_03v3 ad=0.3p pd=2.2u as=0.3p ps=2.2u w=0.5u l=0.32u
X1459 a_16310_110912# w[27] w_68520_109198# w_68520_109198# nfet_03v3 ad=0.14p pd=1.06u as=0.14p ps=1.06u w=0.5u l=0.64u
X1467 w_62932_109198# DAC_7__Vb VSS VSS nfet_03v3 ad=0.6p pd=3.2u as=0.6p ps=3.2u w=1u l=8u
X1470 VDD DPI_4__Vthr DPI_4__Vthr VDD pfet_03v3 ad=0.14p pd=1.06u as=0.14p ps=1.06u w=0.5u l=0.64u
X1473 a_16310_94896# w[23] w_68520_93182# w_68520_93182# nfet_03v3 ad=0.14p pd=1.06u as=0.14p ps=1.06u w=0.5u l=0.64u
X1478 VSS neuron_4__Vlk neuron_4__Vlk VSS nfet_03v3 ad=0.28p pd=1.56u as=0.28p ps=1.56u w=1u l=1u
X1508 w_68520_11838# DAC_7__Vb VSS VSS nfet_03v3 ad=0.6p pd=3.2u as=0.6p ps=3.2u w=1u l=8u
X1512 a_16310_13552# w[3] w_68520_11838# w_68520_11838# nfet_03v3 ad=0.14p pd=1.06u as=0.14p ps=1.06u w=0.5u l=0.64u
X1516 w_68520_123386# DAC_7__Vb VSS VSS nfet_03v3 ad=0.6p pd=3.2u as=0.6p ps=3.2u w=1u l=8u
X1517 w_57824_93182# DAC_7__Vb VSS VSS nfet_03v3 ad=0.6p pd=3.2u as=0.6p ps=3.2u w=1u l=8u
X1518 w_68520_48790# DAC_7__Vb VSS VSS nfet_03v3 ad=0.6p pd=3.2u as=0.6p ps=3.2u w=1u l=8u
X1532 w_68520_109198# w[27] a_16310_110912# w_68520_109198# nfet_03v3 ad=0.14p pd=1.06u as=0.14p ps=1.06u w=0.5u l=0.64u
X1553 VDD a_79226_15456# VMEM_0 VDD pfet_03v3 ad=0.3p pd=2.2u as=0.3p ps=2.2u w=0.5u l=0.64u
X1558 DPI_4__VT DPI_4__VT VDD VDD pfet_03v3 ad=0.14p pd=1.06u as=0.14p ps=1.06u w=0.5u l=0.64u
X1561 VDD a_84038_123924# cap_mim_2f0_m4m5_noshield c_width=22.18u c_length=22.18u
X1562 VDD DPI_4__VT DPI_4__VT VDD pfet_03v3 ad=0.14p pd=1.06u as=0.14p ps=1.06u w=0.5u l=0.64u
X1565 w_62932_78994# w[18] a_16310_80708# w_62932_78994# nfet_03v3 ad=0.14p pd=1.06u as=0.14p ps=1.06u w=0.5u l=0.64u
X1580 w_62932_11838# DAC_7__Vb VSS VSS nfet_03v3 ad=0.6p pd=3.2u as=0.6p ps=3.2u w=1u l=8u
X1581 w_62932_109198# w[26] a_16310_110912# w_62932_109198# nfet_03v3 ad=0.3p pd=2.2u as=0.14p ps=1.06u w=0.5u l=0.64u
X1593 w_57824_48790# DAC_7__Vb VSS VSS nfet_03v3 ad=0.6p pd=3.2u as=0.6p ps=3.2u w=1u l=8u
X1596 VMEM_3 spike[3] a_106338_81648# VSS nfet_03v3 ad=0.3p pd=2.2u as=0.3p ps=2.2u w=0.5u l=11.36u
X1602 VDD DPI_4__Vthr DAC_6__Isum_e DAC_6__Isum_e nfet_03v3 ad=0.3p pd=2.2u as=0.3p ps=2.2u w=0.5u l=0.64u
X1603 w_62932_62978# w[14] a_16310_64692# w_62932_62978# nfet_03v3 ad=0.14p pd=1.06u as=0.14p ps=1.06u w=0.5u l=0.64u
X1605 w_62932_78994# DAC_7__Vb VSS VSS nfet_03v3 ad=0.6p pd=3.2u as=0.6p ps=3.2u w=1u l=8u
X1607 VDD a_38446_142736# neuron_4__Vamp_bias VDD pfet_03v3 ad=5.484p pd=19.48u as=5.484p ps=19.48u w=9.14u l=8u
X1610 a_16310_125100# w[30] w_62932_123386# w_62932_123386# nfet_03v3 ad=0.14p pd=1.06u as=0.3p ps=2.2u w=0.5u l=0.64u
X1614 a_16310_13552# w[1] w_57824_11838# w_57824_11838# nfet_03v3 ad=0.14p pd=1.06u as=0.3p ps=2.2u w=0.5u l=0.64u
X1616 VMEM_3 VSS cap_mim_2f0_m4m5_noshield c_width=22.18u c_length=22.18u
X1623 a_16310_80708# w[16] w_52956_78994# w_52956_78994# nfet_03v3 ad=0.3p pd=2.2u as=0.3p ps=2.2u w=0.5u l=0.64u
X1624 VDD a_79226_82612# cap_mim_2f0_m4m5_noshield c_width=22.18u c_length=22.18u
X1631 a_16310_50504# w[11] w_68520_48790# w_68520_48790# nfet_03v3 ad=0.14p pd=1.06u as=0.14p ps=1.06u w=0.5u l=0.64u
X1634 DPI_4__VT DPI_4__VT VDD VDD pfet_03v3 ad=0.14p pd=1.06u as=0.14p ps=1.06u w=0.5u l=0.64u
X1646 VDD DPI_4__VT DPI_4__VT VDD pfet_03v3 ad=0.14p pd=1.06u as=0.14p ps=1.06u w=0.5u l=0.64u
X1663 w_68520_48790# DAC_7__Vb VSS VSS nfet_03v3 ad=0.6p pd=3.2u as=0.6p ps=3.2u w=1u l=8u
X1666 a_16310_64692# w[12] w_52956_62978# w_52956_62978# nfet_03v3 ad=0.3p pd=2.2u as=0.3p ps=2.2u w=0.5u l=0.64u
X1670 neuron_4__VKdn neuron_4__VKdn VSS VSS nfet_03v3 ad=0.28p pd=1.56u as=0.28p ps=1.56u w=1u l=1u
X1672 VDD a_79226_52408# VMEM_2 VDD pfet_03v3 ad=0.3p pd=2.2u as=0.3p ps=2.2u w=0.5u l=0.64u
X1677 w_68520_30314# w[7] a_16310_32028# w_68520_30314# nfet_03v3 ad=0.14p pd=1.06u as=0.14p ps=1.06u w=0.5u l=0.64u
X1680 VDD a_79226_15456# cap_mim_2f0_m4m5_noshield c_width=22.18u c_length=22.18u
X1685 w_68520_62978# DAC_7__Vb VSS VSS nfet_03v3 ad=0.6p pd=3.2u as=0.6p ps=3.2u w=1u l=8u
X1716 VDD DPI_4__Vthr DPI_4__Vthr VDD pfet_03v3 ad=0.14p pd=1.06u as=0.14p ps=1.06u w=0.5u l=0.64u
X1732 a_16310_50504# w[9] w_57824_48790# w_57824_48790# nfet_03v3 ad=0.14p pd=1.06u as=0.3p ps=2.2u w=0.5u l=0.64u
X1733 VSS neuron_4__Vlk neuron_4__Vlk VSS nfet_03v3 ad=0.6p pd=3.2u as=0.28p ps=1.56u w=1u l=1u
X1752 VDD neuron_4__VKup a_108516_57760# VDD pfet_03v3 ad=0.6p pd=3.2u as=0.6p ps=3.2u w=1u l=1u
X1753 VDD a_103440_87964# a_103440_87964# VDD pfet_03v3 ad=0.3p pd=2.2u as=0.3p ps=2.2u w=0.5u l=8u
X1759 w_57824_62978# DAC_7__Vb VSS VSS nfet_03v3 ad=0.6p pd=3.2u as=0.6p ps=3.2u w=1u l=8u
X1764 w_52956_78994# DAC_7__Vb VSS VSS nfet_03v3 ad=0.6p pd=3.2u as=0.6p ps=3.2u w=1u l=8u
X1770 w_62932_93182# DAC_7__Vb VSS VSS nfet_03v3 ad=0.6p pd=3.2u as=0.6p ps=3.2u w=1u l=8u
X1771 VDD bias_0__VT_inh bias_0__VT_inh VDD pfet_03v3 ad=0.2464p pd=1.44u as=0.2464p ps=1.44u w=0.88u l=1.12u
X1779 a_17058_124892# s[7] VSS VSS nfet_03v3 ad=0.3p pd=2.2u as=0.3p ps=2.2u w=0.5u l=0.64u
X1780 w_68520_109198# w[27] a_16310_110912# w_68520_109198# nfet_03v3 ad=0.14p pd=1.06u as=0.14p ps=1.06u w=0.5u l=0.64u
X1786 w_68520_30314# w[7] a_16310_32028# w_68520_30314# nfet_03v3 ad=0.3p pd=2.2u as=0.14p ps=1.06u w=0.5u l=0.64u
X1791 a_16310_125100# w[31] w_68520_123386# w_68520_123386# nfet_03v3 ad=0.14p pd=1.06u as=0.14p ps=1.06u w=0.5u l=0.64u
X1796 w_68520_30314# DAC_7__Vb VSS VSS nfet_03v3 ad=0.6p pd=3.2u as=0.6p ps=3.2u w=1u l=8u
X1797 w_62932_123386# DAC_7__Vb VSS VSS nfet_03v3 ad=0.6p pd=3.2u as=0.6p ps=3.2u w=1u l=8u
X1799 w_52956_109198# DAC_7__Vb VSS VSS nfet_03v3 ad=0.6p pd=3.2u as=0.6p ps=3.2u w=1u l=8u
X1800 a_79226_82612# a_79226_82612# DAC_3__Isum_e DAC_3__Isum_e nfet_03v3 ad=0.3p pd=2.2u as=0.3p ps=2.2u w=0.5u l=0.64u
X1809 VMEM_3 neuron_4__Vlk VSS VSS nfet_03v3 ad=0.6p pd=3.2u as=0.6p ps=3.2u w=1u l=1u
X1812 a_102902_32968# neuron_4__Vamp_bias VSS VSS nfet_03v3 ad=0.3p pd=2.2u as=0.3p ps=2.2u w=0.5u l=0.64u
X1815 a_105710_32968# neuron_4__VKdn VSS VSS nfet_03v3 ad=0.6p pd=3.2u as=0.6p ps=3.2u w=1u l=1u
X1820 a_16310_80708# w[18] w_62932_78994# w_62932_78994# nfet_03v3 ad=0.14p pd=1.06u as=0.14p ps=1.06u w=0.5u l=0.64u
X1823 w_68520_62978# DAC_7__Vb VSS VSS nfet_03v3 ad=0.6p pd=3.2u as=0.6p ps=3.2u w=1u l=8u
X1827 VMEM_4 a_79938_118260# VSS VSS nfet_03v3 ad=1.44p pd=6u as=1.44p ps=6u w=2.4u l=8u
X1844 a_103440_39284# VMEM_1 a_102902_32968# VSS nfet_03v3 ad=2.4p pd=9.2u as=2.4p ps=9.2u w=4u l=2u
X1846 spike[1] a_105330_32968# a_105710_32968# VSS nfet_03v3 ad=0.3p pd=2.2u as=0.3p ps=2.2u w=0.5u l=0.64u
X1852 w_68520_30314# w[7] a_16310_32028# w_68520_30314# nfet_03v3 ad=0.14p pd=1.06u as=0.14p ps=1.06u w=0.5u l=0.64u
X1857 a_16310_64692# w[14] w_62932_62978# w_62932_62978# nfet_03v3 ad=0.14p pd=1.06u as=0.14p ps=1.06u w=0.5u l=0.64u
X1870 VDD DPI_4__VT DPI_4__VT VDD pfet_03v3 ad=0.14p pd=1.06u as=0.14p ps=1.06u w=0.5u l=0.64u
X1871 w_68520_123386# w[31] a_16310_125100# w_68520_123386# nfet_03v3 ad=0.14p pd=1.06u as=0.14p ps=1.06u w=0.5u l=0.64u
X1876 w_62932_30314# DAC_7__Vb VSS VSS nfet_03v3 ad=0.6p pd=3.2u as=0.6p ps=3.2u w=1u l=8u
X1879 DPI_4__VT DPI_4__VT VDD VDD pfet_03v3 ad=0.14p pd=1.06u as=0.14p ps=1.06u w=0.5u l=0.64u
X1906 w_68520_11838# DAC_7__Vb VSS VSS nfet_03v3 ad=0.6p pd=3.2u as=0.6p ps=3.2u w=1u l=8u
X1918 w_62932_123386# w[30] a_16310_125100# w_62932_123386# nfet_03v3 ad=0.3p pd=2.2u as=0.14p ps=1.06u w=0.5u l=0.64u
X1919 w_52956_93182# DAC_7__Vb VSS VSS nfet_03v3 ad=0.6p pd=3.2u as=0.6p ps=3.2u w=1u l=8u
X1922 VDD s[7] a_17058_124892# VDD pfet_03v3 ad=0.3p pd=2.2u as=0.3p ps=2.2u w=0.5u l=0.32u
X1943 VDD a_84038_93720# a_79938_88056# VDD pfet_03v3 ad=0.3p pd=2.2u as=0.3p ps=2.2u w=0.5u l=0.64u
X1951 a_106338_32968# neuron_4__VK VSS VSS nfet_03v3 ad=0.6p pd=3.2u as=0.6p ps=3.2u w=1u l=1u
X1954 w_68520_30314# w[7] a_16310_32028# w_68520_30314# nfet_03v3 ad=0.14p pd=1.06u as=0.14p ps=1.06u w=0.5u l=0.64u
X1959 VDD bias_0__VT_inh bias_0__VT_inh VDD pfet_03v3 ad=0.2464p pd=1.44u as=0.2464p ps=1.44u w=0.88u l=1.12u
X1962 w_62932_11838# DAC_7__Vb VSS VSS nfet_03v3 ad=0.6p pd=3.2u as=0.6p ps=3.2u w=1u l=8u
X1965 w_68520_109198# DAC_7__Vb VSS VSS nfet_03v3 ad=0.6p pd=3.2u as=0.6p ps=3.2u w=1u l=8u
X1993 DPI_4__Vthr DPI_4__Vthr VDD VDD pfet_03v3 ad=0.14p pd=1.06u as=0.14p ps=1.06u w=0.5u l=0.64u
X2000 DPI_4__Vthr DPI_4__Vthr VDD VDD pfet_03v3 ad=0.14p pd=1.06u as=0.14p ps=1.06u w=0.5u l=0.64u
X2017 VDD a_38446_142736# neuron_4__Vlk VDD pfet_03v3 ad=0.504p pd=2.88u as=0.504p ps=2.88u w=0.84u l=16u
X2019 VDD a_79226_33932# VMEM_1 VDD pfet_03v3 ad=0.3p pd=2.2u as=0.3p ps=2.2u w=0.5u l=0.64u
X2023 w_68520_11838# w[3] a_16310_13552# w_68520_11838# nfet_03v3 ad=0.14p pd=1.06u as=0.14p ps=1.06u w=0.5u l=0.64u
X2032 a_105082_81648# neuron_4__VIp VSS VSS nfet_03v3 ad=0.6p pd=3.2u as=0.6p ps=3.2u w=1u l=1u
X2038 w_68520_48790# DAC_7__Vb VSS VSS nfet_03v3 ad=0.6p pd=3.2u as=0.6p ps=3.2u w=1u l=8u
X2046 w_68520_78994# DAC_7__Vb VSS VSS nfet_03v3 ad=0.6p pd=3.2u as=0.6p ps=3.2u w=1u l=8u
X2050 a_104702_32618# VT a_102902_32968# VSS nfet_03v3 ad=2.4p pd=9.2u as=2.4p ps=9.2u w=4u l=2u
X2051 bias_0__VT_inh bias_0__VT_inh VDD VDD pfet_03v3 ad=0.2464p pd=1.44u as=0.2464p ps=1.44u w=0.88u l=1.12u
X2056 a_16310_110912# w[27] w_68520_109198# w_68520_109198# nfet_03v3 ad=0.14p pd=1.06u as=0.14p ps=1.06u w=0.5u l=0.64u
X2063 VDD DPI_4__Vthr DAC_5__Isum_e DAC_5__Isum_e nfet_03v3 ad=0.3p pd=2.2u as=0.3p ps=2.2u w=0.5u l=0.64u
X2067 a_16558_80708# spike[0] a_16310_80708# VSS nfet_03v3 ad=0.3p pd=2.2u as=0.3p ps=2.2u w=0.5u l=0.64u
X2070 a_16310_80708# w[18] w_62932_78994# w_62932_78994# nfet_03v3 ad=0.14p pd=1.06u as=0.3p ps=2.2u w=0.5u l=0.64u
X2075 VDD DPI_4__Vthr DPI_4__Vthr VDD pfet_03v3 ad=0.14p pd=1.06u as=0.14p ps=1.06u w=0.5u l=0.64u
X2077 VDD DPI_4__VT DPI_4__VT VDD pfet_03v3 ad=0.14p pd=1.06u as=0.14p ps=1.06u w=0.5u l=0.64u
X2080 w_68520_123386# w[31] a_16310_125100# w_68520_123386# nfet_03v3 ad=0.14p pd=1.06u as=0.14p ps=1.06u w=0.5u l=0.64u
X2090 w_52956_123386# DAC_7__Vb VSS VSS nfet_03v3 ad=0.6p pd=3.2u as=0.6p ps=3.2u w=1u l=8u
X2091 a_16558_64692# spike[1] a_16310_64692# VSS nfet_03v3 ad=0.3p pd=2.2u as=0.3p ps=2.2u w=0.5u l=0.64u
X2096 a_16310_64692# w[14] w_62932_62978# w_62932_62978# nfet_03v3 ad=0.14p pd=1.06u as=0.3p ps=2.2u w=0.5u l=0.64u
X2110 w_57824_78994# w[17] a_16310_80708# w_57824_78994# nfet_03v3 ad=0.3p pd=2.2u as=0.14p ps=1.06u w=0.5u l=0.64u
X2112 w_68520_11838# w[3] a_16310_13552# w_68520_11838# nfet_03v3 ad=0.3p pd=2.2u as=0.14p ps=1.06u w=0.5u l=0.64u
X2122 w_68520_48790# w[11] a_16310_50504# w_68520_48790# nfet_03v3 ad=0.14p pd=1.06u as=0.14p ps=1.06u w=0.5u l=0.64u
X2124 Iref Iref VSS VSS nfet_03v3 ad=6p pd=21.2u as=6p ps=21.2u w=10u l=8u
X2130 VDD DPI_4__VT DPI_4__VT VDD pfet_03v3 ad=0.3p pd=2.2u as=0.14p ps=1.06u w=0.5u l=0.64u
X2139 w_57824_62978# w[13] a_16310_64692# w_57824_62978# nfet_03v3 ad=0.3p pd=2.2u as=0.14p ps=1.06u w=0.5u l=0.64u
X2141 w_68520_30314# DAC_7__Vb VSS VSS nfet_03v3 ad=0.6p pd=3.2u as=0.6p ps=3.2u w=1u l=8u
X2151 DPI_4__VT DPI_4__VT VDD VDD pfet_03v3 ad=0.14p pd=1.06u as=0.3p ps=2.2u w=0.5u l=0.64u
X2157 a_16310_32028# w[7] w_68520_30314# w_68520_30314# nfet_03v3 ad=0.14p pd=1.06u as=0.14p ps=1.06u w=0.5u l=0.64u
X2168 w_68520_11838# w[3] a_16310_13552# w_68520_11838# nfet_03v3 ad=0.14p pd=1.06u as=0.14p ps=1.06u w=0.5u l=0.64u
X2171 w_68520_62978# DAC_7__Vb VSS VSS nfet_03v3 ad=0.6p pd=3.2u as=0.6p ps=3.2u w=1u l=8u
X2180 VDD a_84038_93720# cap_mim_2f0_m4m5_noshield c_width=22.18u c_length=22.18u
X2188 w_68520_93182# DAC_7__Vb VSS VSS nfet_03v3 ad=0.6p pd=3.2u as=0.6p ps=3.2u w=1u l=8u
X2201 DAC_6__Isum_e a_17058_31820# a_16558_32028# VSS nfet_03v3 ad=0.3p pd=2.2u as=0.3p ps=2.2u w=0.5u l=0.64u
X2205 DPI_4__Vthr DPI_4__Vthr VDD VDD pfet_03v3 ad=0.14p pd=1.06u as=0.14p ps=1.06u w=0.5u l=0.64u
X2212 w_57824_109198# DAC_7__Vb VSS VSS nfet_03v3 ad=0.6p pd=3.2u as=0.6p ps=3.2u w=1u l=8u
X2216 w_62932_30314# DAC_7__Vb VSS VSS nfet_03v3 ad=0.6p pd=3.2u as=0.6p ps=3.2u w=1u l=8u
X2219 VDD DPI_4__VT DPI_4__VT VDD pfet_03v3 ad=0.14p pd=1.06u as=0.14p ps=1.06u w=0.5u l=0.64u
X2222 w_68520_48790# w[11] a_16310_50504# w_68520_48790# nfet_03v3 ad=0.3p pd=2.2u as=0.14p ps=1.06u w=0.5u l=0.64u
X2226 a_17058_31820# s[1] VSS VSS nfet_03v3 ad=0.3p pd=2.2u as=0.3p ps=2.2u w=0.5u l=0.64u
X2228 w_62932_93182# w[22] a_16310_94896# w_62932_93182# nfet_03v3 ad=0.3p pd=2.2u as=0.14p ps=1.06u w=0.5u l=0.64u
X2244 VDD DPI_4__VT a_84038_63516# VDD pfet_03v3 ad=0.3p pd=2.2u as=0.3p ps=2.2u w=0.5u l=0.64u
X2263 w_68520_123386# DAC_7__Vb VSS VSS nfet_03v3 ad=0.6p pd=3.2u as=0.6p ps=3.2u w=1u l=8u
X2266 VDD DPI_4__Vthr DPI_4__Vthr VDD pfet_03v3 ad=0.3p pd=2.2u as=0.14p ps=1.06u w=0.5u l=0.64u
X2271 w_68520_109198# DAC_7__Vb VSS VSS nfet_03v3 ad=0.6p pd=3.2u as=0.6p ps=3.2u w=1u l=8u
X2272 w_68520_11838# w[3] a_16310_13552# w_68520_11838# nfet_03v3 ad=0.14p pd=1.06u as=0.14p ps=1.06u w=0.5u l=0.64u
X2279 w_68520_48790# w[11] a_16310_50504# w_68520_48790# nfet_03v3 ad=0.14p pd=1.06u as=0.14p ps=1.06u w=0.5u l=0.64u
X2283 DPI_4__Vthr DPI_4__Vthr VDD VDD pfet_03v3 ad=0.14p pd=1.06u as=0.3p ps=2.2u w=0.5u l=0.64u
X2284 a_105330_81648# a_104702_81298# a_105082_81648# VSS nfet_03v3 ad=0.3p pd=2.2u as=0.3p ps=2.2u w=0.5u l=0.64u
X2288 VDD DPI_4__Vthr DPI_4__Vthr VDD pfet_03v3 ad=0.14p pd=1.06u as=0.14p ps=1.06u w=0.5u l=0.64u
X2289 DAC_3__Isum_i s[5] a_16558_94896# VSS nfet_03v3 ad=0.3p pd=2.2u as=0.3p ps=2.2u w=0.5u l=0.64u
X2293 a_102902_14492# neuron_4__Vamp_bias VSS VSS nfet_03v3 ad=0.3p pd=2.2u as=0.3p ps=2.2u w=0.5u l=0.64u
X2301 a_105710_14492# neuron_4__VKdn VSS VSS nfet_03v3 ad=0.6p pd=3.2u as=0.6p ps=3.2u w=1u l=1u
X2306 VDD a_79226_112816# cap_mim_2f0_m4m5_noshield c_width=22.18u c_length=22.18u
X2319 w_62932_11838# DAC_7__Vb VSS VSS nfet_03v3 ad=0.6p pd=3.2u as=0.6p ps=3.2u w=1u l=8u
X2323 VDD neuron_4__VNA a_109144_39284# VDD pfet_03v3 ad=0.6p pd=3.2u as=0.6p ps=3.2u w=1u l=1u
X2325 VDD DPI_4__Vthr DAC_3__Isum_i DAC_3__Isum_i nfet_03v3 ad=0.3p pd=2.2u as=0.3p ps=2.2u w=0.5u l=0.64u
X2330 a_16310_32028# w[7] w_68520_30314# w_68520_30314# nfet_03v3 ad=0.14p pd=1.06u as=0.3p ps=2.2u w=0.5u l=0.64u
X2332 a_103440_20808# VMEM_0 a_102902_14492# VSS nfet_03v3 ad=2.4p pd=9.2u as=2.4p ps=9.2u w=4u l=2u
X2334 spike[0] a_105330_14492# a_105710_14492# VSS nfet_03v3 ad=0.3p pd=2.2u as=0.3p ps=2.2u w=0.5u l=0.64u
X2346 a_79938_57852# a_79938_57852# VSS VSS nfet_03v3 ad=1.2p pd=5.2u as=1.2p ps=5.2u w=2u l=8u
X2353 VDD s[4] a_17058_80500# VDD pfet_03v3 ad=0.3p pd=2.2u as=0.3p ps=2.2u w=0.5u l=0.32u
X2354 a_108516_87964# a_105330_81648# spike[3] VDD pfet_03v3 ad=0.3p pd=2.2u as=0.3p ps=2.2u w=0.5u l=0.64u
X2355 VMEM_1 VSS cap_mim_2f0_m4m5_noshield c_width=22.18u c_length=22.18u
X2364 a_16310_125100# w[31] w_68520_123386# w_68520_123386# nfet_03v3 ad=0.14p pd=1.06u as=0.14p ps=1.06u w=0.5u l=0.64u
X2379 w_68520_109198# DAC_7__Vb VSS VSS nfet_03v3 ad=0.6p pd=3.2u as=0.6p ps=3.2u w=1u l=8u
X2381 w_68520_11838# DAC_7__Vb VSS VSS nfet_03v3 ad=0.6p pd=3.2u as=0.6p ps=3.2u w=1u l=8u
X2382 w_68520_48790# w[11] a_16310_50504# w_68520_48790# nfet_03v3 ad=0.14p pd=1.06u as=0.14p ps=1.06u w=0.5u l=0.64u
X2389 VDD neuron_4__VKup a_108516_20808# VDD pfet_03v3 ad=0.6p pd=3.2u as=0.6p ps=3.2u w=1u l=1u
X2391 w_68520_48790# DAC_7__Vb VSS VSS nfet_03v3 ad=0.6p pd=3.2u as=0.6p ps=3.2u w=1u l=8u
X2397 VDD a_84038_63516# cap_mim_2f0_m4m5_noshield c_width=22.18u c_length=22.18u
X2406 a_102902_51444# neuron_4__Vamp_bias VSS VSS nfet_03v3 ad=0.3p pd=2.2u as=0.3p ps=2.2u w=0.5u l=0.64u
X2414 w_68520_78994# DAC_7__Vb VSS VSS nfet_03v3 ad=0.6p pd=3.2u as=0.6p ps=3.2u w=1u l=8u
X2422 a_16310_32028# w[7] w_68520_30314# w_68520_30314# nfet_03v3 ad=0.14p pd=1.06u as=0.14p ps=1.06u w=0.5u l=0.64u
X2430 a_106338_14492# neuron_4__VK VSS VSS nfet_03v3 ad=0.6p pd=3.2u as=0.6p ps=3.2u w=1u l=1u
X2431 a_16310_110912# w[25] w_57824_109198# w_57824_109198# nfet_03v3 ad=0.14p pd=1.06u as=0.3p ps=2.2u w=0.5u l=0.64u
X2438 spike[2] a_105330_51444# a_105710_51444# VSS nfet_03v3 ad=0.3p pd=2.2u as=0.3p ps=2.2u w=0.5u l=0.64u
X2442 VDD DPI_4__VT DPI_4__VT VDD pfet_03v3 ad=0.14p pd=1.06u as=0.14p ps=1.06u w=0.5u l=0.64u
X2446 w_62932_109198# DAC_7__Vb VSS VSS nfet_03v3 ad=0.6p pd=3.2u as=0.6p ps=3.2u w=1u l=8u
X2463 w_62932_48790# DAC_7__Vb VSS VSS nfet_03v3 ad=0.6p pd=3.2u as=0.6p ps=3.2u w=1u l=8u
X2470 VDD DPI_4__VT a_79226_82612# VDD pfet_03v3 ad=0.3p pd=2.2u as=0.3p ps=2.2u w=0.5u l=0.64u
X2476 w_57824_78994# DAC_7__Vb VSS VSS nfet_03v3 ad=0.6p pd=3.2u as=0.6p ps=3.2u w=1u l=8u
X2479 VDD a_104702_111502# a_105330_111852# VDD pfet_03v3 ad=0.3p pd=2.2u as=0.3p ps=2.2u w=0.5u l=0.64u
X2483 VDD a_79226_33932# cap_mim_2f0_m4m5_noshield c_width=22.18u c_length=22.18u
X2490 w_62932_93182# w[22] a_16310_94896# w_62932_93182# nfet_03v3 ad=0.14p pd=1.06u as=0.14p ps=1.06u w=0.5u l=0.64u
X2500 VDD DPI_4__Vthr DPI_4__Vthr VDD pfet_03v3 ad=0.14p pd=1.06u as=0.14p ps=1.06u w=0.5u l=0.64u
X2503 a_79226_15456# a_79226_15456# DAC_7__Isum_e DAC_7__Isum_e nfet_03v3 ad=0.3p pd=2.2u as=0.3p ps=2.2u w=0.5u l=0.64u
X2507 VDD a_38446_142736# DAC_7__Vb VDD pfet_03v3 ad=0.864p pd=4.08u as=0.864p ps=4.08u w=1.44u l=8u
X2508 a_16310_13552# w[3] w_68520_11838# w_68520_11838# nfet_03v3 ad=0.14p pd=1.06u as=0.14p ps=1.06u w=0.5u l=0.64u
X2513 a_16310_80708# w[19] w_68520_78994# w_68520_78994# nfet_03v3 ad=0.14p pd=1.06u as=0.14p ps=1.06u w=0.5u l=0.64u
X2518 w_57824_123386# DAC_7__Vb VSS VSS nfet_03v3 ad=0.6p pd=3.2u as=0.6p ps=3.2u w=1u l=8u
X2542 w_68520_62978# DAC_7__Vb VSS VSS nfet_03v3 ad=0.6p pd=3.2u as=0.6p ps=3.2u w=1u l=8u
X2544 w_68520_78994# DAC_7__Vb VSS VSS nfet_03v3 ad=0.6p pd=3.2u as=0.6p ps=3.2u w=1u l=8u
X2546 a_16310_94896# w[20] w_52956_93182# w_52956_93182# nfet_03v3 ad=0.3p pd=2.2u as=0.3p ps=2.2u w=0.5u l=0.64u
X2549 a_16310_64692# w[15] w_68520_62978# w_68520_62978# nfet_03v3 ad=0.14p pd=1.06u as=0.14p ps=1.06u w=0.5u l=0.64u
X2552 DAC_7__Isum_e a_17058_13344# a_16558_13552# VSS nfet_03v3 ad=0.3p pd=2.2u as=0.3p ps=2.2u w=0.5u l=0.64u
X2553 a_104702_14142# VT a_102902_14492# VSS nfet_03v3 ad=2.4p pd=9.2u as=2.4p ps=9.2u w=4u l=2u
X2562 w_68520_93182# DAC_7__Vb VSS VSS nfet_03v3 ad=0.6p pd=3.2u as=0.6p ps=3.2u w=1u l=8u
X2570 a_17058_13344# s[0] VSS VSS nfet_03v3 ad=0.3p pd=2.2u as=0.3p ps=2.2u w=0.5u l=0.64u
X2574 VDD DPI_4__Vthr DPI_4__Vthr VDD pfet_03v3 ad=0.14p pd=1.06u as=0.14p ps=1.06u w=0.5u l=0.64u
X2580 VDD bias_0__VT_inh bias_0__VT_inh VDD pfet_03v3 ad=0.2464p pd=1.44u as=0.2464p ps=1.44u w=0.88u l=1.12u
X2582 DPI_4__Vthr DPI_4__Vthr VDD VDD pfet_03v3 ad=0.14p pd=1.06u as=0.14p ps=1.06u w=0.5u l=0.64u
X2592 w_68520_123386# DAC_7__Vb VSS VSS nfet_03v3 ad=0.6p pd=3.2u as=0.6p ps=3.2u w=1u l=8u
X2593 w_62932_30314# DAC_7__Vb VSS VSS nfet_03v3 ad=0.6p pd=3.2u as=0.6p ps=3.2u w=1u l=8u
X2595 DPI_4__Vthr Iref VSS VSS nfet_03v3 ad=0.546p pd=3.02u as=0.546p ps=3.02u w=0.91u l=32u
X2610 VMEM_2 VSS cap_mim_2f0_m4m5_noshield c_width=22.18u c_length=22.18u
X2615 VDD a_79226_52408# cap_mim_2f0_m4m5_noshield c_width=22.18u c_length=22.18u
X2616 a_16310_80708# w[17] w_57824_78994# w_57824_78994# nfet_03v3 ad=0.14p pd=1.06u as=0.3p ps=2.2u w=0.5u l=0.64u
X2617 VDD neuron_4__VKup a_108516_118168# VDD pfet_03v3 ad=0.6p pd=3.2u as=0.6p ps=3.2u w=1u l=1u
X2625 w_62932_62978# DAC_7__Vb VSS VSS nfet_03v3 ad=0.6p pd=3.2u as=0.6p ps=3.2u w=1u l=8u
X2626 a_16310_50504# w[11] w_68520_48790# w_68520_48790# nfet_03v3 ad=0.14p pd=1.06u as=0.14p ps=1.06u w=0.5u l=0.64u
X2632 VDD neuron_4__VKup a_108516_87964# VDD pfet_03v3 ad=0.6p pd=3.2u as=0.6p ps=3.2u w=1u l=1u
X2634 neuron_4__Vlk neuron_4__Vlk VSS VSS nfet_03v3 ad=0.28p pd=1.56u as=0.28p ps=1.56u w=1u l=1u
X2636 w_57824_93182# DAC_7__Vb VSS VSS nfet_03v3 ad=0.6p pd=3.2u as=0.6p ps=3.2u w=1u l=8u
X2653 a_16310_64692# w[13] w_57824_62978# w_57824_62978# nfet_03v3 ad=0.14p pd=1.06u as=0.3p ps=2.2u w=0.5u l=0.64u
X2661 w_68520_30314# DAC_7__Vb VSS VSS nfet_03v3 ad=0.6p pd=3.2u as=0.6p ps=3.2u w=1u l=8u
X2666 DPI_4__VT DPI_4__VT VDD VDD pfet_03v3 ad=0.14p pd=1.06u as=0.14p ps=1.06u w=0.5u l=0.64u
X2667 DAC_5__Isum_e a_17058_50296# a_16558_50504# VSS nfet_03v3 ad=0.3p pd=2.2u as=0.3p ps=2.2u w=0.5u l=0.64u
X2674 a_16558_110912# spike[2] a_16310_110912# VSS nfet_03v3 ad=0.3p pd=2.2u as=0.3p ps=2.2u w=0.5u l=0.64u
X2679 a_16310_13552# w[3] w_68520_11838# w_68520_11838# nfet_03v3 ad=0.14p pd=1.06u as=0.3p ps=2.2u w=0.5u l=0.64u
X2686 bias_0__VT_inh bias_0__VT_inh VDD VDD pfet_03v3 ad=0.2464p pd=1.44u as=0.2464p ps=1.44u w=0.88u l=1.12u
X2688 a_17058_50296# s[2] VSS VSS nfet_03v3 ad=0.3p pd=2.2u as=0.3p ps=2.2u w=0.5u l=0.64u
X2711 w_68520_123386# DAC_7__Vb VSS VSS nfet_03v3 ad=0.6p pd=3.2u as=0.6p ps=3.2u w=1u l=8u
X2712 w_68520_93182# DAC_7__Vb VSS VSS nfet_03v3 ad=0.6p pd=3.2u as=0.6p ps=3.2u w=1u l=8u
X2723 w_68520_109198# DAC_7__Vb VSS VSS nfet_03v3 ad=0.6p pd=3.2u as=0.6p ps=3.2u w=1u l=8u
X2737 a_16310_94896# w[22] w_62932_93182# w_62932_93182# nfet_03v3 ad=0.14p pd=1.06u as=0.14p ps=1.06u w=0.5u l=0.64u
X2744 DPI_4__VT DPI_4__VT VDD VDD pfet_03v3 ad=0.14p pd=1.06u as=0.14p ps=1.06u w=0.5u l=0.64u
X2748 VMEM_1 neuron_4__Vlk VSS VSS nfet_03v3 ad=0.6p pd=3.2u as=0.6p ps=3.2u w=1u l=1u
X2749 VDD DPI_4__VT DPI_4__VT VDD pfet_03v3 ad=0.14p pd=1.06u as=0.14p ps=1.06u w=0.5u l=0.64u
X2756 VDD a_104702_32618# a_105330_32968# VDD pfet_03v3 ad=0.3p pd=2.2u as=0.3p ps=2.2u w=0.5u l=0.64u
X2764 a_16310_125100# w[29] w_57824_123386# w_57824_123386# nfet_03v3 ad=0.14p pd=1.06u as=0.3p ps=2.2u w=0.5u l=0.64u
X2771 w_68520_11838# DAC_7__Vb VSS VSS nfet_03v3 ad=0.6p pd=3.2u as=0.6p ps=3.2u w=1u l=8u
X2777 w_62932_123386# DAC_7__Vb VSS VSS nfet_03v3 ad=0.6p pd=3.2u as=0.6p ps=3.2u w=1u l=8u
X2778 VMEM_4 VSS cap_mim_2f0_m4m5_noshield c_width=22.18u c_length=22.18u
X2783 w_68520_48790# DAC_7__Vb VSS VSS nfet_03v3 ad=0.6p pd=3.2u as=0.6p ps=3.2u w=1u l=8u
X2786 a_16310_13552# w[3] w_68520_11838# w_68520_11838# nfet_03v3 ad=0.14p pd=1.06u as=0.14p ps=1.06u w=0.5u l=0.64u
X2788 VDD neuron_4__VNA a_109144_57760# VDD pfet_03v3 ad=0.6p pd=3.2u as=0.6p ps=3.2u w=1u l=1u
X2796 a_109144_39284# a_105330_32968# VMEM_1 VDD pfet_03v3 ad=0.3p pd=2.2u as=0.3p ps=2.2u w=0.5u l=0.64u
X2801 a_16310_50504# w[11] w_68520_48790# w_68520_48790# nfet_03v3 ad=0.14p pd=1.06u as=0.3p ps=2.2u w=0.5u l=0.64u
X2804 DPI_4__Vthr DPI_4__Vthr VDD VDD pfet_03v3 ad=0.14p pd=1.06u as=0.14p ps=1.06u w=0.5u l=0.64u
X2808 a_105330_111852# a_104702_111502# a_105082_111852# VSS nfet_03v3 ad=0.3p pd=2.2u as=0.3p ps=2.2u w=0.5u l=0.64u
X2815 VDD DPI_4__Vthr DPI_4__Vthr VDD pfet_03v3 ad=0.14p pd=1.06u as=0.14p ps=1.06u w=0.5u l=0.64u
X2821 VSS neuron_4__VKdn neuron_4__VKdn VSS nfet_03v3 ad=0.6p pd=3.2u as=0.28p ps=1.56u w=1u l=1u
X2829 a_103440_118168# VMEM_4 a_102902_111852# VSS nfet_03v3 ad=2.4p pd=9.2u as=2.4p ps=9.2u w=4u l=2u
X2832 w_57824_11838# DAC_7__Vb VSS VSS nfet_03v3 ad=0.6p pd=3.2u as=0.6p ps=3.2u w=1u l=8u
X2838 VDD a_38446_142736# neuron_4__VKdn VDD pfet_03v3 ad=7.764p pd=27.08u as=7.764p ps=27.08u w=12.94u l=8u
X2843 w_62932_48790# DAC_7__Vb VSS VSS nfet_03v3 ad=0.6p pd=3.2u as=0.6p ps=3.2u w=1u l=8u
X2844 neuron_4__Vamp_bias neuron_4__Vamp_bias VSS VSS nfet_03v3 ad=0.3p pd=2.2u as=0.3p ps=2.2u w=0.5u l=0.64u
X2864 a_16310_110912# w[27] w_68520_109198# w_68520_109198# nfet_03v3 ad=0.14p pd=1.06u as=0.3p ps=2.2u w=0.5u l=0.64u
X2870 DPI_4__Vthr DPI_4__Vthr VDD VDD pfet_03v3 ad=0.14p pd=1.06u as=0.14p ps=1.06u w=0.5u l=0.64u
X2872 bias_0__VT_inh bias_0__VT_inh VDD VDD pfet_03v3 ad=0.2464p pd=1.44u as=0.528p ps=2.96u w=0.88u l=1.12u
X2884 a_16310_50504# w[11] w_68520_48790# w_68520_48790# nfet_03v3 ad=0.14p pd=1.06u as=0.14p ps=1.06u w=0.5u l=0.64u
X2905 a_16310_110912# w[26] w_62932_109198# w_62932_109198# nfet_03v3 ad=0.14p pd=1.06u as=0.14p ps=1.06u w=0.5u l=0.64u
X2919 w_68520_62978# DAC_7__Vb VSS VSS nfet_03v3 ad=0.6p pd=3.2u as=0.6p ps=3.2u w=1u l=8u
X2922 w_68520_78994# DAC_7__Vb VSS VSS nfet_03v3 ad=0.6p pd=3.2u as=0.6p ps=3.2u w=1u l=8u
X2923 spike[4] VSS cap_mim_2f0_m4m5_noshield c_width=10u c_length=10u
X2950 VDD DPI_4__Vthr DAC_3__Isum_e DAC_3__Isum_e nfet_03v3 ad=0.3p pd=2.2u as=0.3p ps=2.2u w=0.5u l=0.64u
X2959 DPI_4__VT DPI_4__VT VDD VDD pfet_03v3 ad=0.14p pd=1.06u as=0.14p ps=1.06u w=0.5u l=0.64u
X2963 VDD DPI_4__VT DPI_4__VT VDD pfet_03v3 ad=0.14p pd=1.06u as=0.14p ps=1.06u w=0.5u l=0.64u
X2966 a_105082_32968# neuron_4__VIp VSS VSS nfet_03v3 ad=0.6p pd=3.2u as=0.6p ps=3.2u w=1u l=1u
X2983 a_16558_125100# spike[3] a_16310_125100# VSS nfet_03v3 ad=0.3p pd=2.2u as=0.3p ps=2.2u w=0.5u l=0.64u
X2986 w_62932_62978# DAC_7__Vb VSS VSS nfet_03v3 ad=0.6p pd=3.2u as=0.6p ps=3.2u w=1u l=8u
X2992 neuron_4__VNA Iref VSS VSS nfet_03v3 ad=3.456p pd=12.72u as=3.456p ps=12.72u w=5.76u l=8u
X2993 a_79938_118260# a_79938_118260# VSS VSS nfet_03v3 ad=1.2p pd=5.2u as=1.2p ps=5.2u w=2u l=8u
X2994 a_16558_94896# spike[1] a_16310_94896# VSS nfet_03v3 ad=0.3p pd=2.2u as=0.3p ps=2.2u w=0.5u l=0.64u
X2996 a_16310_94896# w[22] w_62932_93182# w_62932_93182# nfet_03v3 ad=0.14p pd=1.06u as=0.3p ps=2.2u w=0.5u l=0.64u
X3020 w_68520_78994# w[19] a_16310_80708# w_68520_78994# nfet_03v3 ad=0.14p pd=1.06u as=0.14p ps=1.06u w=0.5u l=0.64u
X3022 DPI_4__Vthr DPI_4__Vthr VDD VDD pfet_03v3 ad=0.14p pd=1.06u as=0.14p ps=1.06u w=0.5u l=0.64u
X3024 w_68520_123386# DAC_7__Vb VSS VSS nfet_03v3 ad=0.6p pd=3.2u as=0.6p ps=3.2u w=1u l=8u
X3025 w_68520_109198# DAC_7__Vb VSS VSS nfet_03v3 ad=0.6p pd=3.2u as=0.6p ps=3.2u w=1u l=8u
X3026 a_108516_118168# a_105330_111852# spike[4] VDD pfet_03v3 ad=0.3p pd=2.2u as=0.3p ps=2.2u w=0.5u l=0.64u
X3028 w_68520_30314# DAC_7__Vb VSS VSS nfet_03v3 ad=0.6p pd=3.2u as=0.6p ps=3.2u w=1u l=8u
X3032 VDD neuron_4__VNA neuron_4__VNA VDD pfet_03v3 ad=0.3p pd=2.2u as=0.3p ps=2.2u w=0.5u l=45.45u
X3033 w_57824_93182# w[21] a_16310_94896# w_57824_93182# nfet_03v3 ad=0.3p pd=2.2u as=0.14p ps=1.06u w=0.5u l=0.64u
X3041 VDD neuron_4__VNA a_109144_118168# VDD pfet_03v3 ad=0.6p pd=3.2u as=0.6p ps=3.2u w=1u l=1u
X3044 spike[4] a_105330_111852# a_105710_111852# VSS nfet_03v3 ad=0.3p pd=2.2u as=0.3p ps=2.2u w=0.5u l=0.64u
X3046 w_68520_62978# w[15] a_16310_64692# w_68520_62978# nfet_03v3 ad=0.14p pd=1.06u as=0.14p ps=1.06u w=0.5u l=0.64u
X3056 bias_0__VT_inh bias_0__VT_inh VDD VDD pfet_03v3 ad=0.2464p pd=1.44u as=0.2464p ps=1.44u w=0.88u l=1.12u
X3058 w_62932_11838# DAC_7__Vb VSS VSS nfet_03v3 ad=0.6p pd=3.2u as=0.6p ps=3.2u w=1u l=8u
X3066 w_68520_93182# DAC_7__Vb VSS VSS nfet_03v3 ad=0.6p pd=3.2u as=0.6p ps=3.2u w=1u l=8u
X3070 VDD a_104702_14142# a_105330_14492# VDD pfet_03v3 ad=0.3p pd=2.2u as=0.3p ps=2.2u w=0.5u l=0.64u
X3078 a_16310_110912# w[27] w_68520_109198# w_68520_109198# nfet_03v3 ad=0.14p pd=1.06u as=0.14p ps=1.06u w=0.5u l=0.64u
X3081 VDD a_38446_142736# neuron_4__VIp VDD pfet_03v3 ad=1.404p pd=5.88u as=1.404p ps=5.88u w=2.34u l=8u
X3082_0 neuron_4__VK neuron_4__VK X3082_s1 VSS nfet_03v3 ad=0.3p pd=2.2u as=0.3p ps=2.2u w=0.5u l=45.4550u
X3082_1 X3082_s1 neuron_4__VK VSS VSS nfet_03v3 ad=0.3p pd=2.2u as=0.3p ps=2.2u w=0.5u l=45.4550u
X3083 a_16310_110912# w[24] w_52956_109198# w_52956_109198# nfet_03v3 ad=0.3p pd=2.2u as=0.3p ps=2.2u w=0.5u l=0.64u
X3084 DPI_4__Vthr DPI_4__Vthr VDD VDD pfet_03v3 ad=0.14p pd=1.06u as=0.14p ps=1.06u w=0.5u l=0.64u
X3090 w_57824_30314# DAC_7__Vb VSS VSS nfet_03v3 ad=0.6p pd=3.2u as=0.6p ps=3.2u w=1u l=8u
X3092 VDD DPI_4__Vthr DPI_4__Vthr VDD pfet_03v3 ad=0.14p pd=1.06u as=0.14p ps=1.06u w=0.5u l=0.64u
X3111 a_109144_20808# a_105330_14492# VMEM_0 VDD pfet_03v3 ad=0.3p pd=2.2u as=0.3p ps=2.2u w=0.5u l=0.64u
X3114 w_68520_78994# w[19] a_16310_80708# w_68520_78994# nfet_03v3 ad=0.3p pd=2.2u as=0.14p ps=1.06u w=0.5u l=0.64u
X3146 w_68520_62978# w[15] a_16310_64692# w_68520_62978# nfet_03v3 ad=0.3p pd=2.2u as=0.14p ps=1.06u w=0.5u l=0.64u
X3147 VDD s[3] a_17058_64484# VDD pfet_03v3 ad=0.3p pd=2.2u as=0.3p ps=2.2u w=0.5u l=0.32u
X3160 a_16310_125100# w[31] w_68520_123386# w_68520_123386# nfet_03v3 ad=0.14p pd=1.06u as=0.3p ps=2.2u w=0.5u l=0.64u
X3161 VDD DPI_4__VT DPI_4__VT VDD pfet_03v3 ad=0.14p pd=1.06u as=0.14p ps=1.06u w=0.5u l=0.64u
X3167 w_68520_78994# w[19] a_16310_80708# w_68520_78994# nfet_03v3 ad=0.14p pd=1.06u as=0.14p ps=1.06u w=0.5u l=0.64u
X3169 VDD a_103440_39284# a_104702_32618# VDD pfet_03v3 ad=0.3p pd=2.2u as=0.3p ps=2.2u w=0.5u l=8u
X3174 w_62932_30314# w[6] a_16310_32028# w_62932_30314# nfet_03v3 ad=0.3p pd=2.2u as=0.14p ps=1.06u w=0.5u l=0.64u
X3175 a_105710_51444# neuron_4__VKdn VSS VSS nfet_03v3 ad=0.6p pd=3.2u as=0.6p ps=3.2u w=1u l=1u
X3185 w_57824_109198# DAC_7__Vb VSS VSS nfet_03v3 ad=0.6p pd=3.2u as=0.6p ps=3.2u w=1u l=8u
X3187 w_52956_11838# DAC_7__Vb VSS VSS nfet_03v3 ad=0.6p pd=3.2u as=0.6p ps=3.2u w=1u l=8u
X3189 VDD a_104702_51094# a_105330_51444# VDD pfet_03v3 ad=0.3p pd=2.2u as=0.3p ps=2.2u w=0.5u l=0.64u
X3197 w_62932_48790# DAC_7__Vb VSS VSS nfet_03v3 ad=0.6p pd=3.2u as=0.6p ps=3.2u w=1u l=8u
X3198 w_62932_109198# w[26] a_16310_110912# w_62932_109198# nfet_03v3 ad=0.14p pd=1.06u as=0.14p ps=1.06u w=0.5u l=0.64u
X3202 a_84038_63516# a_84038_63516# DAC_5__Isum_i DAC_5__Isum_i nfet_03v3 ad=0.3p pd=2.2u as=0.3p ps=2.2u w=0.5u l=0.64u
X3207 DAC_1__Isum_e a_17058_110704# a_16558_110912# VSS nfet_03v3 ad=0.3p pd=2.2u as=0.3p ps=2.2u w=0.5u l=0.64u
X3209 w_68520_62978# w[15] a_16310_64692# w_68520_62978# nfet_03v3 ad=0.14p pd=1.06u as=0.14p ps=1.06u w=0.5u l=0.64u
X3213 a_16310_125100# w[30] w_62932_123386# w_62932_123386# nfet_03v3 ad=0.14p pd=1.06u as=0.14p ps=1.06u w=0.5u l=0.64u
X3215 a_103440_57760# VMEM_2 a_102902_51444# VSS nfet_03v3 ad=2.4p pd=9.2u as=2.4p ps=9.2u w=4u l=2u
C0 w[20] spike[1] 0.08685f
C1 w[30] w[28] 0.21316f
C2 a_16558_32028# a_16310_32028# 0.98576f
C3 a_104702_81298# neuron_4__VKup 0.14193f
C4 a_109144_87964# a_105330_81648# 0.03809f
C5 w[19] a_16310_80708# 0.27177f
C6 VDD s[4] 1.70656f
C7 w[26] w[9] 4.20382f
C8 spike[2] a_84038_93720# 0.01807f
C9 w[20] VDD 0.17422f
C10 a_105710_81648# neuron_4__VKdn 0.04013f
C11 VT a_102902_32968# 0.25622f
C12 w[3] w[10] 0.89925f
C13 DAC_3__Isum_e a_16558_94896# 1.13168f
C14 s[5] w[6] 0.0339f
C15 s[2] w[25] 0.13259f
C16 w_68520_93182# w_52956_93182# 0.19827f
C17 s[3] w[26] 0.11389f
C18 w[13] w[4] 0.56484f
C19 s[7] w[27] 0.03379f
C20 w[8] w[14] 3.48012f
C21 neuron_4__VKup a_104702_14142# 0.14159f
C22 neuron_4__VK bias_0__VT_inh 0.24162f
C23 neuron_4__Vlk neuron_4__VK 11.2447f
C24 a_104702_51094# a_105082_51444# 0.32635f
C25 spike[4] VMEM_4 1.60598f
C26 spike[1] neuron_4__Vlk 1.0771f
C27 Iref neuron_4__VKdn 3.98611f
C28 DPI_4__Vthr DAC_3__Isum_i 0.89521f
C29 w[31] w[30] 17.5062f
C30 VDD bias_0__VT_inh 16.7471f
C31 neuron_4__Vlk VDD 4.35625f
C32 w_62932_123386# w_52956_123386# 0.18533f
C33 w[5] s[5] 0.04323f
C34 s[6] w[1] 0.0464f
C35 w[13] w[26] 0.12578f
C36 w[12] w[27] 0.09624f
C37 w[19] w[29] 0.11507f
C38 neuron_4__Vlk a_103440_20808# 0.03028f
C39 VDD a_16310_80708# 0.9668f
C40 w_68520_48790# w[11] 3.71276f
C41 pulse[1] w[7] 0.20007f
C42 w[7] w[11] 0.65475f
C43 neuron_4__VIp neuron_4__VKdn 24.4313f
C44 neuron_4__Vamp_bias neuron_4__VK 6.84377f
C45 DAC_7__Vb w[25] 1.46711f
C46 w[18] w[4] 0.09757f
C47 a_103440_57760# a_105082_51444# 0.05151f
C48 a_102902_51444# VMEM_2 0.2633f
C49 spike[1] neuron_4__Vamp_bias 0.12103f
C50 s[2] s[0] 0.15748f
C51 s[2] w[0] 0.05928f
C52 VDD neuron_4__Vamp_bias 6.32075f
C53 s[5] w[10] 0.04254f
C54 w_68520_93182# w_57824_93182# 0.29105f
C55 spike[2] a_104702_51094# 0.14351f
C56 DAC_1__Isum_i a_16310_110912# 1.41111f
C57 w[3] w[9] 0.59747f
C58 VMEM_2 a_84038_63516# 2.89668f
C59 spike[1] w[15] 0.14245f
C60 pulse[1] w[22] 0.68559f
C61 VDD w[15] 1.51028f
C62 w[11] w[22] 0.2923f
C63 neuron_4__Vamp_bias a_103440_20808# 0.01675f
C64 DAC_1__Isum_i a_17058_124892# 0.06202f
C65 spike[2] spike[4] 0.9042f
C66 w[18] w[26] 0.11587f
C67 DAC_5__Isum_e w_52956_48790# 4.32726f
C68 w[16] w[4] 0.11445f
C69 a_105082_14492# a_105330_14492# 0.73139f
C70 a_102902_111852# a_104702_111502# 0.51605f
C71 w[8] s[4] 0.03465f
C72 w[3] s[3] 0.03522f
C73 w[2] w[30] 0.13262f
C74 neuron_4__Vlk VT 7.26992f
C75 w[5] w_57824_30314# 1.30395f
C76 w[8] w[20] 0.10427f
C77 VDD w[29] 0.17152f
C78 w_52956_62978# w_62932_62978# 0.18533f
C79 a_79226_33932# DAC_6__Isum_e 3.34567f
C80 VDD a_103440_118168# 9.01276f
C81 w[17] w_57824_78994# 1.30395f
C82 w_57824_48790# w[9] 1.30395f
C83 s[3] a_17058_64484# 1.82491f
C84 s[6] w[7] 0.05563f
C85 s[4] w[28] 0.08869f
C86 spike[2] a_103440_57760# 0.32199f
C87 a_103440_87964# a_105082_81648# 0.05151f
C88 w[26] w[16] 0.25823f
C89 s[7] w[23] 0.12437f
C90 w[21] w[25] 6.80492f
C91 pulse[1] w[6] 0.09411f
C92 w[20] w[28] 0.13171f
C93 w[3] w[13] 0.0151f
C94 spike[0] a_105710_14492# 0.7523f
C95 DAC_7__Vb s[0] 3.34333f
C96 neuron_4__Vamp_bias a_102902_81648# 0.04081f
C97 w[0] DAC_7__Vb 4.23236f
C98 s[2] w[27] 0.10973f
C99 w[11] w[6] 0.37941f
C100 w_68520_48790# w_52956_48790# 0.19827f
C101 a_38446_142736# neuron_4__VKdn 1.12079f
C102 w_68520_93182# DAC_3__Isum_i 0.02348f
C103 VT neuron_4__Vamp_bias 4.19074f
C104 spike[4] a_104702_111502# 0.14351f
C105 s[6] w[22] 0.04615f
C106 VDD a_16310_50504# 0.9668f
C107 spike[3] a_17058_124892# 0.22878f
C108 a_16310_13552# DAC_7__Isum_e 0.0727f
C109 w[2] w[14] 0.40108f
C110 VDD w_57824_11838# 11.4772f
C111 w[23] w[12] 0.11735f
C112 a_102902_51444# a_105082_51444# 0.01865f
C113 w_68520_62978# DAC_7__Vb 0.74342f
C114 s[5] w[9] 0.03379f
C115 w[24] w[6] 0.09876f
C116 w[31] s[4] 0.1418f
C117 DAC_6__Isum_e w_52956_30314# 4.32726f
C118 w[5] pulse[1] 0.41128f
C119 w_57824_123386# a_17058_124892# 0.06392f
C120 w[20] w[31] 0.19648f
C121 w[5] w[11] 0.53989f
C122 w_62932_109198# DAC_1__Isum_i 9.19624f
C123 s[5] s[3] 0.13481f
C124 DAC_5__Isum_i s[3] 0.01848f
C125 a_79226_112816# VMEM_4 0.80797f
C126 w[19] spike[1] 0.135f
C127 w_52956_62978# w[12] 0.92401f
C128 a_105082_32968# a_106338_32968# 0.16252f
C129 w[19] VDD 0.39734f
C130 a_79226_82612# a_84038_93720# 0.05391f
C131 a_16558_32028# DAC_6__Isum_e 1.13168f
C132 a_106338_14492# a_105710_14492# 0.77061f
C133 DPI_4__Vthr VMEM_0 0.07556f
C134 w_68520_11838# a_16310_13552# 13.3149f
C135 a_16310_13552# a_16558_13552# 0.98576f
C136 DAC_7__Vb w[27] 1.54268f
C137 s[6] w[6] 0.03393f
C138 w_57824_78994# DAC_7__Vb 0.18591f
C139 a_16558_64692# DAC_5__Isum_e 1.13168f
C140 s[7] w[12] 0.0747f
C141 w[8] w[15] 0.24663f
C142 spike[0] w[22] 2.95672f
C143 pulse[1] w[10] 0.11118f
C144 s[5] w[13] 0.06085f
C145 w[11] w[10] 4.78525f
C146 spike[4] neuron_4__VKdn 0.09918f
C147 spike[0] VMEM_2 0.01597f
C148 w[8] w[29] 0.12222f
C149 s[1] s[0] 0.58214f
C150 s[1] w[0] 0.09999f
C151 spike[1] neuron_4__VK 0.15198f
C152 DAC_7__Vb w_62932_93182# 0.37182f
C153 w_62932_109198# DAC_7__Vb 0.37182f
C154 a_105710_32968# a_105082_32968# 0.96718f
C155 VDD neuron_4__VK 6.77152f
C156 w_68520_11838# w[3] 3.71276f
C157 w[2] s[4] 0.05222f
C158 w[5] s[6] 0.04376f
C159 spike[1] VDD 9.43956f
C160 w[7] w[30] 0.16175f
C161 a_79226_52408# DAC_5__Isum_e 3.32416f
C162 w[29] w[28] 4.13447f
C163 DAC_3__Isum_i a_84038_93720# 2.88991f
C164 VMEM_4 a_84038_123924# 3.24995f
C165 a_105330_111852# a_105082_111852# 0.73139f
C166 neuron_4__Vamp_bias a_102902_14492# 0.04081f
C167 s[2] w[23] 0.13648f
C168 DAC_3__Isum_e a_16310_94896# 0.0727f
C169 VDD a_103440_20808# 9.00706f
C170 w[8] a_16310_50504# 0.01848f
C171 w[21] w[27] 2.2402f
C172 s[5] w[18] 0.15585f
C173 a_17058_13344# s[1] 0.02517f
C174 a_108516_118168# a_109144_118168# 0.27848f
C175 s[7] w[17] 0.0622f
C176 a_16310_64692# w[13] 0.0765f
C177 s[6] w[10] 0.04254f
C178 w_52956_109198# w[24] 0.92401f
C179 w_62932_78994# DAC_7__Vb 0.37182f
C180 spike[2] w[24] 0.08662f
C181 w[25] w[4] 0.59875f
C182 w[29] w[31] 0.09279f
C183 a_104702_14142# a_105330_14492# 7.60272f
C184 a_17058_50296# DAC_5__Isum_e 7.15288f
C185 DAC_7__Vb pulse[0] 0.09747f
C186 a_16558_50504# DAC_5__Isum_e 1.13168f
C187 spike[2] DAC_3__Isum_e 0.10513f
C188 a_17058_110704# VDD 3.27251f
C189 a_105710_111852# a_105082_111852# 0.96718f
C190 VDD w_62932_30314# 13.8716f
C191 pulse[1] w[9] 0.09741f
C192 w[7] w[14] 0.15147f
C193 w[8] w[19] 0.09757f
C194 w[11] w[9] 0.22391f
C195 VT neuron_4__VK 9.42456f
C196 s[5] w[16] 0.03379f
C197 s[7] s[2] 0.13042f
C198 w[1] s[4] 0.04624f
C199 w[17] w[12] 0.13805f
C200 VDD a_102902_81648# 0.22723f
C201 s[7] DAC_1__Isum_i 0.01848f
C202 spike[2] s[6] 0.69956f
C203 pulse[1] s[3] 1.17016f
C204 spike[1] VT 0.12163f
C205 w[23] DAC_7__Vb 1.49984f
C206 w_62932_62978# DAC_7__Vb 0.37182f
C207 VDD VT 1.28687f
C208 s[3] w[11] 0.05525f
C209 w[26] w[25] 13.7489f
C210 w[30] w[6] 1.4921f
C211 a_103440_87964# a_105330_81648# 2.28333f
C212 w[19] w[28] 0.0168f
C213 w_52956_123386# a_17058_124892# 0.06517f
C214 w[14] w[22] 6.34793f
C215 s[2] w[12] 0.82897f
C216 a_105330_32968# neuron_4__Vamp_bias 0.06057f
C217 w_68520_30314# a_17058_31820# 0.0825f
C218 VDD w_57824_62978# 4.0675f
C219 Iref VMEM_0 0.26592f
C220 spike[0] w[10] 0.15214f
C221 a_79226_52408# VMEM_2 0.0542f
C222 w_68520_48790# a_17058_50296# 0.0825f
C223 a_108516_118168# VMEM_4 0.09567f
C224 w_52956_62978# DAC_7__Vb 0.09295f
C225 w[2] w[15] 0.18814f
C226 VDD DAC_1__Isum_e 12.6247f
C227 s[3] w[24] 0.13086f
C228 spike[0] a_105082_14492# 0.04786f
C229 pulse[1] w[13] 0.18792f
C230 VDD a_109144_57760# 2.19403f
C231 a_103440_87964# neuron_4__VKdn 0.01284f
C232 a_108516_57760# a_105330_51444# 0.19949f
C233 w[11] w[13] 0.1457f
C234 DPI_4__VT DAC_7__Vb 0.174f
C235 w[2] w[29] 0.11687f
C236 DAC_5__Isum_i a_79938_57852# 0.16948f
C237 VDD a_16310_32028# 2.37791f
C238 w[8] VDD 0.33025f
C239 DPI_4__VT VMEM_3 0.36786f
C240 w[0] w[4] 0.19092f
C241 s[7] DAC_7__Vb 3.85425f
C242 spike[3] DPI_4__VT 0.9282f
C243 s[6] w[9] 0.0339f
C244 spike[2] spike[0] 0.55439f
C245 a_104702_81298# a_103440_87964# 0.49974f
C246 VMEM_0 neuron_4__VIp 0.18041f
C247 s[5] DAC_3__Isum_i 0.01848f
C248 w[19] w[31] 0.13252f
C249 s[7] spike[3] 0.7175f
C250 VT a_102902_81648# 0.25622f
C251 s[1] pulse[0] 0.09793f
C252 w[14] w[6] 0.12499f
C253 a_79938_88056# VMEM_3 0.20103f
C254 s[6] s[3] 0.13532f
C255 w[23] w[21] 2.59079f
C256 w[24] w[13] 0.11976f
C257 w[7] s[4] 0.05526f
C258 VDD w[28] 0.17495f
C259 VDD a_108516_87964# 2.17376f
C260 a_17058_110704# DAC_1__Isum_e 7.15288f
C261 a_16310_110912# w[26] 0.13617f
C262 w[12] DAC_7__Vb 4.25005f
C263 VDD w_68520_123386# 5.89272f
C264 w_68520_30314# w_57824_30314# 0.29105f
C265 a_108516_20808# VMEM_0 0.09567f
C266 s[2] w[17] 0.14256f
C267 VMEM_1 a_109144_39284# 0.54851f
C268 spike[2] a_16558_110912# 0.01869f
C269 w[18] w[11] 0.14808f
C270 neuron_4__VIp a_105082_111852# 0.04013f
C271 DAC_3__Isum_e w_52956_93182# 4.32726f
C272 a_16310_32028# w_62932_30314# 11.1313f
C273 a_106338_14492# a_105082_14492# 0.16252f
C274 neuron_4__VNA a_109144_39284# 0.04168f
C275 w_68520_78994# w_52956_78994# 0.19827f
C276 VMEM_1 DPI_4__VT 0.26708f
C277 s[4] w[22] 0.13527f
C278 s[6] w[13] 0.06058f
C279 spike[0] w[9] 0.14484f
C280 w[5] w[14] 1.1303f
C281 w[20] w[22] 0.20349f
C282 VDD a_102902_14492# 0.22723f
C283 neuron_4__VNA DPI_4__VT 10.0637f
C284 w[27] w[4] 0.4403f
C285 s[7] w[21] 1.99874f
C286 w_68520_93182# w_62932_93182# 0.4754f
C287 pulse[1] w[16] 1.08551f
C288 w[18] w[24] 0.11135f
C289 a_103440_20808# a_102902_14492# 1.25979f
C290 VDD w[31] 0.31246f
C291 spike[0] s[3] 0.07728f
C292 w[11] w[16] 1.6291f
C293 w[19] w[2] 0.01175f
C294 DPI_4__Vthr DPI_4__VT 21.8855f
C295 a_16310_13552# w[0] 0.01848f
C296 s[7] s[1] 0.10474f
C297 spike[1] a_108516_39284# 1.07702f
C298 w[14] w[10] 0.16658f
C299 w[26] w[27] 11.2958f
C300 w[21] w[12] 0.39483f
C301 VDD a_108516_39284# 2.17376f
C302 s[4] w[6] 0.03388f
C303 a_17058_80500# w_68520_78994# 0.0825f
C304 w[17] DAC_7__Vb 4.37445f
C305 s[6] w[18] 0.1471f
C306 w[24] w[16] 0.08862f
C307 w[20] w[6] 0.11482f
C308 a_16310_125100# w_62932_123386# 11.1313f
C309 neuron_4__Vlk VMEM_2 0.4999f
C310 spike[0] w[13] 0.06155f
C311 w[1] w_57824_11838# 1.30395f
C312 a_79938_57852# a_84038_63516# 4.49421f
C313 w[3] w[0] 0.26627f
C314 s[2] DAC_7__Vb 3.45188f
C315 DAC_3__Isum_e w_57824_93182# 1.51859f
C316 w[3] s[0] 0.61955f
C317 VDD a_16558_125100# 0.21115f
C318 DAC_3__Isum_e a_79226_82612# 3.32268f
C319 w_62932_109198# w[26] 2.11271f
C320 VT a_102902_14492# 0.25622f
C321 w[7] w[15] 0.14879f
C322 spike[0] neuron_4__VKdn 0.17171f
C323 a_105330_32968# spike[1] 5.13237f
C324 s[5] w[25] 0.11331f
C325 a_16310_50504# DAC_5__Isum_e 0.0727f
C326 a_16310_13552# a_17058_13344# 0.07085f
C327 VDD w[2] 0.08905f
C328 s[6] w[16] 0.03406f
C329 a_105330_32968# VDD 3.42003f
C330 a_108516_57760# neuron_4__VKup 0.04013f
C331 w[7] w[29] 0.9734f
C332 spike[3] DAC_1__Isum_i 0.13781f
C333 s[3] w[30] 0.117f
C334 w[5] s[4] 0.04298f
C335 w_68520_11838# w_62932_11838# 0.4754f
C336 a_102902_111852# a_105082_111852# 0.01865f
C337 neuron_4__Vamp_bias VMEM_2 0.98051f
C338 s[3] a_16558_64692# 0.03433f
C339 w_68520_93182# w[23] 3.71276f
C340 w[22] w[15] 6.2932f
C341 spike[1] a_17058_94688# 0.22878f
C342 neuron_4__VKup DPI_4__VT 2.05679f
C343 DAC_1__Isum_i w_57824_123386# 7.40967f
C344 VDD a_17058_94688# 3.27251f
C345 spike[0] w[18] 0.08662f
C346 w[17] w[21] 0.02352f
C347 w_68520_62978# a_17058_64484# 0.0825f
C348 w[3] a_17058_13344# 0.75911f
C349 spike[0] a_104702_14142# 0.14351f
C350 spike[1] a_16558_94896# 0.01869f
C351 w_68520_48790# a_16310_50504# 13.3149f
C352 w[30] w[13] 0.11703f
C353 w[10] s[4] 0.04254f
C354 w[23] w[4] 0.14184f
C355 VDD a_16558_94896# 0.21115f
C356 w[14] w[9] 0.09696f
C357 w[20] a_16310_94896# 0.01848f
C358 w[8] w[31] 0.15769f
C359 w[17] s[1] 0.05012f
C360 DAC_3__Isum_e DAC_3__Isum_i 5.58158f
C361 VMEM_0 a_105330_14492# 0.27808f
C362 s[2] w[21] 0.11023f
C363 spike[3] DAC_7__Vb 0.2891f
C364 neuron_4__Vlk VMEM_4 1.09408f
C365 a_106338_111852# neuron_4__VK 0.04013f
C366 VDD w_68520_109198# 5.89272f
C367 s[3] w[14] 0.39056f
C368 spike[0] w[16] 0.20654f
C369 spike[4] a_105082_111852# 0.04786f
C370 spike[3] VMEM_3 2.22045f
C371 s[5] s[0] 0.15057f
C372 s[5] w[0] 0.05947f
C373 w[6] w[15] 0.12317f
C374 VDD w[1] 0.09422f
C375 a_105330_32968# VT 0.06629f
C376 a_106338_111852# VDD 0.17724f
C377 s[2] s[1] 1.61687f
C378 w[31] w[28] 0.23743f
C379 w[23] w[26] 9.47397f
C380 VDD DAC_6__Isum_e 11.0206f
C381 w_57824_123386# DAC_7__Vb 0.18591f
C382 Iref DPI_4__VT 3.24152f
C383 w_68520_123386# w[31] 3.71276f
C384 w[29] w[6] 0.11901f
C385 w[19] w[7] 0.02715f
C386 a_16558_125100# DAC_1__Isum_e 1.13168f
C387 DPI_4__Vthr DAC_1__Isum_i 0.89521f
C388 w[16] w_52956_78994# 0.92401f
C389 s[7] w[4] 0.05927f
C390 w[18] w[30] 0.1097f
C391 spike[1] DAC_5__Isum_e 0.57343f
C392 DAC_5__Isum_i w_68520_62978# 0.02348f
C393 neuron_4__Vamp_bias VMEM_4 0.89021f
C394 VDD DAC_5__Isum_e 12.3537f
C395 w[14] w[13] 4.5833f
C396 a_17058_110704# w_68520_109198# 0.0825f
C397 w_62932_123386# w[30] 2.11271f
C398 a_16310_13552# pulse[0] 0.03433f
C399 VDD a_105710_14492# 0.15438f
C400 a_109144_20808# VMEM_0 0.54851f
C401 w[5] w[15] 3.08637f
C402 neuron_4__VNA DAC_7__Vb 0.22907f
C403 w[19] w[22] 0.1323f
C404 neuron_4__VIp DPI_4__VT 0.21663f
C405 w[21] DAC_7__Vb 1.5354f
C406 w[8] w[2] 0.61305f
C407 VDD a_105710_51444# 0.15438f
C408 w[12] w[4] 0.58898f
C409 neuron_4__VNA VMEM_3 0.10787f
C410 s[7] w[26] 0.04254f
C411 spike[3] neuron_4__VNA 0.24033f
C412 w[30] w[16] 8.45648f
C413 spike[2] neuron_4__Vlk 1.06474f
C414 s[4] w[9] 0.03379f
C415 s[1] DAC_7__Vb 6.04188f
C416 s[5] w[27] 0.19103f
C417 w[11] w[25] 0.2802f
C418 DPI_4__Vthr DAC_7__Vb 0.18936f
C419 neuron_4__VNA a_105330_51444# 0.33078f
C420 w_68520_48790# VDD 5.89272f
C421 a_103440_118168# VMEM_4 1.06066f
C422 w[3] pulse[0] 0.39665f
C423 spike[3] DPI_4__Vthr 0.21868f
C424 DPI_4__Vthr VMEM_3 1.43783f
C425 DAC_3__Isum_e a_16558_80708# 1.13168f
C426 VDD w[7] 0.29172f
C427 s[3] s[4] 0.25892f
C428 w[10] w[15] 0.11448f
C429 w[12] w[26] 0.11374f
C430 a_16310_80708# w_68520_78994# 13.3149f
C431 w[20] s[3] 1.63221f
C432 a_16310_64692# w_68520_62978# 13.3149f
C433 DAC_3__Isum_i w_52956_78994# 0.18329f
C434 w_52956_30314# w_68520_30314# 0.19827f
C435 w[24] w[25] 5.12101f
C436 w[29] w[10] 0.03929f
C437 w[19] w[6] 0.10751f
C438 spike[2] neuron_4__Vamp_bias 0.18372f
C439 DPI_4__VT a_84038_93720# 0.87458f
C440 neuron_4__VK VMEM_2 1.14296f
C441 neuron_4__VNA VMEM_1 0.07485f
C442 spike[1] w[22] 0.29875f
C443 w_57824_62978# DAC_5__Isum_e 1.51859f
C444 VDD w[22] 0.17809f
C445 w[14] w[16] 0.1033f
C446 w[8] w[1] 0.22369f
C447 DAC_1__Isum_i w_52956_123386# 0.18329f
C448 a_104702_32618# VMEM_1 1.7577f
C449 w[13] s[4] 0.06134f
C450 w_52956_11838# DAC_7__Isum_e 4.32726f
C451 w[20] w[13] 0.61716f
C452 a_79938_88056# a_84038_93720# 4.49421f
C453 VDD VMEM_2 4.66932f
C454 DAC_6__Isum_e a_16310_32028# 0.0727f
C455 w[2] w[31] 0.41319f
C456 w_62932_62978# a_17058_64484# 0.06269f
C457 w[17] w[4] 0.7021f
C458 DPI_4__Vthr VMEM_1 0.19588f
C459 a_104702_32618# neuron_4__VNA 0.16862f
C460 s[6] w[25] 0.40014f
C461 a_106338_81648# VMEM_3 1.75452f
C462 a_38446_142736# DPI_4__VT 0.13805f
C463 pulse[1] s[0] 0.21811f
C464 spike[3] a_106338_81648# 0.6636f
C465 w[20] w_52956_93182# 0.92401f
C466 a_109144_118168# VDD 2.19403f
C467 pulse[1] w[0] 0.07216f
C468 w[5] w[19] 0.09969f
C469 w[10] a_16310_50504# 0.13617f
C470 DPI_4__Vthr neuron_4__VNA 0.47117f
C471 a_17058_80500# DAC_3__Isum_i 0.06202f
C472 a_105330_32968# a_108516_39284# 0.19949f
C473 s[7] w[3] 0.05832f
C474 neuron_4__VKup DAC_7__Vb 0.17265f
C475 s[2] w[4] 0.14668f
C476 w_52956_62978# a_17058_64484# 0.06517f
C477 neuron_4__VNA a_105330_111852# 0.32852f
C478 neuron_4__VKup VMEM_3 0.70955f
C479 spike[0] a_16558_80708# 0.01869f
C480 spike[3] neuron_4__VKup 0.69409f
C481 a_104702_111502# neuron_4__Vamp_bias 0.07771f
C482 w_68520_11838# w_52956_11838# 0.19827f
C483 VDD w[6] 0.14686f
C484 w[24] a_16310_110912# 0.01848f
C485 DAC_7__Vb w_52956_123386# 0.09295f
C486 w[18] s[4] 0.38757f
C487 w[9] w[15] 0.10571f
C488 VDD a_105082_81648# 0.14568f
C489 neuron_4__VKup a_105330_51444# 0.53038f
C490 w[3] w[12] 0.01547f
C491 a_105710_81648# VMEM_3 0.16404f
C492 w[29] w[9] 4.70995f
C493 neuron_4__VKdn bias_0__VT_inh 0.18245f
C494 s[5] w[23] 0.38317f
C495 s[2] w[26] 0.12722f
C496 neuron_4__Vlk neuron_4__VKdn 5.51226f
C497 spike[3] a_105710_81648# 0.7523f
C498 s[3] w[15] 0.38295f
C499 DAC_5__Isum_i w_62932_62978# 9.19624f
C500 neuron_4__VK VMEM_4 0.32986f
C501 VT VMEM_2 4.17575f
C502 w_68520_93182# DAC_7__Vb 0.74342f
C503 w[7] a_16310_32028# 0.27177f
C504 neuron_4__Vamp_bias a_105330_81648# 0.07012f
C505 a_103440_39284# VMEM_1 1.06066f
C506 w_62932_48790# DAC_7__Vb 0.37182f
C507 w_57824_123386# w_52956_123386# 4.49996f
C508 w[8] w[7] 0.6215f
C509 a_103440_118168# a_104702_111502# 0.49974f
C510 s[3] w[29] 0.306f
C511 s[6] s[0] 0.15057f
C512 w[16] s[4] 0.57674f
C513 w[5] VDD 0.22902f
C514 a_16310_125100# a_17058_124892# 0.07085f
C515 VDD VMEM_4 4.71719f
C516 a_109144_87964# VMEM_3 0.54851f
C517 w[11] w[27] 0.33949f
C518 s[6] w[0] 0.05969f
C519 spike[3] a_109144_87964# 0.14726f
C520 w[20] w[16] 0.10467f
C521 neuron_4__VKup VMEM_1 0.07282f
C522 a_103440_39284# neuron_4__VNA 0.32454f
C523 w[6] w_62932_30314# 2.11271f
C524 VDD a_105082_51444# 0.14568f
C525 DAC_7__Vb w[4] 4.25018f
C526 Iref DAC_7__Vb 0.80116f
C527 DAC_5__Isum_i w_52956_62978# 0.18329f
C528 a_103440_39284# a_104702_32618# 0.49974f
C529 spike[3] Iref 0.07399f
C530 neuron_4__VNA neuron_4__VKup 21.7732f
C531 Iref VMEM_3 0.36472f
C532 w[13] w[15] 0.18312f
C533 a_109144_57760# VMEM_2 0.54851f
C534 neuron_4__Vamp_bias neuron_4__VKdn 14.9099f
C535 w[19] w_68520_78994# 3.71276f
C536 a_16310_50504# w[9] 0.0765f
C537 a_105082_81648# a_102902_81648# 0.01865f
C538 w[8] w[22] 0.94752f
C539 neuron_4__Vlk a_104702_14142# 0.01896f
C540 a_104702_32618# neuron_4__VKup 0.14613f
C541 s[7] s[5] 0.14012f
C542 w[18] a_16310_80708# 0.13617f
C543 w[29] w[13] 0.1224f
C544 a_105710_111852# a_105330_111852# 0.35156f
C545 spike[1] a_16310_94896# 0.03433f
C546 w[24] w[27] 0.22671f
C547 spike[0] VMEM_0 1.62998f
C548 a_17058_80500# a_16558_80708# 0.07329f
C549 VDD w[10] 0.16173f
C550 a_104702_81298# neuron_4__Vamp_bias 0.08542f
C551 VDD a_16310_94896# 0.9668f
C552 DPI_4__Vthr neuron_4__VKup 2.01739f
C553 neuron_4__VIp DAC_7__Vb 0.23501f
C554 w[26] DAC_7__Vb 1.46695f
C555 w_62932_11838# a_17058_13344# 0.06269f
C556 neuron_4__VIp VMEM_3 0.22522f
C557 a_16310_64692# w_62932_62978# 11.1313f
C558 VDD a_105082_14492# 0.14568f
C559 DAC_3__Isum_e w_57824_78994# 1.51859f
C560 spike[3] neuron_4__VIp 0.13816f
C561 neuron_4__VKup a_105330_111852# 0.52832f
C562 w[2] w[1] 3.94929f
C563 s[5] w[12] 0.05977f
C564 a_16558_94896# a_17058_94688# 0.07329f
C565 a_79938_118260# DAC_1__Isum_i 0.15479f
C566 spike[2] neuron_4__VK 0.16563f
C567 a_105082_14492# a_103440_20808# 0.05151f
C568 a_16310_80708# w[16] 0.01848f
C569 neuron_4__VNA a_109144_87964# 0.04168f
C570 spike[2] spike[1] 0.22286f
C571 Iref VMEM_1 0.09375f
C572 s[6] w[27] 0.38566f
C573 w[7] w[31] 1.08016f
C574 DAC_3__Isum_i s[4] 0.01848f
C575 neuron_4__Vamp_bias a_104702_14142# 0.07869f
C576 spike[2] VDD 4.54299f
C577 a_16310_32028# w[6] 0.13617f
C578 s[2] w[3] 0.06864f
C579 w_52956_109198# VDD 3.62712f
C580 VT VMEM_4 0.95258f
C581 w[8] w[6] 0.54013f
C582 a_16310_64692# w_52956_62978# 1.46714f
C583 Iref neuron_4__VNA 0.43818f
C584 w[21] w[4] 0.85767f
C585 w[19] s[3] 0.12256f
C586 neuron_4__VK a_106338_32968# 0.04013f
C587 VDD w_68520_78994# 5.89272f
C588 w[18] w[29] 0.11394f
C589 pulse[1] pulse[0] 0.63097f
C590 spike[1] a_106338_32968# 0.6636f
C591 a_16310_110912# a_16558_110912# 0.98576f
C592 s[1] w[4] 0.57963f
C593 a_106338_14492# VMEM_0 1.75452f
C594 Iref DPI_4__Vthr 3.97803f
C595 VDD a_106338_32968# 0.17724f
C596 VMEM_1 neuron_4__VIp 0.23418f
C597 w[6] w[28] 0.12789f
C598 a_84038_93720# VMEM_3 2.8816f
C599 w[16] w[15] 0.20878f
C600 a_103440_39284# neuron_4__VKup 1.7246f
C601 w[14] w[25] 0.49465f
C602 w[21] w[26] 0.22541f
C603 neuron_4__VNA neuron_4__VIp 11.1878f
C604 w[5] a_16310_32028# 0.0765f
C605 a_105710_81648# a_106338_81648# 0.77061f
C606 w[19] w[13] 0.12787f
C607 w[5] w[8] 1.1829f
C608 a_17058_110704# w_52956_109198# 0.06517f
C609 spike[2] a_17058_110704# 0.22878f
C610 w[23] w[11] 0.3031f
C611 w[29] w[16] 8.69551f
C612 a_16310_64692# w[12] 0.01848f
C613 a_38446_142736# DAC_7__Vb 0.32201f
C614 VDD w[9] 0.15966f
C615 s[5] w[17] 0.0549f
C616 VDD a_104702_111502# 4.22706f
C617 DAC_3__Isum_i a_16310_80708# 1.41111f
C618 w[3] DAC_7__Vb 1.54391f
C619 DPI_4__Vthr neuron_4__VIp 1.3381f
C620 a_105710_32968# spike[1] 0.7523f
C621 s[3] spike[1] 0.99042f
C622 w[2] w[7] 0.59147f
C623 a_105710_32968# VDD 0.15438f
C624 spike[2] VT 0.14469f
C625 s[3] VDD 1.70301f
C626 w[31] w[6] 1.37348f
C627 DAC_7__Isum_e w_57824_11838# 1.51859f
C628 w[23] w[24] 0.47604f
C629 DPI_4__VT a_84038_63516# 0.74885f
C630 w[8] w[10] 0.41822f
C631 s[2] s[5] 0.11685f
C632 s[2] DAC_5__Isum_i 0.01848f
C633 a_79226_15456# VDD 7.07201f
C634 w_57824_78994# w_52956_78994# 4.49996f
C635 s[7] pulse[1] 0.25302f
C636 a_79226_112816# DPI_4__VT 0.59553f
C637 a_16558_80708# s[4] 0.03433f
C638 w[19] w[18] 22.0999f
C639 VDD a_105330_81648# 3.39791f
C640 w_52956_109198# DAC_1__Isum_e 4.32726f
C641 w[2] w[22] 0.13869f
C642 s[7] w[11] 0.12811f
C643 spike[1] w[13] 0.1724f
C644 spike[2] a_109144_57760# 0.14726f
C645 w_57824_48790# DAC_7__Vb 0.18591f
C646 VDD w[13] 0.14082f
C647 Iref neuron_4__VKup 1.26825f
C648 w[14] s[0] 0.21892f
C649 neuron_4__VKdn neuron_4__VK 11.783f
C650 DPI_4__Vthr a_84038_93720# 1.07745f
C651 s[6] w[23] 0.0571f
C652 w_68520_11838# w_57824_11838# 0.29105f
C653 spike[1] neuron_4__VKdn 0.16139f
C654 pulse[1] w[12] 0.09132f
C655 neuron_4__VNA a_38446_142736# 0.21979f
C656 VDD w_52956_93182# 3.62712f
C657 w[25] s[4] 0.11256f
C658 w[11] w[12] 0.23998f
C659 s[7] w[24] 0.87981f
C660 VDD neuron_4__VKdn 4.78733f
C661 w[20] w[25] 0.12025f
C662 a_104702_111502# VT 0.40203f
C663 w[7] w[1] 0.37209f
C664 w[19] w[16] 0.18974f
C665 spike[4] spike[3] 4.01915f
C666 a_104702_51094# a_105330_51444# 7.60272f
C667 a_104702_81298# VDD 4.22712f
C668 a_17058_80500# w_57824_78994# 0.06392f
C669 neuron_4__VKup neuron_4__VIp 2.86424f
C670 DPI_4__Vthr a_38446_142736# 9.98487f
C671 w_52956_11838# w[0] 0.92401f
C672 s[5] DAC_7__Vb 3.48195f
C673 w[2] w[6] 0.19872f
C674 w[3] s[1] 0.50333f
C675 a_105082_14492# a_102902_14492# 0.01865f
C676 spike[1] w[18] 0.10652f
C677 w[24] w[12] 0.16762f
C678 a_16310_80708# a_16558_80708# 0.98576f
C679 DPI_4__VT a_84038_123924# 0.6882f
C680 VDD w[18] 0.28116f
C681 s[7] s[6] 24.8698f
C682 w_62932_78994# w_52956_78994# 0.18533f
C683 neuron_4__VKup a_108516_20808# 0.04013f
C684 VT a_105330_81648# 0.06629f
C685 VDD DAC_7__Isum_e 11.2226f
C686 w[8] w[9] 3.78865f
C687 VDD a_104702_14142# 4.22666f
C688 VDD w_62932_123386# 4.67541f
C689 a_103440_57760# a_105330_51444# 2.28333f
C690 neuron_4__VNA a_104702_51094# 0.17044f
C691 a_104702_14142# a_103440_20808# 0.49974f
C692 w[8] s[3] 1.36979f
C693 w[5] w[2] 0.30731f
C694 spike[1] w[16] 0.31446f
C695 s[6] w[12] 0.05922f
C696 w_57824_62978# w[13] 1.30395f
C697 w_52956_11838# a_17058_13344# 0.06517f
C698 pulse[1] w[17] 0.9833f
C699 VDD w[16] 1.12452f
C700 VT neuron_4__VKdn 3.75095f
C701 VDD w_57824_93182# 4.0675f
C702 s[0] s[4] 0.15057f
C703 w[0] s[4] 0.05939f
C704 w[17] w[11] 0.31589f
C705 VDD a_79226_82612# 7.09034f
C706 a_104702_81298# a_102902_81648# 0.51605f
C707 Iref neuron_4__VIp 6.50764f
C708 w[26] w[4] 0.59529f
C709 w_57824_30314# DAC_7__Vb 0.18591f
C710 w_68520_11838# VDD 5.90924f
C711 w[1] w[6] 0.1093f
C712 a_104702_81298# VT 0.40203f
C713 a_16558_13552# VDD 0.91858f
C714 s[3] w[28] 6.36844f
C715 spike[0] DPI_4__VT 0.58127f
C716 s[5] w[21] 0.39447f
C717 s[2] pulse[1] 0.12504f
C718 a_17058_80500# w_62932_78994# 0.06269f
C719 neuron_4__Vlk VMEM_0 0.22761f
C720 w[8] w[13] 0.11817f
C721 neuron_4__VKup a_38446_142736# 0.3765f
C722 VDD w_68520_30314# 5.90924f
C723 a_105710_51444# VMEM_2 0.16404f
C724 s[2] w[11] 0.39784f
C725 w[2] w[10] 0.25174f
C726 a_79226_33932# DPI_4__VT 1.03865f
C727 s[1] a_17058_31820# 1.82491f
C728 neuron_4__VNA a_105330_14492# 0.32835f
C729 spike[4] a_105330_111852# 4.93143f
C730 s[5] s[1] 0.09771f
C731 a_103440_57760# neuron_4__VNA 0.3309f
C732 DAC_5__Isum_i DPI_4__Vthr 0.89521f
C733 w[23] w[30] 0.13473f
C734 a_108516_87964# a_105330_81648# 0.19949f
C735 w[7] w[22] 0.1426f
C736 VT a_104702_14142# 0.40203f
C737 spike[0] w[12] 0.0756f
C738 w[13] w[28] 0.16072f
C739 a_16310_94896# a_17058_94688# 0.07085f
C740 s[2] w[24] 0.12993f
C741 VDD a_79938_57852# 2.12259f
C742 a_105082_32968# VMEM_1 0.10136f
C743 w[5] w[1] 0.02644f
C744 a_106338_111852# VMEM_4 1.75452f
C745 neuron_4__Vamp_bias VMEM_0 0.80299f
C746 s[3] w[31] 0.15462f
C747 w[27] s[4] 0.10918f
C748 s[6] w[17] 0.0549f
C749 DAC_3__Isum_i VDD 7.29026f
C750 a_16310_94896# a_16558_94896# 0.98576f
C751 w[20] w[27] 0.11705f
C752 a_105082_32968# a_104702_32618# 0.32635f
C753 w_68520_30314# w_62932_30314# 0.4754f
C754 spike[3] a_103440_87964# 0.32199f
C755 a_103440_87964# VMEM_3 1.06066f
C756 spike[4] a_105710_111852# 0.7523f
C757 w[8] w[18] 0.10824f
C758 pulse[1] DAC_7__Vb 1.09904f
C759 Iref a_38446_142736# 2.18333f
C760 DAC_1__Isum_i a_16310_125100# 1.41111f
C761 s[7] w[30] 0.38272f
C762 a_104702_51094# neuron_4__VKup 0.14159f
C763 neuron_4__VNA a_109144_20808# 0.04168f
C764 s[2] s[6] 0.11528f
C765 w[11] DAC_7__Vb 4.04265f
C766 VDD w_57824_109198# 4.0675f
C767 w[1] w[10] 0.26122f
C768 w[3] w[4] 0.42524f
C769 w[7] w[6] 4.67065f
C770 s[6] DAC_1__Isum_i 0.01848f
C771 w[23] w[14] 3.81693f
C772 w[14] w_62932_62978# 2.11271f
C773 w[31] w[13] 0.14996f
C774 DAC_1__Isum_i a_84038_123924# 2.86768f
C775 w[18] w[28] 1.10784f
C776 s[0] w[15] 0.23864f
C777 w[8] w[16] 1.44021f
C778 w[12] w[30] 0.11637f
C779 w_52956_109198# w_68520_109198# 0.19827f
C780 w[2] w[9] 0.21517f
C781 w[24] DAC_7__Vb 4.32058f
C782 a_105710_51444# a_105082_51444# 0.96718f
C783 a_38446_142736# neuron_4__VIp 0.35566f
C784 w_57824_48790# w_62932_48790# 0.25259f
C785 spike[0] w[17] 1.14263f
C786 w[22] w[6] 1.44205f
C787 w_68520_123386# w_62932_123386# 0.4754f
C788 neuron_4__VKup a_105330_14492# 0.5301f
C789 w[19] w[25] 0.12206f
C790 a_105710_32968# a_105330_32968# 0.35156f
C791 w_57824_78994# a_16310_80708# 1.50544f
C792 s[3] w[2] 0.04648f
C793 a_103440_57760# neuron_4__VKup 1.7246f
C794 a_79226_52408# DPI_4__VT 0.60645f
C795 w_68520_62978# w[15] 3.71276f
C796 a_17058_110704# w_57824_109198# 0.06392f
C797 a_103440_87964# neuron_4__VNA 0.33146f
C798 w[5] w[7] 0.20916f
C799 w[16] w[28] 0.14309f
C800 spike[3] DAC_3__Isum_e 0.66014f
C801 w_62932_11838# DAC_7__Vb 0.37182f
C802 a_16310_32028# w_68520_30314# 13.3149f
C803 a_105082_14492# a_105710_14492# 0.96718f
C804 s[7] w[14] 0.05989f
C805 a_103440_118168# a_105082_111852# 0.05151f
C806 s[2] spike[0] 1.0633f
C807 spike[3] a_16310_125100# 0.03433f
C808 w[18] w[31] 0.13252f
C809 s[6] DAC_7__Vb 3.61311f
C810 pulse[1] w[21] 0.55741f
C811 a_104702_14142# a_102902_14492# 0.51605f
C812 w[21] w[11] 0.26655f
C813 spike[3] s[6] 0.29112f
C814 a_103440_39284# a_105082_32968# 0.05151f
C815 VDD a_16558_80708# 0.21115f
C816 DPI_4__Vthr a_84038_63516# 1.17396f
C817 w_62932_48790# DAC_5__Isum_i 9.19624f
C818 pulse[1] s[1] 1.58583f
C819 a_16310_125100# w_57824_123386# 1.50544f
C820 w[5] w[22] 0.8933f
C821 w[14] w[12] 0.64577f
C822 w[7] w[10] 0.12814f
C823 s[1] w[11] 0.64206f
C824 s[5] w[4] 0.05195f
C825 DPI_4__Vthr a_79226_112816# 0.76693f
C826 spike[2] a_105710_51444# 0.7523f
C827 DAC_7__Vb w_52956_48790# 0.09295f
C828 a_16310_13552# w[3] 0.27177f
C829 w[1] w[9] 0.93366f
C830 w[23] s[4] 0.11701f
C831 a_105082_51444# VMEM_2 0.10136f
C832 w[29] w[27] 3.28839f
C833 DAC_1__Isum_e w_57824_109198# 1.51859f
C834 w[20] w[23] 0.2159f
C835 VDD w[25] 0.48227f
C836 a_109144_118168# VMEM_4 0.54851f
C837 spike[4] neuron_4__VIp 0.08826f
C838 DAC_1__Isum_i a_16558_110912# 0.70742f
C839 s[3] w[1] 0.06549f
C840 a_16310_94896# w[22] 0.13617f
C841 w_52956_93182# a_17058_94688# 0.06517f
C842 w[10] w[22] 0.19673f
C843 w_62932_78994# a_16310_80708# 11.1313f
C844 spike[0] DAC_7__Vb 0.53431f
C845 s[5] w[26] 0.11396f
C846 s[2] w[30] 0.11847f
C847 w[5] w[6] 4.92907f
C848 w[2] w[18] 0.02712f
C849 s[6] w[21] 0.0474f
C850 spike[3] spike[0] 0.08022f
C851 DPI_4__Vthr DAC_3__Isum_e 0.89458f
C852 VMEM_0 neuron_4__VK 0.45907f
C853 a_17058_13344# w_57824_11838# 0.06392f
C854 s[7] s[4] 0.13876f
C855 s[7] w[20] 0.07735f
C856 s[6] s[1] 0.09771f
C857 DAC_7__Vb w_52956_78994# 0.09295f
C858 VDD VMEM_0 3.9439f
C859 a_103440_87964# neuron_4__VKup 1.7246f
C860 DPI_4__Vthr a_84038_123924# 0.79181f
C861 w[17] w[14] 0.12736f
C862 spike[2] VMEM_2 1.64109f
C863 w[10] w[6] 1.99263f
C864 a_108516_20808# a_105330_14492# 0.19949f
C865 w[2] w[16] 0.58988f
C866 VMEM_0 a_103440_20808# 1.06066f
C867 w[12] s[4] 0.0609f
C868 a_105082_32968# neuron_4__VIp 0.04013f
C869 w[7] w[9] 0.35982f
C870 VDD a_16310_110912# 0.9668f
C871 VDD w[0] 0.09479f
C872 w[20] w[12] 12.4821f
C873 VDD s[0] 1.83864f
C874 w[19] w[27] 0.11868f
C875 spike[0] VMEM_1 0.024f
C876 s[2] w[14] 0.11676f
C877 DPI_4__VT bias_0__VT_inh 12.0474f
C878 neuron_4__Vlk DPI_4__VT 0.24852f
C879 VDD a_17058_124892# 3.27251f
C880 w[30] DAC_7__Vb 1.37773f
C881 w_52956_30314# DAC_7__Vb 0.09295f
C882 spike[0] neuron_4__VNA 0.08863f
C883 a_79226_33932# VMEM_1 0.0542f
C884 s[3] w[7] 0.06761f
C885 VDD a_105082_111852# 0.14568f
C886 spike[0] w[21] 1.46218f
C887 w_57824_93182# a_17058_94688# 0.06392f
C888 spike[3] w[30] 0.08662f
C889 neuron_4__VKdn a_105710_14492# 0.04013f
C890 a_17058_80500# DAC_7__Vb 0.05044f
C891 VDD w_68520_62978# 5.89272f
C892 w[22] w[9] 0.11293f
C893 w[5] w[10] 0.1814f
C894 s[5] w[3] 0.05832f
C895 DPI_4__Vthr spike[0] 0.55766f
C896 w[23] w[29] 0.13871f
C897 a_105710_51444# neuron_4__VKdn 0.04013f
C898 w[8] w[25] 0.23654f
C899 a_17058_110704# a_16310_110912# 0.07085f
C900 VT VMEM_0 1.26299f
C901 s[3] w[22] 0.10838f
C902 a_79226_33932# DPI_4__Vthr 0.77966f
C903 a_109144_20808# a_108516_20808# 0.27848f
C904 pulse[1] w[4] 0.53717f
C905 s[2] a_17058_50296# 1.82491f
C906 s[2] a_16558_50504# 0.03433f
C907 neuron_4__Vamp_bias DPI_4__VT 0.2548f
C908 VDD a_17058_13344# 3.33452f
C909 w[11] w[4] 0.18893f
C910 DAC_5__Isum_i a_17058_64484# 0.06202f
C911 a_16310_125100# w_52956_123386# 1.46714f
C912 VDD w[27] 0.31246f
C913 w[17] s[4] 0.41119f
C914 w[14] DAC_7__Vb 1.48674f
C915 s[7] w[15] 0.03379f
C916 VDD w_57824_78994# 4.0675f
C917 spike[2] a_105082_51444# 0.04786f
C918 w[6] w[9] 0.12244f
C919 w[21] w[30] 0.12238f
C920 w[13] w[22] 0.10718f
C921 w_57824_48790# DAC_5__Isum_i 7.40967f
C922 DAC_3__Isum_i a_17058_94688# 0.06202f
C923 s[7] w[29] 0.39128f
C924 w[11] w[26] 0.30108f
C925 s[2] s[4] 3.14579f
C926 a_108516_118168# a_105330_111852# 0.19949f
C927 s[3] w[6] 0.10348f
C928 VDD w_62932_93182# 4.67541f
C929 a_103440_118168# DPI_4__VT 0.01784f
C930 a_16310_110912# DAC_1__Isum_e 0.0727f
C931 w_52956_11838# DAC_7__Vb 0.09295f
C932 w_62932_109198# VDD 4.67541f
C933 DAC_3__Isum_i a_16558_94896# 0.70742f
C934 w[18] w[7] 0.01764f
C935 w[12] w[15] 0.19449f
C936 neuron_4__VKdn VMEM_2 0.27406f
C937 a_103440_57760# a_104702_51094# 0.49974f
C938 a_17058_124892# DAC_1__Isum_e 7.15288f
C939 w_68520_62978# w_57824_62978# 0.29105f
C940 a_17058_110704# w[27] 0.75911f
C941 w[24] w[26] 0.23157f
C942 spike[0] neuron_4__VKup 0.07477f
C943 w[29] w[12] 0.16779f
C944 s[6] w[4] 0.05187f
C945 w[19] w[23] 0.11865f
C946 w[5] w[9] 0.11432f
C947 a_104702_111502# VMEM_4 1.7577f
C948 Iref a_84038_123924# 0.05225f
C949 s[1] a_16558_32028# 0.03433f
C950 a_16310_64692# a_17058_64484# 0.07085f
C951 a_105082_81648# a_105330_81648# 0.73139f
C952 w[13] w[6] 0.14748f
C953 w[17] a_16310_80708# 0.0765f
C954 w[18] w[22] 0.14138f
C955 w_62932_48790# w_52956_48790# 0.18533f
C956 w[7] w[16] 0.14431f
C957 w[14] w[21] 1.83307f
C958 w[5] s[3] 0.0531f
C959 w_68520_109198# w_57824_109198# 0.29105f
C960 VDD w_62932_78994# 4.67541f
C961 w_62932_109198# a_17058_110704# 0.06269f
C962 VMEM_1 a_102902_32968# 0.2633f
C963 s[6] w[26] 0.39194f
C964 VMEM_0 a_102902_14492# 0.2633f
C965 DPI_4__Vthr a_79226_52408# 1.04779f
C966 DAC_7__Vb s[4] 3.52347f
C967 w[14] s[1] 0.31884f
C968 w[10] w[9] 8.03413f
C969 w[20] DAC_7__Vb 4.29448f
C970 a_108516_118168# neuron_4__VKup 0.04013f
C971 VDD pulse[0] 0.0889f
C972 w_68520_123386# a_17058_124892# 0.0825f
C973 w[16] w[22] 0.25291f
C974 a_104702_81298# a_105082_81648# 0.32635f
C975 a_104702_32618# a_102902_32968# 0.51605f
C976 s[7] w[19] 0.19668f
C977 w[7] w_68520_30314# 3.71276f
C978 s[3] w[10] 0.049f
C979 w[5] w[13] 0.10108f
C980 pulse[1] w[3] 0.288f
C981 Iref spike[0] 0.09367f
C982 w[17] w[15] 0.36757f
C983 w[3] w[11] 0.17841f
C984 spike[1] w[23] 0.07426f
C985 w[18] w[6] 0.11112f
C986 w[8] w[27] 1.04784f
C987 w_57824_30314# a_17058_31820# 0.06392f
C988 VDD w[23] 0.31635f
C989 w[2] w[25] 0.1019f
C990 VDD w_62932_62978# 4.67541f
C991 DAC_5__Isum_i a_16310_64692# 1.41111f
C992 neuron_4__VKdn VMEM_4 2.59156f
C993 w_62932_11838# a_16310_13552# 11.1313f
C994 w[19] w[12] 0.11727f
C995 s[2] w[15] 0.10098f
C996 VDD a_108516_57760# 2.17376f
C997 w[31] a_17058_124892# 0.75911f
C998 a_104702_51094# a_102902_51444# 0.51605f
C999 neuron_4__Vlk DAC_7__Vb 10.3856f
C1000 DAC_7__Vb bias_0__VT_inh 0.1821f
C1001 a_109144_20808# a_105330_14492# 0.03809f
C1002 spike[0] neuron_4__VIp 0.15903f
C1003 spike[1] a_109144_39284# 0.14726f
C1004 w[10] w[13] 0.05568f
C1005 w[27] w[28] 0.83362f
C1006 spike[3] neuron_4__Vlk 1.14769f
C1007 neuron_4__Vlk VMEM_3 0.70357f
C1008 DPI_4__VT neuron_4__VK 0.30942f
C1009 w_52956_62978# VDD 3.62712f
C1010 s[2] w[29] 0.10973f
C1011 VDD a_109144_39284# 2.19403f
C1012 w[16] w[6] 0.53068f
C1013 spike[1] DPI_4__VT 0.07955f
C1014 w_52956_93182# a_16310_94896# 1.46714f
C1015 a_79938_118260# a_84038_123924# 4.49421f
C1016 w[21] s[4] 0.11402f
C1017 VDD DPI_4__VT 51.17f
C1018 w[5] w[18] 0.29476f
C1019 w[20] w[21] 4.51741f
C1020 s[7] VDD 3.84974f
C1021 a_105710_32968# a_106338_32968# 0.77061f
C1022 a_79938_57852# VMEM_2 0.20103f
C1023 spike[0] a_108516_20808# 1.07702f
C1024 s[1] s[4] 0.10307f
C1025 w[30] w[4] 0.33356f
C1026 w_52956_30314# w[4] 0.92401f
C1027 s[6] w[3] 0.05832f
C1028 VDD a_79938_88056# 2.15264f
C1029 DAC_5__Isum_i a_84038_63516# 2.89599f
C1030 neuron_4__Vamp_bias DAC_7__Vb 10.0914f
C1031 a_103440_57760# a_102902_51444# 1.25979f
C1032 a_103440_39284# a_102902_32968# 1.25979f
C1033 pulse[1] a_17058_31820# 0.22878f
C1034 neuron_4__Vamp_bias VMEM_3 0.78368f
C1035 a_16558_125100# a_17058_124892# 0.07329f
C1036 spike[1] w[12] 0.17461f
C1037 pulse[1] s[5] 0.11277f
C1038 spike[3] neuron_4__Vamp_bias 1.04832f
C1039 w[5] w[16] 0.58596f
C1040 w[2] s[0] 1.03847f
C1041 neuron_4__Vlk VMEM_1 0.39341f
C1042 VDD w[12] 0.15526f
C1043 s[3] w[9] 0.03387f
C1044 spike[2] neuron_4__VKdn 0.1757f
C1045 w[2] w[0] 0.25668f
C1046 DAC_7__Vb w[15] 1.87718f
C1047 s[5] w[11] 0.04304f
C1048 neuron_4__Vamp_bias a_105330_51444# 0.06892f
C1049 neuron_4__VNA bias_0__VT_inh 0.41066f
C1050 w[19] w[17] 0.09496f
C1051 w_57824_62978# w_62932_62978# 0.25259f
C1052 w[29] DAC_7__Vb 1.37472f
C1053 neuron_4__VNA neuron_4__Vlk 2.40199f
C1054 spike[3] w[29] 0.08662f
C1055 a_105082_14492# a_104702_14142# 0.32635f
C1056 s[5] w[24] 0.09842f
C1057 DPI_4__Vthr bias_0__VT_inh 3.70207f
C1058 w[10] w[16] 0.11836f
C1059 DPI_4__Vthr neuron_4__Vlk 5.21493f
C1060 s[2] w[19] 0.12332f
C1061 w[8] w[23] 0.26416f
C1062 w[14] w[4] 0.96644f
C1063 w_52956_62978# w_57824_62978# 4.49996f
C1064 w_57824_93182# a_16310_94896# 1.50544f
C1065 a_108516_57760# a_109144_57760# 0.27848f
C1066 w[29] w_57824_123386# 1.30395f
C1067 VMEM_1 neuron_4__Vamp_bias 2.06892f
C1068 w_68520_109198# a_16310_110912# 13.3149f
C1069 w_57824_48790# w_52956_48790# 4.49996f
C1070 neuron_4__VNA neuron_4__Vamp_bias 1.42867f
C1071 s[3] w[13] 3.19999f
C1072 a_104702_32618# neuron_4__Vamp_bias 0.07771f
C1073 w[1] s[0] 1.04287f
C1074 w[2] w[27] 0.14559f
C1075 w[0] w[1] 4.28283f
C1076 s[6] s[5] 21.5297f
C1077 DAC_7__Vb w_57824_11838# 0.18591f
C1078 spike[1] w[17] 0.11703f
C1079 w[21] w[15] 4.17014f
C1080 w_62932_48790# a_17058_50296# 0.06269f
C1081 w[7] w[25] 0.12706f
C1082 a_105710_32968# neuron_4__VKdn 0.04013f
C1083 w[17] VDD 3.81777f
C1084 VMEM_0 a_105710_14492# 0.16404f
C1085 DPI_4__Vthr neuron_4__Vamp_bias 0.42854f
C1086 spike[2] a_79226_82612# 0.01003f
C1087 a_106338_111852# a_105082_111852# 0.16252f
C1088 w[29] w[21] 0.74988f
C1089 s[1] w[15] 0.20642f
C1090 s[7] w[8] 1.77933f
C1091 neuron_4__Vamp_bias a_105330_111852# 0.06057f
C1092 s[2] spike[1] 0.32693f
C1093 DAC_5__Isum_i w_52956_48790# 0.18329f
C1094 w[19] DAC_7__Vb 1.49476f
C1095 neuron_4__VNA a_103440_118168# 0.31936f
C1096 s[2] VDD 1.715f
C1097 w[25] w[22] 0.04053f
C1098 s[3] w[18] 0.13496f
C1099 spike[4] spike[0] 1.39054f
C1100 DAC_3__Isum_i a_16310_94896# 1.41111f
C1101 DAC_1__Isum_i VDD 9.11533f
C1102 w[23] w[31] 0.43426f
C1103 neuron_4__VKup bias_0__VT_inh 0.42435f
C1104 neuron_4__Vlk neuron_4__VKup 6.18096f
C1105 a_104702_81298# a_105330_81648# 7.60272f
C1106 s[7] w[28] 0.66983f
C1107 w[8] w[12] 0.10312f
C1108 w_62932_93182# a_17058_94688# 0.06269f
C1109 w_68520_109198# w[27] 3.71276f
C1110 w[16] w[9] 0.98708f
C1111 s[4] w[4] 0.05215f
C1112 a_79226_15456# DAC_7__Isum_e 3.33062f
C1113 a_103440_118168# a_105330_111852# 2.28333f
C1114 spike[0] a_105330_14492# 4.93143f
C1115 pulse[1] w[11] 2.39666f
C1116 spike[2] DAC_3__Isum_i 0.8364f
C1117 s[3] w[16] 0.10955f
C1118 a_16558_64692# a_17058_64484# 0.07329f
C1119 w[18] w[13] 1.92048f
C1120 w[12] w[28] 0.14851f
C1121 DAC_7__Vb neuron_4__VK 0.23331f
C1122 w[7] s[0] 0.01827f
C1123 spike[4] a_108516_118168# 1.07702f
C1124 w[7] w[0] 0.34389f
C1125 w_52956_11838# a_16310_13552# 1.46714f
C1126 neuron_4__VK VMEM_3 2.2039f
C1127 w_62932_109198# w_68520_109198# 0.4754f
C1128 w[25] w[6] 0.12698f
C1129 spike[3] neuron_4__VK 0.21052f
C1130 DAC_3__Isum_i w_68520_78994# 0.01652f
C1131 spike[1] DAC_7__Vb 3.81707f
C1132 DAC_1__Isum_i a_17058_110704# 0.06202f
C1133 neuron_4__VKup neuron_4__Vamp_bias 2.68523f
C1134 w[2] pulse[0] 0.08662f
C1135 w[26] s[4] 0.11256f
C1136 VDD DAC_7__Vb 18.7881f
C1137 w[20] w[26] 0.12036f
C1138 s[7] w[31] 3.36166f
C1139 spike[3] spike[1] 3.38213f
C1140 w_52956_109198# w_57824_109198# 4.49996f
C1141 w[3] w[14] 0.06674f
C1142 a_109144_39284# a_108516_39284# 0.27848f
C1143 VDD VMEM_3 4.69674f
C1144 w[19] w[21] 1.00061f
C1145 spike[3] VDD 10.9254f
C1146 w[24] w[11] 0.1319f
C1147 Iref bias_0__VT_inh 0.10346f
C1148 Iref neuron_4__Vlk 4.00118f
C1149 w[13] w[16] 0.10828f
C1150 VDD a_105330_51444# 3.41205f
C1151 w[2] w[23] 0.77341f
C1152 w_52956_30314# a_17058_31820# 0.06517f
C1153 w[31] w[12] 0.14864f
C1154 VDD w_57824_123386# 4.0675f
C1155 s[5] w[30] 0.11238f
C1156 w[8] w[17] 1.00382f
C1157 w_52956_93182# w_57824_93182# 4.49996f
C1158 a_103440_118168# neuron_4__VKup 1.73185f
C1159 spike[0] a_109144_20808# 0.14726f
C1160 pulse[1] s[6] 0.11413f
C1161 VMEM_1 neuron_4__VK 1.5041f
C1162 DAC_5__Isum_i a_16558_64692# 0.70742f
C1163 a_17058_110704# DAC_7__Vb 0.05254f
C1164 s[6] w[11] 0.04327f
C1165 w[23] a_17058_94688# 0.77177f
C1166 DAC_1__Isum_i DAC_1__Isum_e 4.66489f
C1167 neuron_4__VIp bias_0__VT_inh 0.15808f
C1168 neuron_4__Vlk neuron_4__VIp 3.45777f
C1169 a_105330_32968# a_109144_39284# 0.03809f
C1170 DAC_7__Vb w_62932_30314# 0.37182f
C1171 spike[1] VMEM_1 1.64109f
C1172 a_79226_112816# a_84038_123924# 0.05391f
C1173 w[7] w[27] 2.07119f
C1174 w[8] s[2] 0.72911f
C1175 neuron_4__VNA neuron_4__VK 6.28644f
C1176 Iref neuron_4__Vamp_bias 0.17743f
C1177 s[7] a_16558_125100# 0.03433f
C1178 a_16558_32028# a_17058_31820# 0.07329f
C1179 VDD VMEM_1 4.60438f
C1180 w[1] pulse[0] 0.09659f
C1181 neuron_4__VNA spike[1] 0.11215f
C1182 spike[1] w[21] 0.08679f
C1183 s[7] w[2] 0.87772f
C1184 VDD w[21] 0.67699f
C1185 w[18] w[16] 0.31885f
C1186 neuron_4__VNA VDD 32.919f
C1187 w[10] w[25] 4.2308f
C1188 a_102902_81648# VMEM_3 0.2633f
C1189 w[4] w[15] 3.13042f
C1190 a_104702_32618# spike[1] 0.85376f
C1191 s[6] w[24] 0.66293f
C1192 VT VMEM_3 3.23379f
C1193 DPI_4__Vthr neuron_4__VK 0.31596f
C1194 a_104702_32618# VDD 4.24658f
C1195 spike[3] VT 0.22596f
C1196 s[2] w[28] 0.11044f
C1197 neuron_4__VNA a_103440_20808# 0.31783f
C1198 DPI_4__Vthr spike[1] 0.07955f
C1199 w_57824_62978# DAC_7__Vb 0.18591f
C1200 w[29] w[4] 0.99141f
C1201 VDD s[1] 1.95362f
C1202 s[5] w[14] 0.04957f
C1203 w_57824_48790# a_17058_50296# 0.06392f
C1204 neuron_4__Vamp_bias neuron_4__VIp 3.06089f
C1205 w[3] s[4] 0.05832f
C1206 VT a_105330_51444# 0.06629f
C1207 DPI_4__Vthr VDD 46.5968f
C1208 a_16558_13552# DAC_7__Isum_e 1.13168f
C1209 w_52956_30314# w_57824_30314# 4.49996f
C1210 DAC_1__Isum_i w_68520_123386# 0.01652f
C1211 DAC_3__Isum_i w_52956_93182# 0.18329f
C1212 spike[2] w[25] 0.08662f
C1213 VDD a_105330_111852# 3.39783f
C1214 spike[0] w[11] 0.14378f
C1215 a_16310_64692# a_16558_64692# 0.98576f
C1216 spike[3] DAC_1__Isum_e 1.22912f
C1217 w_62932_93182# w[22] 2.11271f
C1218 w[8] DAC_7__Vb 4.83445f
C1219 w_62932_48790# a_16310_50504# 11.1313f
C1220 a_109144_57760# a_105330_51444# 0.03809f
C1221 VMEM_4 a_105082_111852# 0.10136f
C1222 s[2] w[31] 0.13562f
C1223 a_106338_81648# neuron_4__VK 0.04013f
C1224 a_38446_142736# bias_0__VT_inh 0.15271f
C1225 neuron_4__Vlk a_38446_142736# 0.25776f
C1226 VMEM_1 VT 1.08935f
C1227 w_57824_123386# DAC_1__Isum_e 1.51859f
C1228 w[27] w[6] 0.13556f
C1229 DAC_5__Isum_i a_16558_50504# 0.70742f
C1230 VMEM_0 a_105082_14492# 0.10136f
C1231 DAC_5__Isum_i a_17058_50296# 0.06202f
C1232 s[7] w[1] 0.04672f
C1233 neuron_4__VNA VT 0.79184f
C1234 DAC_7__Vb w[28] 4.18621f
C1235 w[10] s[0] 0.05817f
C1236 a_106338_81648# VDD 0.17724f
C1237 w_52956_62978# DAC_5__Isum_e 4.32726f
C1238 a_108516_87964# VMEM_3 0.09567f
C1239 a_105710_111852# VDD 0.15438f
C1240 a_104702_32618# VT 0.40203f
C1241 spike[3] w[28] 0.08662f
C1242 spike[3] a_108516_87964# 1.07702f
C1243 a_16310_64692# w[14] 0.13617f
C1244 w_68520_123386# DAC_7__Vb 0.74342f
C1245 neuron_4__VKup neuron_4__VK 8.90548f
C1246 a_103440_39284# spike[1] 0.39885f
C1247 w[25] w[9] 4.22185f
C1248 a_103440_39284# VDD 9.04081f
C1249 DPI_4__Vthr VT 0.14638f
C1250 a_105082_32968# a_102902_32968# 0.01865f
C1251 spike[1] neuron_4__VKup 0.87746f
C1252 w[23] w[7] 0.61797f
C1253 w[11] w[30] 0.13854f
C1254 w[19] w[4] 0.41976f
C1255 VDD neuron_4__VKup 13.3952f
C1256 a_38446_142736# neuron_4__Vamp_bias 0.8477f
C1257 neuron_4__VNA a_109144_57760# 0.04168f
C1258 s[5] s[4] 18.5919f
C1259 w[17] w[2] 0.31223f
C1260 w_52956_109198# a_16310_110912# 1.46714f
C1261 s[3] w[25] 0.12883f
C1262 spike[2] a_16310_110912# 0.03433f
C1263 DAC_3__Isum_e w_52956_78994# 4.32726f
C1264 VT a_105330_111852# 0.06629f
C1265 w[20] s[5] 0.55895f
C1266 DAC_3__Isum_i w_57824_93182# 7.40967f
C1267 w_68520_123386# w_57824_123386# 0.29105f
C1268 neuron_4__VKup a_103440_20808# 1.7246f
C1269 w[8] w[21] 0.30247f
C1270 VDD w_52956_123386# 3.62712f
C1271 w[31] DAC_7__Vb 1.45347f
C1272 DAC_1__Isum_i a_16558_125100# 0.70742f
C1273 DPI_4__Vthr DAC_1__Isum_e 0.89458f
C1274 pulse[1] a_16558_32028# 0.01869f
C1275 a_105710_81648# VDD 0.15438f
C1276 spike[3] w[31] 0.07426f
C1277 s[2] w[2] 0.05149f
C1278 a_102902_111852# neuron_4__Vamp_bias 0.04081f
C1279 w[24] w[30] 0.11256f
C1280 w[8] s[1] 0.30833f
C1281 w[23] w[22] 6.67538f
C1282 w[19] w[26] 0.1097f
C1283 spike[4] neuron_4__Vlk 1.00233f
C1284 s[6] a_16558_110912# 0.03433f
C1285 a_79226_52408# a_84038_63516# 0.05652f
C1286 w_68520_93182# VDD 5.89272f
C1287 w[13] w[25] 0.12578f
C1288 w[10] w[27] 4.87833f
C1289 VDD a_109144_87964# 2.19403f
C1290 Iref neuron_4__VK 0.18887f
C1291 s[7] w[7] 0.84048f
C1292 w_62932_48790# VDD 4.67541f
C1293 w[15] a_17058_64484# 0.75911f
C1294 pulse[1] w[14] 0.65719f
C1295 a_16310_125100# w[30] 0.13617f
C1296 a_16310_13552# w_57824_11838# 1.50544f
C1297 Iref spike[1] 0.09367f
C1298 a_108516_57760# VMEM_2 0.09567f
C1299 w[14] w[11] 0.36523f
C1300 a_17058_80500# DAC_3__Isum_e 7.15288f
C1301 Iref VDD 2.24982f
C1302 VDD w[4] 0.37933f
C1303 a_104702_51094# neuron_4__Vamp_bias 0.08665f
C1304 neuron_4__Vlk a_105330_14492# 0.02423f
C1305 s[6] w[30] 0.11256f
C1306 a_79226_15456# VMEM_0 0.0542f
C1307 a_102902_111852# a_103440_118168# 1.25979f
C1308 neuron_4__VKup VT 6.21166f
C1309 a_16310_94896# w_62932_93182# 11.1313f
C1310 spike[2] w[27] 0.07426f
C1311 neuron_4__VIp neuron_4__VK 18.4872f
C1312 spike[4] neuron_4__Vamp_bias 0.07293f
C1313 w[23] w[6] 2.36114f
C1314 s[7] w[22] 0.05646f
C1315 s[3] s[0] 0.33194f
C1316 s[3] w[0] 0.78403f
C1317 a_104702_111502# a_105082_111852# 0.32635f
C1318 DPI_4__VT VMEM_2 0.3927f
C1319 spike[3] a_16558_125100# 0.01869f
C1320 DAC_1__Isum_i w_68520_109198# 0.01652f
C1321 w[21] w[31] 1.64843f
C1322 spike[1] neuron_4__VIp 0.14871f
C1323 w[2] DAC_7__Vb 1.53397f
C1324 w_57824_78994# w_68520_78994# 0.29105f
C1325 VDD neuron_4__VIp 11.2119f
C1326 VDD w[26] 0.16936f
C1327 s[2] w[1] 0.04615f
C1328 w[18] w[25] 0.12823f
C1329 VMEM_1 a_108516_39284# 0.09567f
C1330 a_17058_50296# w[11] 0.75911f
C1331 w_62932_109198# w_52956_109198# 0.18533f
C1332 VMEM_0 neuron_4__VKdn 0.19235f
C1333 w[12] w[22] 0.12123f
C1334 neuron_4__Vamp_bias a_105330_14492# 0.06263f
C1335 s[5] w[15] 0.03379f
C1336 DAC_7__Vb a_17058_94688# 0.02045f
C1337 a_103440_57760# neuron_4__Vamp_bias 0.01493f
C1338 a_106338_51444# neuron_4__VK 0.04013f
C1339 w_52956_123386# DAC_1__Isum_e 4.32726f
C1340 spike[0] a_106338_14492# 0.6636f
C1341 spike[4] a_103440_118168# 0.32199f
C1342 s[5] w[29] 0.14915f
C1343 s[6] w[14] 0.04957f
C1344 VDD a_108516_20808# 2.17376f
C1345 w[25] w[16] 0.2461f
C1346 s[7] w[6] 0.03397f
C1347 w_57824_48790# a_16310_50504# 1.50544f
C1348 w[27] w[9] 0.13546f
C1349 a_106338_51444# VDD 0.17724f
C1350 Iref VT 0.5716f
C1351 a_17058_80500# spike[0] 0.22878f
C1352 pulse[1] s[4] 0.1176f
C1353 w_62932_11838# w_52956_11838# 0.18533f
C1354 w_68520_109198# DAC_7__Vb 0.74342f
C1355 a_105330_32968# VMEM_1 0.27808f
C1356 neuron_4__VKup a_108516_87964# 0.04013f
C1357 a_16310_13552# VDD 2.37791f
C1358 w[11] s[4] 0.04291f
C1359 s[3] w[27] 0.10967f
C1360 VDD a_84038_93720# 6.80363f
C1361 w[20] w[11] 0.14795f
C1362 w[17] w[7] 0.11214f
C1363 VMEM_0 a_104702_14142# 1.7577f
C1364 w[1] DAC_7__Vb 1.46208f
C1365 w[12] w[6] 0.19941f
C1366 a_105330_32968# neuron_4__VNA 0.33186f
C1367 w[23] w[10] 0.21444f
C1368 w[23] a_16310_94896# 0.27177f
C1369 a_38446_142736# neuron_4__VK 0.91585f
C1370 w_52956_123386# w[28] 0.92401f
C1371 DPI_4__VT VMEM_4 0.56352f
C1372 a_79938_118260# VDD 2.13827f
C1373 a_105330_32968# a_104702_32618# 7.60272f
C1374 VT neuron_4__VIp 1.34226f
C1375 w_62932_78994# w_68520_78994# 0.4754f
C1376 DAC_3__Isum_i a_16558_80708# 0.70742f
C1377 w_68520_123386# w_52956_123386# 0.19827f
C1378 s[7] w[5] 0.20414f
C1379 a_17058_80500# w_52956_78994# 0.06517f
C1380 DAC_5__Isum_i a_16310_50504# 1.41111f
C1381 a_16310_32028# w[4] 0.01848f
C1382 w[2] s[1] 0.18418f
C1383 w[24] s[4] 0.10931f
C1384 s[2] w[7] 0.05507f
C1385 spike[0] a_79226_52408# 0.34085f
C1386 a_16310_64692# w[15] 0.27177f
C1387 VDD a_38446_142736# 34.9041f
C1388 w[20] w[24] 18.6434f
C1389 w[8] w[4] 0.20484f
C1390 spike[0] w[14] 0.20011f
C1391 w[17] w[22] 0.4966f
C1392 w[13] w[27] 0.1224f
C1393 w[3] VDD 0.22815f
C1394 a_108516_87964# a_109144_87964# 0.27848f
C1395 w_62932_123386# a_17058_124892# 0.06269f
C1396 a_17058_50296# w_52956_48790# 0.06517f
C1397 w[5] w[12] 0.23491f
C1398 a_102902_111852# VDD 0.22723f
C1399 spike[1] a_17058_64484# 0.22878f
C1400 s[2] w[22] 0.11333f
C1401 w[19] s[5] 0.43969f
C1402 s[7] w[10] 0.04254f
C1403 neuron_4__Vamp_bias a_102902_51444# 0.04081f
C1404 s[6] s[4] 0.11843f
C1405 spike[2] a_108516_57760# 1.07702f
C1406 w[8] w[26] 1.15657f
C1407 VDD a_17058_64484# 3.27251f
C1408 s[6] w[20] 0.07869f
C1409 neuron_4__VKup a_108516_39284# 0.04013f
C1410 a_103440_87964# neuron_4__Vamp_bias 0.01758f
C1411 a_16558_13552# s[0] 0.03433f
C1412 spike[0] a_16558_50504# 0.01869f
C1413 spike[0] a_17058_50296# 0.22878f
C1414 w_52956_93182# w_62932_93182# 0.18533f
C1415 w[25] w_57824_109198# 1.30395f
C1416 w_57824_48790# VDD 4.0675f
C1417 w_68520_48790# DAC_7__Vb 0.74342f
C1418 a_105710_51444# a_105330_51444# 0.35156f
C1419 w[17] w[6] 0.12758f
C1420 a_17058_13344# DAC_7__Isum_e 7.15288f
C1421 w[18] w[27] 0.12485f
C1422 spike[2] DPI_4__VT 0.09367f
C1423 w[12] w[10] 0.01308f
C1424 spike[4] neuron_4__VK 0.08809f
C1425 w[7] DAC_7__Vb 1.44206f
C1426 a_104702_51094# VDD 4.23811f
C1427 s[1] w[1] 0.60394f
C1428 spike[4] spike[1] 6.27416f
C1429 pulse[1] w[15] 0.88834f
C1430 a_103440_39284# a_105330_32968# 2.28333f
C1431 w[23] w[9] 0.20787f
C1432 DAC_3__Isum_e a_16310_80708# 0.0727f
C1433 w[31] w[4] 0.20443f
C1434 w[11] w[15] 0.30449f
C1435 DPI_4__Vthr DAC_6__Isum_e 0.89458f
C1436 spike[4] VDD 1.57453f
C1437 s[2] w[6] 0.04109f
C1438 a_105330_32968# neuron_4__VKup 0.52828f
C1439 s[3] w[23] 0.1177f
C1440 s[5] spike[1] 0.64272f
C1441 VDD a_17058_31820# 3.33452f
C1442 w[29] w[11] 1.84967f
C1443 DAC_5__Isum_i spike[1] 0.15863f
C1444 w[27] w[16] 0.2672f
C1445 DAC_7__Vb w[22] 1.42006f
C1446 spike[0] s[4] 0.52064f
C1447 DAC_5__Isum_i VDD 7.52594f
C1448 s[5] VDD 1.71573f
C1449 w[5] w[17] 2.52618f
C1450 a_102902_111852# VT 0.25622f
C1451 DPI_4__Vthr DAC_5__Isum_e 0.89458f
C1452 w_68520_11838# a_17058_13344# 0.0825f
C1453 a_16558_13552# a_17058_13344# 0.07329f
C1454 VDD a_105330_14492# 3.3973f
C1455 a_103440_57760# VDD 9.02621f
C1456 a_16310_110912# w_57824_109198# 1.50544f
C1457 s[7] w[9] 0.03392f
C1458 w_57824_62978# a_17058_64484# 0.06392f
C1459 a_103440_20808# a_105330_14492# 2.28333f
C1460 w[24] w[29] 0.11793f
C1461 w[5] s[2] 0.05014f
C1462 a_105330_51444# VMEM_2 0.27808f
C1463 w[23] w[13] 0.12961f
C1464 w[8] w[3] 0.1362f
C1465 w_57824_93182# w_62932_93182# 0.25259f
C1466 a_106338_111852# a_105710_111852# 0.77061f
C1467 w[7] w[21] 1.71266f
C1468 DAC_1__Isum_i VMEM_4 0.23264f
C1469 w[17] w[10] 0.13221f
C1470 a_104702_51094# VT 0.40203f
C1471 s[7] s[3] 0.40946f
C1472 w[11] a_16310_50504# 0.27177f
C1473 spike[0] neuron_4__Vlk 1.11871f
C1474 a_105082_32968# spike[1] 0.04786f
C1475 w_62932_30314# a_17058_31820# 0.06269f
C1476 DAC_7__Vb w[6] 1.37246f
C1477 w[18] w_62932_78994# 2.11271f
C1478 s[6] w[15] 0.03379f
C1479 a_16310_125100# w[29] 0.0765f
C1480 w[2] w[4] 0.63033f
C1481 spike[4] VT 0.07353f
C1482 w_68520_93182# a_17058_94688# 0.0825f
C1483 a_105082_32968# VDD 0.14568f
C1484 a_79226_15456# DPI_4__VT 1.03969f
C1485 w[7] s[1] 0.68745f
C1486 s[6] w[29] 0.11793f
C1487 a_16310_64692# spike[1] 0.03433f
C1488 spike[0] a_16310_80708# 0.03433f
C1489 a_105082_81648# VMEM_3 0.10136f
C1490 s[2] w[10] 0.3914f
C1491 w[30] s[4] 0.10495f
C1492 spike[3] a_105082_81648# 0.04786f
C1493 a_16310_64692# VDD 0.9668f
C1494 w[21] w[22] 6.16464f
C1495 VDD w_57824_30314# 11.4772f
C1496 w[20] w[30] 0.17176f
C1497 s[3] w[12] 0.71512f
C1498 VDD a_109144_20808# 2.19403f
C1499 DAC_3__Isum_i w_57824_78994# 7.40967f
C1500 neuron_4__VNA VMEM_2 0.20249f
C1501 a_17058_80500# s[4] 1.82491f
C1502 s[7] w[13] 0.07619f
C1503 w[19] w[11] 0.14453f
C1504 w[18] w[23] 0.12716f
C1505 VT a_105330_14492# 0.06629f
C1506 w[2] w[26] 0.1194f
C1507 DAC_5__Isum_i w_57824_62978# 7.40967f
C1508 neuron_4__VNA a_109144_118168# 0.04168f
C1509 w[5] DAC_7__Vb 1.50556f
C1510 a_16310_80708# w_52956_78994# 1.46714f
C1511 spike[0] neuron_4__Vamp_bias 0.38078f
C1512 DPI_4__VT neuron_4__VKdn 0.24898f
C1513 DAC_3__Isum_i w_62932_93182# 9.19624f
C1514 DPI_4__Vthr VMEM_2 1.23607f
C1515 w_62932_11838# w_57824_11838# 0.25259f
C1516 DAC_1__Isum_i w_52956_109198# 0.18329f
C1517 spike[0] w[15] 2.24116f
C1518 w[12] w[13] 5.01241f
C1519 a_16310_32028# a_17058_31820# 0.07085f
C1520 VDD a_102902_51444# 0.22723f
C1521 a_16558_13552# pulse[0] 0.01869f
C1522 w_57824_30314# w_62932_30314# 0.25259f
C1523 w[23] w[16] 0.24092f
C1524 w[21] w[6] 1.23581f
C1525 w[8] s[5] 0.03505f
C1526 a_105082_51444# a_105330_51444# 0.73139f
C1527 w[1] w[4] 0.15015f
C1528 w[14] s[4] 0.04957f
C1529 a_16558_50504# a_17058_50296# 0.07329f
C1530 a_103440_87964# VDD 9.00761f
C1531 a_109144_118168# a_105330_111852# 0.03809f
C1532 a_16310_110912# w[25] 0.0765f
C1533 w_62932_109198# w_57824_109198# 0.25259f
C1534 w[10] DAC_7__Vb 1.37914f
C1535 VDD a_84038_63516# 6.67898f
C1536 w[17] w[9] 0.12344f
C1537 s[7] w[18] 0.26107f
C1538 s[1] w[6] 0.27359f
C1539 a_16310_13552# w[2] 0.13617f
C1540 a_16310_50504# w_52956_48790# 1.46714f
C1541 pulse[1] VDD 0.55227f
C1542 VDD w[11] 2.35746f
C1543 VDD a_79226_112816# 7.09929f
C1544 s[5] w[28] 0.07633f
C1545 s[6] w[19] 0.1578f
C1546 a_17058_80500# a_16310_80708# 0.07085f
C1547 s[3] w[17] 0.14276f
C1548 a_16310_64692# w_57824_62978# 1.50544f
C1549 DAC_3__Isum_i w_62932_78994# 9.19624f
C1550 s[2] w[9] 0.3725f
C1551 spike[2] DAC_7__Vb 0.197f
C1552 w[5] w[21] 0.13679f
C1553 neuron_4__VNA VMEM_4 0.07472f
C1554 w_52956_109198# DAC_7__Vb 0.09295f
C1555 w[18] w[12] 0.12997f
C1556 spike[0] a_16310_50504# 0.03433f
C1557 s[7] w[16] 0.03412f
C1558 spike[2] spike[3] 6.01471f
C1559 a_79226_82612# DPI_4__VT 0.605f
C1560 s[2] s[3] 0.1273f
C1561 VDD w[24] 0.16734f
C1562 DAC_7__Vb w_68520_78994# 0.74342f
C1563 neuron_4__VKup VMEM_2 0.91071f
C1564 w[3] w[2] 4.53758f
C1565 w_68520_48790# w_62932_48790# 0.4754f
C1566 w[5] s[1] 0.27608f
C1567 a_16310_32028# w_57824_30314# 1.50544f
C1568 w[17] w[13] 0.1269f
C1569 spike[2] a_105330_51444# 4.93143f
C1570 DPI_4__Vthr VMEM_4 0.844f
C1571 a_103440_87964# a_102902_81648# 1.25979f
C1572 VT a_102902_51444# 0.25622f
C1573 DAC_3__Isum_e VDD 14.8008f
C1574 w[29] w[30] 13.3972f
C1575 s[5] w[31] 0.14112f
C1576 w[12] w[16] 0.10876f
C1577 w_62932_11838# VDD 13.8716f
C1578 a_105330_111852# VMEM_4 0.27808f
C1579 VDD a_16310_125100# 0.9668f
C1580 w[25] w[27] 0.09279f
C1581 w[21] w[10] 0.10932f
C1582 a_16310_94896# w[21] 0.0765f
C1583 a_106338_81648# a_105082_81648# 0.16252f
C1584 w[7] w[4] 0.36777f
C1585 w[19] spike[0] 0.07426f
C1586 a_16310_13552# w[1] 0.0765f
C1587 s[6] VDD 1.71548f
C1588 s[2] w[13] 8.94169f
C1589 w[0] s[0] 1.28769f
C1590 VDD a_84038_123924# 6.73476f
C1591 s[1] w[10] 0.54582f
C1592 DAC_7__Vb w[9] 1.38852f
C1593 w[14] w[15] 6.93149f
C1594 w[22] w[4] 0.1287f
C1595 spike[2] neuron_4__VNA 0.07814f
C1596 w[7] w[26] 0.1255f
C1597 w[17] w[18] 4.2007f
C1598 s[3] DAC_7__Vb 3.54992f
C1599 VDD w_52956_48790# 3.62712f
C1600 neuron_4__Vamp_bias a_102902_32968# 0.04081f
C1601 a_105710_111852# VMEM_4 0.16404f
C1602 Iref VMEM_2 0.23232f
C1603 a_79226_112816# DAC_1__Isum_e 3.33973f
C1604 a_106338_51444# a_105710_51444# 0.77061f
C1605 w[3] w[1] 0.74263f
C1606 VMEM_1 a_106338_32968# 1.75452f
C1607 DAC_3__Isum_i a_79938_88056# 0.16351f
C1608 spike[0] neuron_4__VK 0.16376f
C1609 a_105710_81648# a_105082_81648# 0.96718f
C1610 pulse[1] a_16310_32028# 0.03433f
C1611 s[6] a_17058_110704# 1.82491f
C1612 w[8] pulse[1] 0.372f
C1613 spike[2] DPI_4__Vthr 0.09367f
C1614 s[2] w[18] 8.81908f
C1615 w[8] w[11] 3.70299f
C1616 spike[0] spike[1] 3.02267f
C1617 s[5] w[2] 0.05331f
C1618 a_17058_13344# s[0] 1.82491f
C1619 neuron_4__VKup VMEM_4 0.05522f
C1620 spike[3] a_105330_81648# 4.93143f
C1621 a_105330_81648# VMEM_3 0.27808f
C1622 spike[0] VDD 2.28369f
C1623 w[13] DAC_7__Vb 1.35603f
C1624 w[19] w[30] 0.1097f
C1625 w[17] w[16] 11.6286f
C1626 a_16310_110912# w[27] 0.27177f
C1627 neuron_4__VIp VMEM_2 0.24676f
C1628 a_79226_33932# VDD 7.05481f
C1629 spike[0] a_103440_20808# 0.32199f
C1630 w_52956_93182# DAC_7__Vb 0.09295f
C1631 DAC_1__Isum_i w_62932_123386# 9.19624f
C1632 w[6] w[4] 0.21384f
C1633 a_17058_80500# w[19] 0.75911f
C1634 s[5] a_17058_94688# 1.82491f
C1635 w[21] w[9] 0.09369f
C1636 DAC_7__Vb neuron_4__VKdn 0.3173f
C1637 w[11] w[28] 0.59154f
C1638 a_105710_32968# VMEM_1 0.16404f
C1639 w[8] w[24] 0.09552f
C1640 neuron_4__VNA a_104702_111502# 0.16872f
C1641 a_16310_125100# DAC_1__Isum_e 0.0727f
C1642 DAC_5__Isum_e a_17058_64484# 7.15288f
C1643 VDD w_52956_78994# 3.62712f
C1644 neuron_4__VKdn VMEM_3 0.26142f
C1645 s[2] w[16] 0.12425f
C1646 spike[3] neuron_4__VKdn 0.18511f
C1647 VDD a_16558_110912# 0.21115f
C1648 s[1] w[9] 0.69199f
C1649 w_62932_109198# a_16310_110912# 11.1313f
C1650 s[3] w[21] 0.21821f
C1651 s[5] a_16558_94896# 0.03433f
C1652 neuron_4__Vlk bias_0__VT_inh 0.17447f
C1653 a_108516_118168# VDD 2.17376f
C1654 a_106338_51444# VMEM_2 1.75452f
C1655 a_105330_32968# a_105082_32968# 0.73139f
C1656 a_104702_81298# spike[3] 0.14351f
C1657 a_106338_111852# spike[4] 0.6636f
C1658 a_104702_81298# VMEM_3 1.7577f
C1659 w[23] w[25] 1.61283f
C1660 w[26] w[6] 0.14375f
C1661 w_57824_48790# DAC_5__Isum_e 1.51859f
C1662 a_106338_14492# neuron_4__VK 0.04013f
C1663 w[24] w[28] 23.0411f
C1664 s[4] w[15] 0.03379f
C1665 a_105082_81648# neuron_4__VIp 0.04013f
C1666 w[18] DAC_7__Vb 1.42035f
C1667 w[5] w[4] 5.36475f
C1668 w[8] s[6] 0.03583f
C1669 Iref VMEM_4 0.61162f
C1670 a_104702_111502# a_105330_111852# 7.60272f
C1671 w[3] w[7] 0.16068f
C1672 s[5] w[1] 0.04629f
C1673 w_52956_11838# w_57824_11838# 4.49996f
C1674 neuron_4__VNA a_105330_81648# 0.33114f
C1675 VDD a_106338_14492# 0.17724f
C1676 DAC_6__Isum_e a_17058_31820# 7.15288f
C1677 w[29] s[4] 0.10918f
C1678 VDD w_52956_30314# 3.81041f
C1679 VDD w[30] 0.16936f
C1680 spike[2] neuron_4__VKup 0.07116f
C1681 a_16558_50504# a_16310_50504# 0.98576f
C1682 w[20] w[29] 0.12571f
C1683 w[11] w[31] 2.03288f
C1684 a_17058_50296# a_16310_50504# 0.07085f
C1685 w_62932_123386# DAC_7__Vb 0.37182f
C1686 spike[0] VT 0.13911f
C1687 w[21] w[13] 0.19601f
C1688 DPI_4__Vthr a_79226_15456# 0.76693f
C1689 w_68520_93182# a_16310_94896# 13.3149f
C1690 a_16310_125100# w[28] 0.01848f
C1691 spike[1] a_16558_64692# 0.01869f
C1692 VMEM_1 neuron_4__VKdn 0.22208f
C1693 VDD a_16558_64692# 0.21115f
C1694 w_62932_48790# w[10] 2.11271f
C1695 a_17058_80500# VDD 3.27251f
C1696 a_16310_125100# w_68520_123386# 13.3149f
C1697 neuron_4__Vamp_bias bias_0__VT_inh 3.2992f
C1698 s[6] w[28] 0.07633f
C1699 neuron_4__Vlk neuron_4__Vamp_bias 5.45496f
C1700 a_17058_110704# a_16558_110912# 0.07329f
C1701 w[8] w_52956_48790# 0.92401f
C1702 w_57824_48790# w_68520_48790# 0.29105f
C1703 DAC_5__Isum_i DAC_5__Isum_e 5.60363f
C1704 neuron_4__VIp VMEM_4 2.09671f
C1705 DAC_7__Vb w[16] 5.32805f
C1706 neuron_4__VNA neuron_4__VKdn 4.41938f
C1707 VDD a_16558_32028# 0.91858f
C1708 w[10] w[4] 0.36189f
C1709 w_57824_93182# DAC_7__Vb 0.18591f
C1710 w[24] w[31] 0.13538f
C1711 s[7] w[25] 0.04254f
C1712 neuron_4__VIp a_105082_51444# 0.04013f
C1713 w_57824_123386# w_62932_123386# 0.25259f
C1714 s[0] pulse[0] 0.57024f
C1715 w[0] pulse[0] 0.4973f
C1716 a_79226_82612# VMEM_3 0.0542f
C1717 a_104702_81298# neuron_4__VNA 0.17066f
C1718 spike[3] a_79226_82612# 0.71634f
C1719 w_68520_11838# DAC_7__Vb 0.74342f
C1720 a_105330_14492# a_105710_14492# 0.35156f
C1721 DPI_4__Vthr neuron_4__VKdn 0.36885f
C1722 w_52956_30314# w_62932_30314# 0.18533f
C1723 a_79226_52408# VDD 7.06393f
C1724 spike[1] w[14] 0.14208f
C1725 w[8] spike[0] 0.17782f
C1726 a_16310_125100# w[31] 0.27177f
C1727 VDD w[14] 0.34737f
C1728 w_68520_30314# DAC_7__Vb 0.74342f
C1729 w[12] w[25] 0.12887f
C1730 neuron_4__VKup a_104702_111502# 0.14489f
C1731 w[18] w[21] 0.11331f
C1732 w[10] w[26] 0.12852f
C1733 spike[2] Iref 0.12176f
C1734 DAC_1__Isum_i w_57824_109198# 7.40967f
C1735 s[6] w[31] 0.14127f
C1736 pulse[1] w[2] 0.27557f
C1737 DAC_6__Isum_e w_57824_30314# 1.51859f
C1738 a_106338_51444# a_105082_51444# 0.16252f
C1739 a_16558_110912# DAC_1__Isum_e 1.13168f
C1740 w_68520_48790# DAC_5__Isum_i 0.01652f
C1741 w[2] w[11] 0.22012f
C1742 neuron_4__VIp a_105082_14492# 0.04013f
C1743 neuron_4__VNA a_104702_14142# 0.16858f
C1744 VMEM_0 DPI_4__VT 0.23937f
C1745 w[3] w[6] 0.14907f
C1746 w[7] a_17058_31820# 0.75911f
C1747 s[5] w[7] 0.0554f
C1748 w[19] s[4] 15.5267f
C1749 VDD a_102902_32968# 0.22723f
C1750 w_52956_11838# VDD 3.81041f
C1751 a_104702_51094# VMEM_2 1.7577f
C1752 w_68520_62978# w_62932_62978# 0.4754f
C1753 w[20] w[19] 0.27514f
C1754 a_16310_64692# DAC_5__Isum_e 0.0727f
C1755 DPI_4__Vthr DAC_7__Isum_e 0.89458f
C1756 w_57824_78994# w_62932_78994# 0.25259f
C1757 a_17058_13344# pulse[0] 0.22878f
C1758 w[21] w[16] 0.21012f
C1759 a_79938_118260# VMEM_4 0.20103f
C1760 spike[2] neuron_4__VIp 0.15067f
C1761 spike[2] w[26] 0.08662f
C1762 w_57824_93182# w[21] 1.30395f
C1763 neuron_4__VKup a_105330_81648# 0.53088f
C1764 a_16558_50504# VDD 0.21115f
C1765 DAC_3__Isum_i VMEM_3 0.23264f
C1766 VDD a_17058_50296# 3.31621f
C1767 spike[3] DAC_3__Isum_i 0.29813f
C1768 a_105710_111852# neuron_4__VKdn 0.04013f
C1769 s[7] s[0] 0.23437f
C1770 s[7] w[0] 0.17408f
C1771 s[5] w[22] 0.39334f
C1772 a_16310_125100# a_16558_125100# 0.98576f
C1773 spike[4] a_109144_118168# 0.14726f
C1774 w_52956_62978# w_68520_62978# 0.19827f
C1775 w_52956_30314# a_16310_32028# 1.46714f
C1776 w[9] w[4] 0.29735f
C1777 w[5] w[3] 0.47705f
C1778 w[8] w[30] 0.14309f
C1779 s[7] a_17058_124892# 1.82491f
C1780 DAC_5__Isum_i VMEM_2 0.23264f
C1781 DAC_7__Vb w_57824_109198# 0.18591f
C1782 a_105710_81648# a_105330_81648# 0.35156f
C1783 w_62932_11838# w[2] 2.11271f
C1784 w[23] w[27] 9.33425f
C1785 DPI_4__Vthr a_79226_82612# 0.76693f
C1786 neuron_4__VKup neuron_4__VKdn 3.73885f
C1787 pulse[1] w[1] 0.06051f
C1788 spike[2] a_106338_51444# 0.6636f
C1789 a_103440_57760# VMEM_2 1.06066f
C1790 a_102902_111852# VMEM_4 0.2633f
C1791 s[3] w[4] 0.06147f
C1792 s[6] w[2] 0.05575f
C1793 w[1] w[11] 0.0138f
C1794 DAC_3__Isum_e a_17058_94688# 7.15288f
C1795 spike[1] s[4] 0.24895f
C1796 w[3] VSS 14.0661f
C1797 w[2] VSS 8.66289f
C1798 w[1] VSS 6.08404f
C1799 w[0] VSS 5.91561f
C1800 pulse[0] VSS 6.88981f
C1801 s[0] VSS 24.7091f
C1802 w[7] VSS 17.3736f
C1803 w[6] VSS 8.97358f
C1804 w[5] VSS 7.82104f
C1805 w[4] VSS 8.65095f
C1806 pulse[1] VSS 8.48038f
C1807 s[1] VSS 28.0119f
C1808 w[11] VSS 19.4553f
C1809 w[10] VSS 8.69839f
C1810 w[9] VSS 7.76171f
C1811 w[8] VSS 9.98496f
C1812 s[2] VSS 26.3025f
C1813 w[15] VSS 16.6804f
C1814 w[14] VSS 9.20226f
C1815 w[13] VSS 11.5013f
C1816 w[12] VSS 17.061f
C1817 s[3] VSS 31.0205f
C1818 w[19] VSS 17.235f
C1819 w[18] VSS 10.6916f
C1820 w[17] VSS 10.6847f
C1821 w[16] VSS 10.7195f
C1822 spike[0] VSS 69.4859f
C1823 s[4] VSS 27.2345f
C1824 w[23] VSS 20.0717f
C1825 w[22] VSS 13.9966f
C1826 w[21] VSS 14.0507f
C1827 w[20] VSS 14.3625f
C1828 spike[1] VSS 66.15839f
C1829 s[5] VSS 29.3018f
C1830 VT VSS 24.4163f
C1831 w[27] VSS 19.3664f
C1832 w[26] VSS 10.5007f
C1833 w[25] VSS 12.1929f
C1834 w[24] VSS 12.4503f
C1835 spike[2] VSS 75.4307f
C1836 spike[4] VSS 34.4093f
C1837 s[6] VSS 29.8928f
C1838 w[31] VSS 23.5768f
C1839 w[30] VSS 11.6377f
C1840 w[29] VSS 13.5625f
C1841 w[28] VSS 20.0569f
C1842 spike[3] VSS 70.26379f
C1843 s[7] VSS 34.1618f
C1844 Iref VSS 0.10076p
C1845 VDD VSS 2.98059p
C1846 a_106338_14492# VSS 3.67986f ; **FLOATING
C1847 a_105710_14492# VSS 2.85794f ; **FLOATING
C1848 a_105082_14492# VSS 4.00483f ; **FLOATING
C1849 a_102902_14492# VSS 4.07791f ; **FLOATING
C1850 a_79226_15456# VSS 8.52314f ; **FLOATING
C1851 a_16558_13552# VSS 2.7749f ; **FLOATING
C1852 a_16310_13552# VSS 7.21379f ; **FLOATING
C1853 a_109144_20808# VSS 0.15398f ; **FLOATING
C1854 VMEM_0 VSS 25.8903f ; **FLOATING
C1855 a_108516_20808# VSS 0.36265f ; **FLOATING
C1856 a_105330_14492# VSS 4.55133f ; **FLOATING
C1857 a_104702_14142# VSS 7.21454f ; **FLOATING
C1858 a_103440_20808# VSS 4.12714f ; **FLOATING
C1859 a_17058_13344# VSS 10.7298f ; **FLOATING
C1860 a_106338_32968# VSS 3.67986f ; **FLOATING
C1861 a_105710_32968# VSS 2.85794f ; **FLOATING
C1862 a_105082_32968# VSS 4.00483f ; **FLOATING
C1863 a_102902_32968# VSS 4.07791f ; **FLOATING
C1864 a_79226_33932# VSS 8.48679f ; **FLOATING
C1865 a_16558_32028# VSS 2.7749f ; **FLOATING
C1866 a_16310_32028# VSS 7.21379f ; **FLOATING
C1867 a_109144_39284# VSS 0.15398f ; **FLOATING
C1868 VMEM_1 VSS 24.9368f ; **FLOATING
C1869 a_108516_39284# VSS 0.36265f ; **FLOATING
C1870 a_105330_32968# VSS 4.51114f ; **FLOATING
C1871 a_104702_32618# VSS 7.12395f ; **FLOATING
C1872 a_103440_39284# VSS 4.11903f ; **FLOATING
C1873 a_17058_31820# VSS 10.6996f ; **FLOATING
C1874 a_106338_51444# VSS 3.67986f ; **FLOATING
C1875 a_105710_51444# VSS 2.85794f ; **FLOATING
C1876 a_105082_51444# VSS 4.00483f ; **FLOATING
C1877 a_102902_51444# VSS 4.07791f ; **FLOATING
C1878 a_79226_52408# VSS 8.33493f ; **FLOATING
C1879 a_16558_50504# VSS 2.7749f ; **FLOATING
C1880 a_16310_50504# VSS 7.21379f ; **FLOATING
C1881 a_109144_57760# VSS 0.15398f ; **FLOATING
C1882 a_108516_57760# VSS 0.36265f ; **FLOATING
C1883 a_105330_51444# VSS 4.55152f ; **FLOATING
C1884 a_104702_51094# VSS 7.20811f ; **FLOATING
C1885 a_103440_57760# VSS 4.14754f ; **FLOATING
C1886 VMEM_2 VSS 30.2288f ; **FLOATING
C1887 a_17058_50296# VSS 10.6903f ; **FLOATING
C1888 a_79938_57852# VSS 14.6846f ; **FLOATING
C1889 a_84038_63516# VSS 11.8341f ; **FLOATING
C1890 a_16558_64692# VSS 2.7749f ; **FLOATING
C1891 a_16310_64692# VSS 7.21379f ; **FLOATING
C1892 a_17058_64484# VSS 10.7093f ; **FLOATING
C1893 a_106338_81648# VSS 3.67986f ; **FLOATING
C1894 a_105710_81648# VSS 2.85794f ; **FLOATING
C1895 a_105082_81648# VSS 4.00483f ; **FLOATING
C1896 a_102902_81648# VSS 4.07791f ; **FLOATING
C1897 a_79226_82612# VSS 8.5368f ; **FLOATING
C1898 a_16558_80708# VSS 2.7749f ; **FLOATING
C1899 a_16310_80708# VSS 7.21379f ; **FLOATING
C1900 a_109144_87964# VSS 0.15398f ; **FLOATING
C1901 a_108516_87964# VSS 0.36265f ; **FLOATING
C1902 a_105330_81648# VSS 4.56188f ; **FLOATING
C1903 a_104702_81298# VSS 7.21477f ; **FLOATING
C1904 a_103440_87964# VSS 4.14192f ; **FLOATING
C1905 VMEM_3 VSS 30.2613f ; **FLOATING
C1906 a_17058_80500# VSS 10.6821f ; **FLOATING
C1907 a_79938_88056# VSS 14.635f ; **FLOATING
C1908 a_84038_93720# VSS 11.5673f ; **FLOATING
C1909 a_16558_94896# VSS 2.7749f ; **FLOATING
C1910 a_16310_94896# VSS 7.21379f ; **FLOATING
C1911 a_17058_94688# VSS 10.6824f ; **FLOATING
C1912 a_106338_111852# VSS 3.67986f ; **FLOATING
C1913 a_105710_111852# VSS 2.85794f ; **FLOATING
C1914 a_105082_111852# VSS 4.00483f ; **FLOATING
C1915 a_102902_111852# VSS 4.07791f ; **FLOATING
C1916 a_79226_112816# VSS 8.35711f ; **FLOATING
C1917 a_16558_110912# VSS 2.7749f ; **FLOATING
C1918 a_16310_110912# VSS 7.21379f ; **FLOATING
C1919 a_109144_118168# VSS 0.15398f ; **FLOATING
C1920 a_108516_118168# VSS 0.36265f ; **FLOATING
C1921 a_105330_111852# VSS 4.56829f ; **FLOATING
C1922 a_104702_111502# VSS 7.21622f ; **FLOATING
C1923 a_103440_118168# VSS 4.13791f ; **FLOATING
C1924 VMEM_4 VSS 30.9409f ; **FLOATING
C1925 a_17058_110704# VSS 10.6898f ; **FLOATING
C1926 a_79938_118260# VSS 14.647f ; **FLOATING
C1927 a_84038_123924# VSS 11.6404f ; **FLOATING
C1928 a_16558_125100# VSS 2.7749f ; **FLOATING
C1929 a_16310_125100# VSS 7.21379f ; **FLOATING
C1930 a_17058_124892# VSS 10.7101f ; **FLOATING
C1931 DPI_4__VT VSS 85.77879f ; **FLOATING
C1932 DPI_4__Vthr VSS 91.48399f ; **FLOATING
C1933 bias_0__VT_inh VSS 24.2176f ; **FLOATING
C1934 neuron_4__Vlk VSS 60.5018f ; **FLOATING
C1935 neuron_4__VNA VSS 32.9579f ; **FLOATING
C1936 neuron_4__VKup VSS 39.0335f ; **FLOATING
C1937 neuron_4__VIp VSS 35.7145f ; **FLOATING
C1938 neuron_4__Vamp_bias VSS 47.2607f ; **FLOATING
C1939 neuron_4__VK VSS 76.5811f ; **FLOATING
C1940 DAC_7__Vb VSS 0.66598p ; **FLOATING
C1941 neuron_4__VKdn VSS 41.8143f ; **FLOATING
C1942 a_38446_142736# VSS 12.9252f ; **FLOATING
C1943 DAC_7__Isum_e VSS 13.8703f ; **FLOATING
C1944 w_68520_11838# VSS 42.2051f ; **FLOATING
C1945 w_62932_11838# VSS 20.0529f ; **FLOATING
C1946 w_57824_11838# VSS 14.1497f ; **FLOATING
C1947 w_52956_11838# VSS 10.6264f ; **FLOATING
C1948 DAC_6__Isum_e VSS 13.9491f ; **FLOATING
C1949 w_68520_30314# VSS 42.1981f ; **FLOATING
C1950 w_62932_30314# VSS 20.0529f ; **FLOATING
C1951 w_57824_30314# VSS 14.1497f ; **FLOATING
C1952 w_52956_30314# VSS 10.6264f ; **FLOATING
C1953 DAC_5__Isum_e VSS 21.7127f ; **FLOATING
C1954 w_68520_48790# VSS 42.1981f ; **FLOATING
C1955 w_62932_48790# VSS 20.0529f ; **FLOATING
C1956 w_57824_48790# VSS 14.1497f ; **FLOATING
C1957 w_52956_48790# VSS 10.6264f ; **FLOATING
C1958 DAC_5__Isum_i VSS 25.4843f ; **FLOATING
C1959 w_68520_62978# VSS 42.1981f ; **FLOATING
C1960 w_62932_62978# VSS 20.0529f ; **FLOATING
C1961 w_57824_62978# VSS 14.1497f ; **FLOATING
C1962 w_52956_62978# VSS 10.6264f ; **FLOATING
C1963 DAC_3__Isum_e VSS 19.3619f ; **FLOATING
C1964 w_68520_78994# VSS 42.1981f ; **FLOATING
C1965 w_62932_78994# VSS 20.0529f ; **FLOATING
C1966 w_57824_78994# VSS 14.1497f ; **FLOATING
C1967 w_52956_78994# VSS 10.6264f ; **FLOATING
C1968 DAC_3__Isum_i VSS 24.8009f ; **FLOATING
C1969 w_68520_93182# VSS 42.1981f ; **FLOATING
C1970 w_62932_93182# VSS 20.0529f ; **FLOATING
C1971 w_57824_93182# VSS 14.1497f ; **FLOATING
C1972 w_52956_93182# VSS 10.6264f ; **FLOATING
C1973 DAC_1__Isum_e VSS 20.6463f ; **FLOATING
C1974 w_68520_109198# VSS 42.1981f ; **FLOATING
C1975 w_62932_109198# VSS 20.0529f ; **FLOATING
C1976 w_57824_109198# VSS 14.1497f ; **FLOATING
C1977 w_52956_109198# VSS 10.6264f ; **FLOATING
C1978 DAC_1__Isum_i VSS 24.6091f ; **FLOATING
C1979 w_68520_123386# VSS 42.1981f ; **FLOATING
C1980 w_62932_123386# VSS 20.0529f ; **FLOATING
C1981 w_57824_123386# VSS 14.1497f ; **FLOATING
C1982 w_52956_123386# VSS 10.6264f ; **FLOATING
.ends
