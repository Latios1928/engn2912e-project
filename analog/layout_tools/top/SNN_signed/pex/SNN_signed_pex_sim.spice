* NGSPICE file created from SNN_signed_flat__ext - technology: gf180mcuD

.subckt SNN_signed_flat w[31] w[30] w[29] w[28] w[27] w[26] w[25] w[24] w[23] w[22]  w[21] w[20] w[19] w[18] w[17] w[16] w[15] w[14] w[13] w[12] w[11] w[10] w[9] w[8]  w[7] w[6] w[5] w[4] w[3] w[2] w[1] w[0] s[7] s[6] s[5] s[4] s[3] s[2] s[1] s[0]  pulse[1] pulse[0] VDD VSS VT spike[4] spike[3] spike[2] spike[1] spike[0] Iref
X20 a_16310_94896# w[22] a_22014_94846# VSS nfet_03v3 ad=0.14p pd=1.06u as=0.3p ps=2.2u w=0.5u l=0.64u
X21 DPI_4__VT DPI_4__VT VDD VDD pfet_03v3 ad=1.12p pd=4.56u as=2.4p ps=9.2u w=4u l=5.12u
X24 VDD bias_0__VT_inh bias_0__VT_inh VDD pfet_03v3 ad=0.528p pd=2.96u as=0.2464p ps=1.44u w=0.88u l=1.12u
X31 VDD s[1] a_16558_32028# VSS nfet_03v3 ad=0.3p pd=2.2u as=0.3p ps=2.2u w=0.5u l=0.64u
X39 a_16310_94896# w[23] a_19914_94846# VSS nfet_03v3 ad=0.14p pd=1.06u as=0.14p ps=1.06u w=0.5u l=0.64u
X41 DPI_4__Vthr Iref VSS VSS nfet_03v3 ad=0.546p pd=3.02u as=0.546p ps=3.02u w=0.91u l=32u
X46 neuron_4__VKdn neuron_4__VKdn VSS VSS nfet_03v3 ad=0.28p pd=1.56u as=0.6p ps=3.2u w=1u l=1u
X57 a_19914_50454# DAC_7__Vb VSS VSS nfet_03v3 ad=0.6p pd=3.2u as=0.6p ps=3.2u w=1u l=8u
X64 VDD neuron_4__VKup a_93348_57760# VDD pfet_03v3 ad=0.6p pd=3.2u as=0.6p ps=3.2u w=1u l=1u
X65 VDD a_88272_87964# a_88272_87964# VDD pfet_03v3 ad=0.3p pd=2.2u as=0.3p ps=2.2u w=0.5u l=8u
X77 a_19914_80658# DAC_7__Vb VSS VSS nfet_03v3 ad=0.6p pd=3.2u as=0.6p ps=3.2u w=1u l=8u
X84 neuron_4__Vlk neuron_4__Vlk VSS VSS nfet_03v3 ad=0.28p pd=1.56u as=0.28p ps=1.56u w=1u l=1u
X85 a_93976_57760# a_90162_51444# VMEM_2 VDD pfet_03v3 ad=0.3p pd=2.2u as=0.3p ps=2.2u w=0.5u l=0.64u
X116 DPI_4__VT DPI_4__VT VDD VDD pfet_03v3 ad=1.12p pd=4.56u as=1.12p ps=4.56u w=4u l=5.12u
X123 a_19914_110862# w[27] a_16310_110912# VSS nfet_03v3 ad=0.14p pd=1.06u as=0.14p ps=1.06u w=0.5u l=0.64u
X126 a_22014_31978# DAC_7__Vb VSS VSS nfet_03v3 ad=0.6p pd=3.2u as=0.6p ps=3.2u w=1u l=8u
X131 VDD a_88272_57760# a_89534_51094# VDD pfet_03v3 ad=0.3p pd=2.2u as=0.3p ps=2.2u w=0.5u l=8u
X134 VMEM_3 neuron_4__Vlk VSS VSS nfet_03v3 ad=0.6p pd=3.2u as=0.6p ps=3.2u w=1u l=1u
X137 a_16310_94896# w[20] a_34614_94846# VSS nfet_03v3 ad=0.3p pd=2.2u as=0.3p ps=2.2u w=0.5u l=0.64u
X140 a_19914_125050# DAC_7__Vb VSS VSS nfet_03v3 ad=0.6p pd=3.2u as=0.6p ps=3.2u w=1u l=8u
X141 a_22014_31978# w[6] a_16310_32028# VSS nfet_03v3 ad=0.14p pd=1.06u as=0.14p ps=1.06u w=0.5u l=0.64u
X150 a_16310_125100# w[31] a_19914_125050# VSS nfet_03v3 ad=0.14p pd=1.06u as=0.14p ps=1.06u w=0.5u l=0.64u
X153 VDD DPI_4__VT a_62528_16118# VDD pfet_03v3 ad=2.4p pd=9.2u as=2.4p ps=9.2u w=4u l=5.12u
X164 a_22014_64642# DAC_7__Vb VSS VSS nfet_03v3 ad=0.6p pd=3.2u as=0.6p ps=3.2u w=1u l=8u
X170 a_22014_80658# DAC_7__Vb VSS VSS nfet_03v3 ad=0.6p pd=3.2u as=0.6p ps=3.2u w=1u l=8u
X174 VDD neuron_4__VNA a_93976_87964# VDD pfet_03v3 ad=0.6p pd=3.2u as=0.6p ps=3.2u w=1u l=1u
X176 VDD bias_0__VT_inh bias_0__VT_inh VDD pfet_03v3 ad=0.2464p pd=1.44u as=0.2464p ps=1.44u w=0.88u l=1.12u
X178 a_88272_39284# VMEM_1 a_87734_32968# VSS nfet_03v3 ad=2.4p pd=9.2u as=2.4p ps=9.2u w=4u l=2u
X186 VDD DPI_4__Vthr DPI_4__Vthr VDD pfet_03v3 ad=1.12p pd=4.56u as=1.12p ps=4.56u w=4u l=5.12u
X212 a_16310_110912# w[25] a_26214_110862# VSS nfet_03v3 ad=0.14p pd=1.06u as=0.3p ps=2.2u w=0.5u l=0.64u
X220 a_19914_64642# DAC_7__Vb VSS VSS nfet_03v3 ad=0.6p pd=3.2u as=0.6p ps=3.2u w=1u l=8u
X225 DPI_4__Vthr DPI_4__Vthr VDD VDD pfet_03v3 ad=1.12p pd=4.56u as=1.12p ps=4.56u w=4u l=5.12u
X227 DPI_4__VT DPI_4__VT VDD VDD pfet_03v3 ad=1.12p pd=4.56u as=1.12p ps=4.56u w=4u l=5.12u
X234 a_22014_31978# w[6] a_16310_32028# VSS nfet_03v3 ad=0.3p pd=2.2u as=0.14p ps=1.06u w=0.5u l=0.64u
X236 a_19914_94846# DAC_7__Vb VSS VSS nfet_03v3 ad=0.6p pd=3.2u as=0.6p ps=3.2u w=1u l=8u
X251 a_19914_110862# DAC_7__Vb VSS VSS nfet_03v3 ad=0.6p pd=3.2u as=0.6p ps=3.2u w=1u l=8u
X255 a_19914_31978# w[7] a_16310_32028# VSS nfet_03v3 ad=0.14p pd=1.06u as=0.14p ps=1.06u w=0.5u l=0.64u
X263 DAC_1__Isum_i s[6] a_16558_110912# VSS nfet_03v3 ad=0.3p pd=2.2u as=0.3p ps=2.2u w=0.5u l=0.64u
X264 a_34614_31978# DAC_7__Vb VSS VSS nfet_03v3 ad=0.6p pd=3.2u as=0.6p ps=3.2u w=1u l=8u
X266 a_91170_32968# neuron_4__VK VSS VSS nfet_03v3 ad=0.6p pd=3.2u as=0.6p ps=3.2u w=1u l=1u
X278 DPI_4__Vthr DPI_4__Vthr VDD VDD pfet_03v3 ad=1.12p pd=4.56u as=1.12p ps=4.56u w=4u l=5.12u
X281 DPI_4__VT DPI_4__VT VDD VDD pfet_03v3 ad=1.12p pd=4.56u as=1.12p ps=4.56u w=4u l=5.12u
X284 VMEM_1 VSS cap_mim_2f0_m4m5_noshield c_width=22.18u c_length=22.18u
X285 a_19914_94846# w[23] a_16310_94896# VSS nfet_03v3 ad=0.14p pd=1.06u as=0.14p ps=1.06u w=0.5u l=0.64u
X289 a_19914_13502# DAC_7__Vb VSS VSS nfet_03v3 ad=0.6p pd=3.2u as=0.6p ps=3.2u w=1u l=8u
X294 neuron_4__Vamp_bias neuron_4__Vamp_bias VSS VSS nfet_03v3 ad=0.3p pd=2.2u as=0.3p ps=2.2u w=0.5u l=0.64u
X296 VDD a_62528_53070# VMEM_2 VDD pfet_03v3 ad=2.4p pd=9.2u as=2.4p ps=9.2u w=4u l=5.12u
X302 a_26214_125050# DAC_7__Vb VSS VSS nfet_03v3 ad=0.6p pd=3.2u as=0.6p ps=3.2u w=1u l=8u
X303 a_22014_94846# DAC_7__Vb VSS VSS nfet_03v3 ad=0.6p pd=3.2u as=0.6p ps=3.2u w=1u l=8u
X314 DAC_1__Isum_e a_17058_124892# a_16558_125100# VSS nfet_03v3 ad=0.3p pd=2.2u as=0.3p ps=2.2u w=0.5u l=0.64u
X318 VDD s[1] a_17058_31820# VDD pfet_03v3 ad=0.3p pd=2.2u as=0.3p ps=2.2u w=0.5u l=0.32u
X332 DPI_4__Vthr DPI_4__Vthr VDD VDD pfet_03v3 ad=1.12p pd=4.56u as=2.4p ps=9.2u w=4u l=5.12u
X335 a_19914_110862# w[27] a_16310_110912# VSS nfet_03v3 ad=0.3p pd=2.2u as=0.14p ps=1.06u w=0.5u l=0.64u
X336 a_62528_53070# a_62528_53070# DAC_5__Isum_e DAC_5__Isum_e nfet_03v3 ad=2.4p pd=9.2u as=2.4p ps=9.2u w=4u l=5.12u
X344 DAC_3__Isum_e a_17058_80500# a_16558_80708# VSS nfet_03v3 ad=0.3p pd=2.2u as=0.3p ps=2.2u w=0.5u l=0.64u
X351 a_19914_31978# w[7] a_16310_32028# VSS nfet_03v3 ad=0.3p pd=2.2u as=0.14p ps=1.06u w=0.5u l=0.64u
X373 a_17058_80500# s[4] VSS VSS nfet_03v3 ad=0.3p pd=2.2u as=0.3p ps=2.2u w=0.5u l=0.64u
X379 a_93348_118168# a_90162_111852# spike[4] VDD pfet_03v3 ad=0.3p pd=2.2u as=0.3p ps=2.2u w=0.5u l=0.64u
X380 a_89534_32618# VT a_87734_32968# VSS nfet_03v3 ad=2.4p pd=9.2u as=2.4p ps=9.2u w=4u l=2u
X381 DAC_5__Isum_e a_17058_64484# a_16558_64692# VSS nfet_03v3 ad=0.3p pd=2.2u as=0.3p ps=2.2u w=0.5u l=0.64u
X388 VDD s[0] a_16558_13552# VSS nfet_03v3 ad=0.3p pd=2.2u as=0.3p ps=2.2u w=0.5u l=0.64u
X396 DPI_4__Vthr DPI_4__Vthr VDD VDD pfet_03v3 ad=1.12p pd=4.56u as=1.12p ps=4.56u w=4u l=5.12u
X397 a_17058_64484# s[3] VSS VSS nfet_03v3 ad=0.3p pd=2.2u as=0.3p ps=2.2u w=0.5u l=0.64u
X417 a_19914_125050# w[31] a_16310_125100# VSS nfet_03v3 ad=0.14p pd=1.06u as=0.14p ps=1.06u w=0.5u l=0.64u
X421 a_19914_50454# DAC_7__Vb VSS VSS nfet_03v3 ad=0.6p pd=3.2u as=0.6p ps=3.2u w=1u l=8u
X439 neuron_4__VNA Iref VSS VSS nfet_03v3 ad=3.456p pd=12.72u as=3.456p ps=12.72u w=5.76u l=8u
X442 a_19914_80658# DAC_7__Vb VSS VSS nfet_03v3 ad=0.6p pd=3.2u as=0.6p ps=3.2u w=1u l=8u
X449 VDD a_62528_16118# cap_mim_2f0_m4m5_noshield c_width=22.18u c_length=22.18u
X461 a_22014_13502# w[2] a_16310_13552# VSS nfet_03v3 ad=0.14p pd=1.06u as=0.14p ps=1.06u w=0.5u l=0.64u
X470 a_26214_80658# w[17] a_16310_80708# VSS nfet_03v3 ad=0.3p pd=2.2u as=0.14p ps=1.06u w=0.5u l=0.64u
X482 VDD DPI_4__VT DPI_4__VT VDD pfet_03v3 ad=1.12p pd=4.56u as=1.12p ps=4.56u w=4u l=5.12u
X485 a_90162_32968# a_89534_32618# a_89914_32968# VSS nfet_03v3 ad=0.3p pd=2.2u as=0.3p ps=2.2u w=0.5u l=0.64u
X490 DAC_5__Isum_i s[2] a_16558_50504# VSS nfet_03v3 ad=0.3p pd=2.2u as=0.3p ps=2.2u w=0.5u l=0.64u
X492 VMEM_3 spike[3] a_91170_81648# VSS nfet_03v3 ad=0.3p pd=2.2u as=0.3p ps=2.2u w=0.5u l=11.36u
X495 a_26214_50454# DAC_7__Vb VSS VSS nfet_03v3 ad=0.6p pd=3.2u as=0.6p ps=3.2u w=1u l=8u
X501 neuron_4__VKdn neuron_4__VKdn VSS VSS nfet_03v3 ad=0.28p pd=1.56u as=0.28p ps=1.56u w=1u l=1u
X508 a_26214_64642# w[13] a_16310_64692# VSS nfet_03v3 ad=0.3p pd=2.2u as=0.14p ps=1.06u w=0.5u l=0.64u
X510 a_22014_80658# DAC_7__Vb VSS VSS nfet_03v3 ad=0.6p pd=3.2u as=0.6p ps=3.2u w=1u l=8u
X512 a_16310_125100# w[29] a_26214_125050# VSS nfet_03v3 ad=0.14p pd=1.06u as=0.3p ps=2.2u w=0.5u l=0.64u
X519 bias_0__VT_inh Iref VSS VSS nfet_03v3 ad=0.378p pd=2.46u as=0.378p ps=2.46u w=0.63u l=32u
X527 VMEM_2 VSS cap_mim_2f0_m4m5_noshield c_width=22.18u c_length=22.18u
X537 VDD a_62528_113478# cap_mim_2f0_m4m5_noshield c_width=22.18u c_length=22.18u
X538 VDD neuron_4__VKup a_93348_118168# VDD pfet_03v3 ad=0.6p pd=3.2u as=0.6p ps=3.2u w=1u l=1u
X544 a_19914_94846# w[23] a_16310_94896# VSS nfet_03v3 ad=0.14p pd=1.06u as=0.14p ps=1.06u w=0.5u l=0.64u
X548 VDD DPI_4__VT DPI_4__VT VDD pfet_03v3 ad=1.12p pd=4.56u as=1.12p ps=4.56u w=4u l=5.12u
X553 a_19914_31978# DAC_7__Vb VSS VSS nfet_03v3 ad=0.6p pd=3.2u as=0.6p ps=3.2u w=1u l=8u
X555 a_19914_125050# DAC_7__Vb VSS VSS nfet_03v3 ad=0.6p pd=3.2u as=0.6p ps=3.2u w=1u l=8u
X562 a_90542_81648# neuron_4__VKdn VSS VSS nfet_03v3 ad=0.6p pd=3.2u as=0.6p ps=3.2u w=1u l=1u
X566 DAC_1__Isum_i s[7] a_16558_125100# VSS nfet_03v3 ad=0.3p pd=2.2u as=0.3p ps=2.2u w=0.5u l=0.64u
X571 VDD a_89534_81298# a_90162_81648# VDD pfet_03v3 ad=0.3p pd=2.2u as=0.3p ps=2.2u w=0.5u l=0.64u
X572 a_22014_13502# w[2] a_16310_13552# VSS nfet_03v3 ad=0.3p pd=2.2u as=0.14p ps=1.06u w=0.5u l=0.64u
X579 a_22014_50454# w[10] a_16310_50504# VSS nfet_03v3 ad=0.14p pd=1.06u as=0.14p ps=1.06u w=0.5u l=0.64u
X580 VMEM_2 a_62978_59374# VSS VSS nfet_03v3 ad=1.44p pd=6u as=1.44p ps=6u w=2.4u l=8u
X584 a_19914_64642# DAC_7__Vb VSS VSS nfet_03v3 ad=0.6p pd=3.2u as=0.6p ps=3.2u w=1u l=8u
X590 a_19914_13502# w[3] a_16310_13552# VSS nfet_03v3 ad=0.14p pd=1.06u as=0.14p ps=1.06u w=0.5u l=0.64u
X599 a_19914_94846# DAC_7__Vb VSS VSS nfet_03v3 ad=0.6p pd=3.2u as=0.6p ps=3.2u w=1u l=8u
X602 VDD bias_0__VT_inh bias_0__VT_inh VDD pfet_03v3 ad=0.2464p pd=1.44u as=0.2464p ps=1.44u w=0.88u l=1.12u
X606 VDD DPI_4__VT DPI_4__VT VDD pfet_03v3 ad=1.12p pd=4.56u as=1.12p ps=4.56u w=4u l=5.12u
X615 VDD a_4687_155494# neuron_4__Vamp_bias VDD pfet_03v3 ad=5.484p pd=19.48u as=5.484p ps=19.48u w=9.14u l=8u
X625 DPI_4__VT DPI_4__VT VDD VDD pfet_03v3 ad=1.12p pd=4.56u as=1.12p ps=4.56u w=4u l=5.12u
X641 a_62978_59374# a_62978_59374# VSS VSS nfet_03v3 ad=1.2p pd=5.2u as=1.2p ps=5.2u w=2u l=8u
X642 a_26214_64642# DAC_7__Vb VSS VSS nfet_03v3 ad=0.6p pd=3.2u as=0.6p ps=3.2u w=1u l=8u
X643 a_19914_125050# w[31] a_16310_125100# VSS nfet_03v3 ad=0.3p pd=2.2u as=0.14p ps=1.06u w=0.5u l=0.64u
X654 a_19914_13502# DAC_7__Vb VSS VSS nfet_03v3 ad=0.6p pd=3.2u as=0.6p ps=3.2u w=1u l=8u
X656 a_88272_20808# VMEM_0 a_87734_14492# VSS nfet_03v3 ad=2.4p pd=9.2u as=2.4p ps=9.2u w=4u l=2u
X661 a_22014_94846# DAC_7__Vb VSS VSS nfet_03v3 ad=0.6p pd=3.2u as=0.6p ps=3.2u w=1u l=8u
X667 VDD neuron_4__VNA neuron_4__VNA VDD pfet_03v3 ad=0.3p pd=2.2u as=0.3p ps=2.2u w=0.5u l=45.45u
X669 VDD a_4687_155494# DAC_7__Vb VDD pfet_03v3 ad=0.864p pd=4.08u as=0.864p ps=4.08u w=1.44u l=8u
X678 a_22014_50454# w[10] a_16310_50504# VSS nfet_03v3 ad=0.3p pd=2.2u as=0.14p ps=1.06u w=0.5u l=0.64u
X686 DPI_4__VT DPI_4__VT VDD VDD pfet_03v3 ad=1.12p pd=4.56u as=1.12p ps=4.56u w=4u l=5.12u
X689 a_19914_13502# w[3] a_16310_13552# VSS nfet_03v3 ad=0.3p pd=2.2u as=0.14p ps=1.06u w=0.5u l=0.64u
X694 a_19914_50454# w[11] a_16310_50504# VSS nfet_03v3 ad=0.14p pd=1.06u as=0.14p ps=1.06u w=0.5u l=0.64u
X707 VDD a_4687_155494# neuron_4__VIp VDD pfet_03v3 ad=1.404p pd=5.88u as=1.404p ps=5.88u w=2.34u l=8u
X709 a_89914_111852# neuron_4__VIp VSS VSS nfet_03v3 ad=0.6p pd=3.2u as=0.6p ps=3.2u w=1u l=1u
X711 VDD neuron_4__VKup a_93348_20808# VDD pfet_03v3 ad=0.6p pd=3.2u as=0.6p ps=3.2u w=1u l=1u
X713 a_16310_32028# w[6] a_22014_31978# VSS nfet_03v3 ad=0.14p pd=1.06u as=0.14p ps=1.06u w=0.5u l=0.64u
X715 a_26214_13502# DAC_7__Vb VSS VSS nfet_03v3 ad=0.6p pd=3.2u as=0.6p ps=3.2u w=1u l=8u
X726 a_22014_110862# DAC_7__Vb VSS VSS nfet_03v3 ad=0.6p pd=3.2u as=0.6p ps=3.2u w=1u l=8u
X727 a_22014_50454# DAC_7__Vb VSS VSS nfet_03v3 ad=0.6p pd=3.2u as=0.6p ps=3.2u w=1u l=8u
X733 a_16558_32028# pulse[1] a_16310_32028# VSS nfet_03v3 ad=0.3p pd=2.2u as=0.3p ps=2.2u w=0.5u l=0.64u
X738 DPI_4__Vthr DPI_4__Vthr VDD VDD pfet_03v3 ad=1.12p pd=4.56u as=1.12p ps=4.56u w=4u l=5.12u
X740 a_16310_32028# w[7] a_19914_31978# VSS nfet_03v3 ad=0.14p pd=1.06u as=0.14p ps=1.06u w=0.5u l=0.64u
X745 a_88272_118168# VMEM_4 a_87734_111852# VSS nfet_03v3 ad=2.4p pd=9.2u as=2.4p ps=9.2u w=4u l=2u
X752 VDD DPI_4__Vthr DAC_3__Isum_i DAC_3__Isum_i nfet_03v3 ad=2.4p pd=9.2u as=2.4p ps=9.2u w=4u l=5.12u
X768 a_91170_14492# neuron_4__VK VSS VSS nfet_03v3 ad=0.6p pd=3.2u as=0.6p ps=3.2u w=1u l=1u
X788 a_19914_13502# DAC_7__Vb VSS VSS nfet_03v3 ad=0.6p pd=3.2u as=0.6p ps=3.2u w=1u l=8u
X792 a_19914_110862# DAC_7__Vb VSS VSS nfet_03v3 ad=0.6p pd=3.2u as=0.6p ps=3.2u w=1u l=8u
X798 a_19914_50454# w[11] a_16310_50504# VSS nfet_03v3 ad=0.3p pd=2.2u as=0.14p ps=1.06u w=0.5u l=0.64u
X800 a_16310_94896# w[21] a_26214_94846# VSS nfet_03v3 ad=0.14p pd=1.06u as=0.3p ps=2.2u w=0.5u l=0.64u
X843 a_89914_51444# neuron_4__VIp VSS VSS nfet_03v3 ad=0.6p pd=3.2u as=0.6p ps=3.2u w=1u l=1u
X844 a_16310_32028# w[7] a_19914_31978# VSS nfet_03v3 ad=0.14p pd=1.06u as=0.14p ps=1.06u w=0.5u l=0.64u
X854 VDD a_62528_53070# cap_mim_2f0_m4m5_noshield c_width=22.18u c_length=22.18u
X855 a_87734_111852# neuron_4__Vamp_bias VSS VSS nfet_03v3 ad=0.3p pd=2.2u as=0.3p ps=2.2u w=0.5u l=0.64u
X872 a_34614_50454# DAC_7__Vb VSS VSS nfet_03v3 ad=0.6p pd=3.2u as=0.6p ps=3.2u w=1u l=8u
X879 a_89534_14142# VT a_87734_14492# VSS nfet_03v3 ad=2.4p pd=9.2u as=2.4p ps=9.2u w=4u l=2u
X880 a_22014_64642# DAC_7__Vb VSS VSS nfet_03v3 ad=0.6p pd=3.2u as=0.6p ps=3.2u w=1u l=8u
X882 DPI_4__VT DPI_4__VT VDD VDD pfet_03v3 ad=1.12p pd=4.56u as=1.12p ps=4.56u w=4u l=5.12u
X885 a_22014_80658# DAC_7__Vb VSS VSS nfet_03v3 ad=0.6p pd=3.2u as=0.6p ps=3.2u w=1u l=8u
X887 a_67078_125606# a_67078_125606# DAC_1__Isum_i DAC_1__Isum_i nfet_03v3 ad=2.4p pd=9.2u as=2.4p ps=9.2u w=4u l=5.12u
X895 VDD DPI_4__VT DPI_4__VT VDD pfet_03v3 ad=1.12p pd=4.56u as=1.12p ps=4.56u w=4u l=5.12u
X908 a_16310_32028# w[7] a_19914_31978# VSS nfet_03v3 ad=0.14p pd=1.06u as=0.3p ps=2.2u w=0.5u l=0.64u
X909 a_16310_110912# w[26] a_22014_110862# VSS nfet_03v3 ad=0.14p pd=1.06u as=0.3p ps=2.2u w=0.5u l=0.64u
X933 a_19914_31978# DAC_7__Vb VSS VSS nfet_03v3 ad=0.6p pd=3.2u as=0.6p ps=3.2u w=1u l=8u
X943 VDD s[2] a_17058_50296# VDD pfet_03v3 ad=0.3p pd=2.2u as=0.3p ps=2.2u w=0.5u l=0.32u
X945 VDD s[6] a_17058_110704# VDD pfet_03v3 ad=0.3p pd=2.2u as=0.3p ps=2.2u w=0.5u l=0.32u
X958 a_19914_80658# DAC_7__Vb VSS VSS nfet_03v3 ad=0.6p pd=3.2u as=0.6p ps=3.2u w=1u l=8u
X963 VDD DPI_4__Vthr DPI_4__Vthr VDD pfet_03v3 ad=1.12p pd=4.56u as=1.12p ps=4.56u w=4u l=5.12u
X965 VDD DPI_4__VT DPI_4__VT VDD pfet_03v3 ad=1.12p pd=4.56u as=1.12p ps=4.56u w=4u l=5.12u
X966 a_62978_119782# a_62978_119782# VSS VSS nfet_03v3 ad=1.2p pd=5.2u as=1.2p ps=5.2u w=2u l=8u
X967 VDD neuron_4__VKup a_93348_87964# VDD pfet_03v3 ad=0.6p pd=3.2u as=0.6p ps=3.2u w=1u l=1u
X979 a_22014_110862# w[26] a_16310_110912# VSS nfet_03v3 ad=0.14p pd=1.06u as=0.14p ps=1.06u w=0.5u l=0.64u
X983 a_93976_87964# a_90162_81648# VMEM_3 VDD pfet_03v3 ad=0.3p pd=2.2u as=0.3p ps=2.2u w=0.5u l=0.64u
X988 VDD bias_0__VT_inh bias_0__VT_inh VDD pfet_03v3 ad=0.2464p pd=1.44u as=0.2464p ps=1.44u w=0.88u l=1.12u
X1001 a_16310_32028# w[6] a_22014_31978# VSS nfet_03v3 ad=0.14p pd=1.06u as=0.3p ps=2.2u w=0.5u l=0.64u
X1007 a_26214_31978# DAC_7__Vb VSS VSS nfet_03v3 ad=0.6p pd=3.2u as=0.6p ps=3.2u w=1u l=8u
X1012 a_90162_14492# a_89534_14142# a_89914_14492# VSS nfet_03v3 ad=0.3p pd=2.2u as=0.3p ps=2.2u w=0.5u l=0.64u
X1014 a_93348_39284# a_90162_32968# spike[1] VDD pfet_03v3 ad=0.3p pd=2.2u as=0.3p ps=2.2u w=0.5u l=0.64u
X1016 DPI_4__VT DPI_4__VT VDD VDD pfet_03v3 ad=1.12p pd=4.56u as=1.12p ps=4.56u w=4u l=5.12u
X1022 a_16310_32028# w[7] a_19914_31978# VSS nfet_03v3 ad=0.14p pd=1.06u as=0.14p ps=1.06u w=0.5u l=0.64u
X1026 neuron_4__Vlk neuron_4__Vlk VSS VSS nfet_03v3 ad=0.28p pd=1.56u as=0.28p ps=1.56u w=1u l=1u
X1027 VDD a_88272_87964# a_89534_81298# VDD pfet_03v3 ad=0.3p pd=2.2u as=0.3p ps=2.2u w=0.5u l=8u
X1034 VDD DPI_4__VT DPI_4__VT VDD pfet_03v3 ad=1.12p pd=4.56u as=1.12p ps=4.56u w=4u l=5.12u
X1037 a_34614_64642# DAC_7__Vb VSS VSS nfet_03v3 ad=0.6p pd=3.2u as=0.6p ps=3.2u w=1u l=8u
X1045 a_22014_94846# DAC_7__Vb VSS VSS nfet_03v3 ad=0.6p pd=3.2u as=0.6p ps=3.2u w=1u l=8u
X1054 a_22014_125050# DAC_7__Vb VSS VSS nfet_03v3 ad=0.6p pd=3.2u as=0.6p ps=3.2u w=1u l=8u
X1065 a_22014_110862# DAC_7__Vb VSS VSS nfet_03v3 ad=0.6p pd=3.2u as=0.6p ps=3.2u w=1u l=8u
X1071 a_19914_31978# DAC_7__Vb VSS VSS nfet_03v3 ad=0.6p pd=3.2u as=0.6p ps=3.2u w=1u l=8u
X1086 VMEM_1 neuron_4__Vlk VSS VSS nfet_03v3 ad=0.6p pd=3.2u as=0.6p ps=3.2u w=1u l=1u
X1087 a_16310_13552# w[2] a_22014_13502# VSS nfet_03v3 ad=0.14p pd=1.06u as=0.14p ps=1.06u w=0.5u l=0.64u
X1105 a_16558_13552# pulse[0] a_16310_13552# VSS nfet_03v3 ad=0.3p pd=2.2u as=0.3p ps=2.2u w=0.5u l=0.64u
X1106 a_16310_32028# w[4] a_34614_31978# VSS nfet_03v3 ad=0.3p pd=2.2u as=0.3p ps=2.2u w=0.5u l=0.64u
X1113 VMEM_4 a_62978_119782# VSS VSS nfet_03v3 ad=1.44p pd=6u as=1.44p ps=6u w=2.4u l=8u
X1115 a_16310_13552# w[3] a_19914_13502# VSS nfet_03v3 ad=0.14p pd=1.06u as=0.14p ps=1.06u w=0.5u l=0.64u
X1119 VDD a_88272_118168# a_89534_111502# VDD pfet_03v3 ad=0.3p pd=2.2u as=0.3p ps=2.2u w=0.5u l=8u
X1129 a_19914_94846# DAC_7__Vb VSS VSS nfet_03v3 ad=0.6p pd=3.2u as=0.6p ps=3.2u w=1u l=8u
X1138 a_19914_125050# DAC_7__Vb VSS VSS nfet_03v3 ad=0.6p pd=3.2u as=0.6p ps=3.2u w=1u l=8u
X1139 a_90162_51444# a_89534_51094# a_89914_51444# VSS nfet_03v3 ad=0.3p pd=2.2u as=0.3p ps=2.2u w=0.5u l=0.64u
X1144 DPI_4__Vthr DPI_4__Vthr VDD VDD pfet_03v3 ad=1.12p pd=4.56u as=1.12p ps=4.56u w=4u l=5.12u
X1170 a_19914_110862# w[27] a_16310_110912# VSS nfet_03v3 ad=0.14p pd=1.06u as=0.14p ps=1.06u w=0.5u l=0.64u
X1177 VDD DPI_4__VT DPI_4__VT VDD pfet_03v3 ad=1.12p pd=4.56u as=1.12p ps=4.56u w=4u l=5.12u
X1180 VDD a_88272_118168# a_88272_118168# VDD pfet_03v3 ad=0.3p pd=2.2u as=0.3p ps=2.2u w=0.5u l=8u
X1182 VDD bias_0__VT_inh bias_0__VT_inh VDD pfet_03v3 ad=0.2464p pd=1.44u as=0.2464p ps=1.44u w=0.88u l=1.12u
X1183 a_19914_13502# DAC_7__Vb VSS VSS nfet_03v3 ad=0.6p pd=3.2u as=0.6p ps=3.2u w=1u l=8u
X1185 DPI_4__VT DPI_4__VT VDD VDD pfet_03v3 ad=1.12p pd=4.56u as=1.12p ps=4.56u w=4u l=5.12u
X1188 a_19914_50454# DAC_7__Vb VSS VSS nfet_03v3 ad=0.6p pd=3.2u as=0.6p ps=3.2u w=1u l=8u
X1189 DPI_4__Vthr DPI_4__Vthr VDD VDD pfet_03v3 ad=1.12p pd=4.56u as=1.12p ps=4.56u w=4u l=5.12u
X1195 a_16310_50504# w[10] a_22014_50454# VSS nfet_03v3 ad=0.14p pd=1.06u as=0.14p ps=1.06u w=0.5u l=0.64u
X1196 a_62528_16118# a_62528_16118# DAC_7__Isum_e DAC_7__Isum_e nfet_03v3 ad=2.4p pd=9.2u as=2.4p ps=9.2u w=4u l=5.12u
X1200 VDD a_62528_83274# VMEM_3 VDD pfet_03v3 ad=2.4p pd=9.2u as=2.4p ps=9.2u w=4u l=5.12u
X1204 a_16310_13552# w[3] a_19914_13502# VSS nfet_03v3 ad=0.14p pd=1.06u as=0.14p ps=1.06u w=0.5u l=0.64u
X1205 a_16558_50504# spike[0] a_16310_50504# VSS nfet_03v3 ad=0.3p pd=2.2u as=0.3p ps=2.2u w=0.5u l=0.64u
X1212 a_22014_110862# w[26] a_16310_110912# VSS nfet_03v3 ad=0.3p pd=2.2u as=0.14p ps=1.06u w=0.5u l=0.64u
X1214 a_16310_50504# w[11] a_19914_50454# VSS nfet_03v3 ad=0.14p pd=1.06u as=0.14p ps=1.06u w=0.5u l=0.64u
X1219 VSS neuron_4__VKdn neuron_4__VKdn VSS nfet_03v3 ad=0.28p pd=1.56u as=0.28p ps=1.56u w=1u l=1u
X1230 spike[1] VSS cap_mim_2f0_m4m5_noshield c_width=10u c_length=10u
X1232 a_87734_32968# neuron_4__Vamp_bias VSS VSS nfet_03v3 ad=0.3p pd=2.2u as=0.3p ps=2.2u w=0.5u l=0.64u
X1235 a_16310_125100# w[30] a_22014_125050# VSS nfet_03v3 ad=0.14p pd=1.06u as=0.3p ps=2.2u w=0.5u l=0.64u
X1241 a_19914_110862# DAC_7__Vb VSS VSS nfet_03v3 ad=0.6p pd=3.2u as=0.6p ps=3.2u w=1u l=8u
X1243 a_90542_111852# neuron_4__VKdn VSS VSS nfet_03v3 ad=0.6p pd=3.2u as=0.6p ps=3.2u w=1u l=1u
X1249 DPI_4__VT DPI_4__VT VDD VDD pfet_03v3 ad=1.12p pd=4.56u as=1.12p ps=4.56u w=4u l=5.12u
X1250 bias_0__VT_inh bias_0__VT_inh VDD VDD pfet_03v3 ad=0.2464p pd=1.44u as=0.2464p ps=1.44u w=0.88u l=1.12u
X1252 a_62528_83274# a_62528_83274# DAC_3__Isum_e DAC_3__Isum_e nfet_03v3 ad=2.4p pd=9.2u as=2.4p ps=9.2u w=4u l=5.12u
X1258 a_19914_31978# w[7] a_16310_32028# VSS nfet_03v3 ad=0.14p pd=1.06u as=0.14p ps=1.06u w=0.5u l=0.64u
X1260 VDD DPI_4__VT a_67078_125606# VDD pfet_03v3 ad=2.4p pd=9.2u as=2.4p ps=9.2u w=4u l=5.12u
X1267 spike[0] VSS cap_mim_2f0_m4m5_noshield c_width=10u c_length=10u
X1270 a_16310_13552# w[3] a_19914_13502# VSS nfet_03v3 ad=0.14p pd=1.06u as=0.3p ps=2.2u w=0.5u l=0.64u
X1275 neuron_4__Vlk neuron_4__Vlk VSS VSS nfet_03v3 ad=0.28p pd=1.56u as=0.28p ps=1.56u w=1u l=1u
X1277 bias_0__VT_inh bias_0__VT_inh VDD VDD pfet_03v3 ad=0.2464p pd=1.44u as=0.2464p ps=1.44u w=0.88u l=1.12u
X1282 DAC_3__Isum_e a_17058_94688# a_16558_94896# VSS nfet_03v3 ad=0.3p pd=2.2u as=0.3p ps=2.2u w=0.5u l=0.64u
X1289 VDD DPI_4__VT DPI_4__VT VDD pfet_03v3 ad=1.12p pd=4.56u as=1.12p ps=4.56u w=4u l=5.12u
X1294 a_22014_125050# w[30] a_16310_125100# VSS nfet_03v3 ad=0.14p pd=1.06u as=0.14p ps=1.06u w=0.5u l=0.64u
X1307 a_17058_94688# s[5] VSS VSS nfet_03v3 ad=0.3p pd=2.2u as=0.3p ps=2.2u w=0.5u l=0.64u
X1317 a_16310_50504# w[11] a_19914_50454# VSS nfet_03v3 ad=0.14p pd=1.06u as=0.14p ps=1.06u w=0.5u l=0.64u
X1320 VMEM_4 spike[4] a_91170_111852# VSS nfet_03v3 ad=0.3p pd=2.2u as=0.3p ps=2.2u w=0.5u l=11.36u
X1324 VDD DPI_4__VT DPI_4__VT VDD pfet_03v3 ad=1.12p pd=4.56u as=1.12p ps=4.56u w=4u l=5.12u
X1333 a_19914_64642# DAC_7__Vb VSS VSS nfet_03v3 ad=0.6p pd=3.2u as=0.6p ps=3.2u w=1u l=8u
X1339 VDD DPI_4__Vthr DPI_4__Vthr VDD pfet_03v3 ad=1.12p pd=4.56u as=1.12p ps=4.56u w=4u l=5.12u
X1340 a_19914_80658# DAC_7__Vb VSS VSS nfet_03v3 ad=0.6p pd=3.2u as=0.6p ps=3.2u w=1u l=8u
X1345 bias_0__VT_inh bias_0__VT_inh VDD VDD pfet_03v3 ad=0.2464p pd=1.44u as=0.2464p ps=1.44u w=0.88u l=1.12u
X1347 a_16310_13552# w[2] a_22014_13502# VSS nfet_03v3 ad=0.14p pd=1.06u as=0.3p ps=2.2u w=0.5u l=0.64u
X1351 a_93348_20808# a_90162_14492# spike[0] VDD pfet_03v3 ad=0.3p pd=2.2u as=0.3p ps=2.2u w=0.5u l=0.64u
X1367 a_16310_13552# w[3] a_19914_13502# VSS nfet_03v3 ad=0.14p pd=1.06u as=0.14p ps=1.06u w=0.5u l=0.64u
X1375 a_16310_50504# w[11] a_19914_50454# VSS nfet_03v3 ad=0.14p pd=1.06u as=0.3p ps=2.2u w=0.5u l=0.64u
X1383 a_22014_125050# DAC_7__Vb VSS VSS nfet_03v3 ad=0.6p pd=3.2u as=0.6p ps=3.2u w=1u l=8u
X1385 VDD DPI_4__VT DPI_4__VT VDD pfet_03v3 ad=1.12p pd=4.56u as=1.12p ps=4.56u w=4u l=5.12u
X1386 VDD DPI_4__VT a_62528_34594# VDD pfet_03v3 ad=2.4p pd=9.2u as=2.4p ps=9.2u w=4u l=5.12u
X1400 VDD DPI_4__Vthr DPI_4__Vthr VDD pfet_03v3 ad=1.12p pd=4.56u as=1.12p ps=4.56u w=4u l=5.12u
X1406 DAC_3__Isum_i s[4] a_16558_80708# VSS nfet_03v3 ad=0.3p pd=2.2u as=0.3p ps=2.2u w=0.5u l=0.64u
X1410 a_26214_80658# DAC_7__Vb VSS VSS nfet_03v3 ad=0.6p pd=3.2u as=0.6p ps=3.2u w=1u l=8u
X1422 a_26214_94846# w[21] a_16310_94896# VSS nfet_03v3 ad=0.3p pd=2.2u as=0.14p ps=1.06u w=0.5u l=0.64u
X1436 DAC_5__Isum_i s[3] a_16558_64692# VSS nfet_03v3 ad=0.3p pd=2.2u as=0.3p ps=2.2u w=0.5u l=0.64u
X1442 a_16310_13552# w[0] a_34614_13502# VSS nfet_03v3 ad=0.3p pd=2.2u as=0.3p ps=2.2u w=0.5u l=0.64u
X1449 a_16310_110912# w[27] a_19914_110862# VSS nfet_03v3 ad=0.14p pd=1.06u as=0.14p ps=1.06u w=0.5u l=0.64u
X1450 a_19914_31978# DAC_7__Vb VSS VSS nfet_03v3 ad=0.6p pd=3.2u as=0.6p ps=3.2u w=1u l=8u
X1458 a_16310_50504# w[10] a_22014_50454# VSS nfet_03v3 ad=0.14p pd=1.06u as=0.3p ps=2.2u w=0.5u l=0.64u
X1461 VDD DPI_4__Vthr DPI_4__Vthr VDD pfet_03v3 ad=1.12p pd=4.56u as=1.12p ps=4.56u w=4u l=5.12u
X1463 a_62528_113478# a_62528_113478# DAC_1__Isum_e DAC_1__Isum_e nfet_03v3 ad=2.4p pd=9.2u as=2.4p ps=9.2u w=4u l=5.12u
X1474 a_93348_57760# a_90162_51444# spike[2] VDD pfet_03v3 ad=0.3p pd=2.2u as=0.3p ps=2.2u w=0.5u l=0.64u
X1475 a_19914_125050# w[31] a_16310_125100# VSS nfet_03v3 ad=0.14p pd=1.06u as=0.14p ps=1.06u w=0.5u l=0.64u
X1478 a_16310_50504# w[11] a_19914_50454# VSS nfet_03v3 ad=0.14p pd=1.06u as=0.14p ps=1.06u w=0.5u l=0.64u
X1480 DPI_4__Vthr DPI_4__Vthr VDD VDD pfet_03v3 ad=1.12p pd=4.56u as=1.12p ps=4.56u w=4u l=5.12u
X1486 a_17058_110704# s[6] VSS VSS nfet_03v3 ad=0.3p pd=2.2u as=0.3p ps=2.2u w=0.5u l=0.64u
X1487 a_22014_80658# w[18] a_16310_80708# VSS nfet_03v3 ad=0.14p pd=1.06u as=0.14p ps=1.06u w=0.5u l=0.64u
X1489 VDD a_62528_113478# VMEM_4 VDD pfet_03v3 ad=2.4p pd=9.2u as=2.4p ps=9.2u w=4u l=5.12u
X1490 VMEM_3 a_62978_89578# VSS VSS nfet_03v3 ad=1.44p pd=6u as=1.44p ps=6u w=2.4u l=8u
X1496 a_19914_94846# DAC_7__Vb VSS VSS nfet_03v3 ad=0.6p pd=3.2u as=0.6p ps=3.2u w=1u l=8u
X1498 a_89534_111502# VT a_87734_111852# VSS nfet_03v3 ad=2.4p pd=9.2u as=2.4p ps=9.2u w=4u l=2u
X1504 a_22014_110862# DAC_7__Vb VSS VSS nfet_03v3 ad=0.6p pd=3.2u as=0.6p ps=3.2u w=1u l=8u
X1514 a_19914_31978# w[7] a_16310_32028# VSS nfet_03v3 ad=0.14p pd=1.06u as=0.14p ps=1.06u w=0.5u l=0.64u
X1515 VDD a_4687_155494# neuron_4__VK VDD pfet_03v3 ad=6.27p pd=22.1u as=6.27p ps=22.1u w=10.45u l=8u
X1517 a_22014_64642# w[14] a_16310_64692# VSS nfet_03v3 ad=0.14p pd=1.06u as=0.14p ps=1.06u w=0.5u l=0.64u
X1518 a_22014_125050# w[30] a_16310_125100# VSS nfet_03v3 ad=0.3p pd=2.2u as=0.14p ps=1.06u w=0.5u l=0.64u
X1520 a_90542_32968# neuron_4__VKdn VSS VSS nfet_03v3 ad=0.6p pd=3.2u as=0.6p ps=3.2u w=1u l=1u
X1549 a_19914_13502# DAC_7__Vb VSS VSS nfet_03v3 ad=0.6p pd=3.2u as=0.6p ps=3.2u w=1u l=8u
X1554 a_16310_50504# w[8] a_34614_50454# VSS nfet_03v3 ad=0.3p pd=2.2u as=0.3p ps=2.2u w=0.5u l=0.64u
X1556 spike[1] a_90162_32968# a_90542_32968# VSS nfet_03v3 ad=0.3p pd=2.2u as=0.3p ps=2.2u w=0.5u l=0.64u
X1564 a_19914_125050# DAC_7__Vb VSS VSS nfet_03v3 ad=0.6p pd=3.2u as=0.6p ps=3.2u w=1u l=8u
X1566 a_26214_94846# DAC_7__Vb VSS VSS nfet_03v3 ad=0.6p pd=3.2u as=0.6p ps=3.2u w=1u l=8u
X1567 a_62978_89578# a_62978_89578# VSS VSS nfet_03v3 ad=1.2p pd=5.2u as=1.2p ps=5.2u w=2u l=8u
X1569 a_19914_50454# DAC_7__Vb VSS VSS nfet_03v3 ad=0.6p pd=3.2u as=0.6p ps=3.2u w=1u l=8u
X1571 a_88272_57760# VMEM_2 a_87734_51444# VSS nfet_03v3 ad=2.4p pd=9.2u as=2.4p ps=9.2u w=4u l=2u
X1578 neuron_4__VKup Iref VSS VSS nfet_03v3 ad=3.606p pd=13.22u as=3.606p ps=13.22u w=6.01u l=8u
X1594 a_22014_80658# w[18] a_16310_80708# VSS nfet_03v3 ad=0.3p pd=2.2u as=0.14p ps=1.06u w=0.5u l=0.64u
X1598 VMEM_0 neuron_4__Vlk VSS VSS nfet_03v3 ad=0.6p pd=3.2u as=0.6p ps=3.2u w=1u l=1u
X1599 VDD DPI_4__Vthr DAC_6__Isum_e DAC_6__Isum_e nfet_03v3 ad=2.4p pd=9.2u as=2.4p ps=9.2u w=4u l=5.12u
X1603 DPI_4__VT DPI_4__VT VDD VDD pfet_03v3 ad=1.12p pd=4.56u as=1.12p ps=4.56u w=4u l=5.12u
X1610 a_19914_13502# w[3] a_16310_13552# VSS nfet_03v3 ad=0.14p pd=1.06u as=0.14p ps=1.06u w=0.5u l=0.64u
X1621 a_19914_80658# w[19] a_16310_80708# VSS nfet_03v3 ad=0.14p pd=1.06u as=0.14p ps=1.06u w=0.5u l=0.64u
X1624 a_91170_111852# neuron_4__VK VSS VSS nfet_03v3 ad=0.6p pd=3.2u as=0.6p ps=3.2u w=1u l=1u
X1627 a_22014_13502# DAC_7__Vb VSS VSS nfet_03v3 ad=0.6p pd=3.2u as=0.6p ps=3.2u w=1u l=8u
X1633 a_22014_64642# w[14] a_16310_64692# VSS nfet_03v3 ad=0.3p pd=2.2u as=0.14p ps=1.06u w=0.5u l=0.64u
X1637 a_26214_50454# DAC_7__Vb VSS VSS nfet_03v3 ad=0.6p pd=3.2u as=0.6p ps=3.2u w=1u l=8u
X1652 a_22014_80658# DAC_7__Vb VSS VSS nfet_03v3 ad=0.6p pd=3.2u as=0.6p ps=3.2u w=1u l=8u
X1653 VDD DPI_4__VT DPI_4__VT VDD pfet_03v3 ad=1.12p pd=4.56u as=1.12p ps=4.56u w=4u l=5.12u
X1656 a_19914_64642# w[15] a_16310_64692# VSS nfet_03v3 ad=0.14p pd=1.06u as=0.14p ps=1.06u w=0.5u l=0.64u
X1675 a_4687_155494# Iref VSS VSS nfet_03v3 ad=6p pd=21.2u as=6p ps=21.2u w=10u l=8u
X1676 VSS neuron_4__VKdn neuron_4__VKdn VSS nfet_03v3 ad=0.6p pd=3.2u as=0.28p ps=1.56u w=1u l=1u
X1678 a_91170_51444# neuron_4__VK VSS VSS nfet_03v3 ad=0.6p pd=3.2u as=0.6p ps=3.2u w=1u l=1u
X1681 a_16310_110912# w[27] a_19914_110862# VSS nfet_03v3 ad=0.14p pd=1.06u as=0.14p ps=1.06u w=0.5u l=0.64u
X1694 VDD DPI_4__Vthr DPI_4__Vthr VDD pfet_03v3 ad=1.12p pd=4.56u as=1.12p ps=4.56u w=4u l=5.12u
X1699 VDD DPI_4__Vthr DPI_4__Vthr VDD pfet_03v3 ad=1.12p pd=4.56u as=1.12p ps=4.56u w=4u l=5.12u
X1700 a_19914_50454# DAC_7__Vb VSS VSS nfet_03v3 ad=0.6p pd=3.2u as=0.6p ps=3.2u w=1u l=8u
X1706 VDD a_62528_16118# VMEM_0 VDD pfet_03v3 ad=2.4p pd=9.2u as=2.4p ps=9.2u w=4u l=5.12u
X1719 VDD DPI_4__VT DPI_4__VT VDD pfet_03v3 ad=1.12p pd=4.56u as=1.12p ps=4.56u w=4u l=5.12u
X1731 a_19914_80658# w[19] a_16310_80708# VSS nfet_03v3 ad=0.3p pd=2.2u as=0.14p ps=1.06u w=0.5u l=0.64u
X1733 a_19914_50454# w[11] a_16310_50504# VSS nfet_03v3 ad=0.14p pd=1.06u as=0.14p ps=1.06u w=0.5u l=0.64u
X1734 a_19914_64642# DAC_7__Vb VSS VSS nfet_03v3 ad=0.6p pd=3.2u as=0.6p ps=3.2u w=1u l=8u
X1750 VSS neuron_4__Vlk neuron_4__Vlk VSS nfet_03v3 ad=0.28p pd=1.56u as=0.28p ps=1.56u w=1u l=1u
X1764 a_87734_14492# neuron_4__Vamp_bias VSS VSS nfet_03v3 ad=0.3p pd=2.2u as=0.3p ps=2.2u w=0.5u l=0.64u
X1767 a_19914_64642# w[15] a_16310_64692# VSS nfet_03v3 ad=0.3p pd=2.2u as=0.14p ps=1.06u w=0.5u l=0.64u
X1772 VDD DPI_4__Vthr DPI_4__Vthr VDD pfet_03v3 ad=1.12p pd=4.56u as=1.12p ps=4.56u w=4u l=5.12u
X1773 a_89914_81648# neuron_4__VIp VSS VSS nfet_03v3 ad=0.6p pd=3.2u as=0.6p ps=3.2u w=1u l=1u
X1779 a_16310_125100# w[31] a_19914_125050# VSS nfet_03v3 ad=0.14p pd=1.06u as=0.14p ps=1.06u w=0.5u l=0.64u
X1783 a_26214_110862# w[25] a_16310_110912# VSS nfet_03v3 ad=0.3p pd=2.2u as=0.14p ps=1.06u w=0.5u l=0.64u
X1794 a_26214_64642# DAC_7__Vb VSS VSS nfet_03v3 ad=0.6p pd=3.2u as=0.6p ps=3.2u w=1u l=8u
X1799 a_16310_32028# w[5] a_26214_31978# VSS nfet_03v3 ad=0.14p pd=1.06u as=0.3p ps=2.2u w=0.5u l=0.64u
X1800 a_67078_65198# a_67078_65198# DAC_5__Isum_i DAC_5__Isum_i nfet_03v3 ad=2.4p pd=9.2u as=2.4p ps=9.2u w=4u l=5.12u
X1807 a_34614_80658# DAC_7__Vb VSS VSS nfet_03v3 ad=0.6p pd=3.2u as=0.6p ps=3.2u w=1u l=8u
X1812 a_89534_51094# VT a_87734_51444# VSS nfet_03v3 ad=2.4p pd=9.2u as=2.4p ps=9.2u w=4u l=2u
X1815 VDD a_67078_125606# a_62978_119782# VDD pfet_03v3 ad=2.4p pd=9.2u as=2.4p ps=9.2u w=4u l=5.12u
X1818 a_22014_94846# DAC_7__Vb VSS VSS nfet_03v3 ad=0.6p pd=3.2u as=0.6p ps=3.2u w=1u l=8u
X1832 a_17058_124892# s[7] VSS VSS nfet_03v3 ad=0.3p pd=2.2u as=0.3p ps=2.2u w=0.5u l=0.64u
X1839 VDD DPI_4__Vthr DPI_4__Vthr VDD pfet_03v3 ad=1.12p pd=4.56u as=1.12p ps=4.56u w=4u l=5.12u
X1840 a_19914_31978# DAC_7__Vb VSS VSS nfet_03v3 ad=0.6p pd=3.2u as=0.6p ps=3.2u w=1u l=8u
X1841 a_22014_125050# DAC_7__Vb VSS VSS nfet_03v3 ad=0.6p pd=3.2u as=0.6p ps=3.2u w=1u l=8u
X1842 a_16310_110912# w[24] a_34614_110862# VSS nfet_03v3 ad=0.3p pd=2.2u as=0.3p ps=2.2u w=0.5u l=0.64u
X1844 VDD bias_0__VT_inh bias_0__VT_inh VDD pfet_03v3 ad=0.2464p pd=1.44u as=0.2464p ps=1.44u w=0.88u l=1.12u
X1845 a_34614_110862# DAC_7__Vb VSS VSS nfet_03v3 ad=0.6p pd=3.2u as=0.6p ps=3.2u w=1u l=8u
X1877 a_19914_64642# DAC_7__Vb VSS VSS nfet_03v3 ad=0.6p pd=3.2u as=0.6p ps=3.2u w=1u l=8u
X1887 VDD s[4] a_17058_80500# VDD pfet_03v3 ad=0.3p pd=2.2u as=0.3p ps=2.2u w=0.5u l=0.32u
X1889 a_87734_51444# neuron_4__Vamp_bias VSS VSS nfet_03v3 ad=0.3p pd=2.2u as=0.3p ps=2.2u w=0.5u l=0.64u
X1899 VDD a_67078_65198# a_62978_59374# VDD pfet_03v3 ad=2.4p pd=9.2u as=2.4p ps=9.2u w=4u l=5.12u
X1903 a_19914_13502# w[3] a_16310_13552# VSS nfet_03v3 ad=0.14p pd=1.06u as=0.14p ps=1.06u w=0.5u l=0.64u
X1910 VDD DPI_4__Vthr DPI_4__Vthr VDD pfet_03v3 ad=1.12p pd=4.56u as=1.12p ps=4.56u w=4u l=5.12u
X1928 a_22014_31978# DAC_7__Vb VSS VSS nfet_03v3 ad=0.6p pd=3.2u as=0.6p ps=3.2u w=1u l=8u
X1956 bias_0__VT_inh bias_0__VT_inh VDD VDD pfet_03v3 ad=0.2464p pd=1.44u as=0.2464p ps=1.44u w=0.88u l=1.12u
X1958 a_19914_13502# DAC_7__Vb VSS VSS nfet_03v3 ad=0.6p pd=3.2u as=0.6p ps=3.2u w=1u l=8u
X1972 a_34614_94846# DAC_7__Vb VSS VSS nfet_03v3 ad=0.6p pd=3.2u as=0.6p ps=3.2u w=1u l=8u
X1987 VDD s[5] a_17058_94688# VDD pfet_03v3 ad=0.3p pd=2.2u as=0.3p ps=2.2u w=0.5u l=0.32u
X1992_0 neuron_4__VK neuron_4__VK X1992_s1 VSS nfet_03v3 ad=0.3p pd=2.2u as=0.3p ps=2.2u w=0.5u l=45.4550u
X1992_1 X1992_s1 neuron_4__VK VSS VSS nfet_03v3 ad=0.3p pd=2.2u as=0.3p ps=2.2u w=0.5u l=45.4550u
X2004 DPI_4__Vthr DPI_4__Vthr VDD VDD pfet_03v3 ad=1.12p pd=4.56u as=1.12p ps=4.56u w=4u l=5.12u
X2007 VDD a_88272_39284# a_88272_39284# VDD pfet_03v3 ad=0.3p pd=2.2u as=0.3p ps=2.2u w=0.5u l=8u
X2012 a_19914_50454# w[11] a_16310_50504# VSS nfet_03v3 ad=0.14p pd=1.06u as=0.14p ps=1.06u w=0.5u l=0.64u
X2020 a_22014_13502# DAC_7__Vb VSS VSS nfet_03v3 ad=0.6p pd=3.2u as=0.6p ps=3.2u w=1u l=8u
X2023 a_16310_125100# w[31] a_19914_125050# VSS nfet_03v3 ad=0.14p pd=1.06u as=0.14p ps=1.06u w=0.5u l=0.64u
X2027 a_19914_110862# DAC_7__Vb VSS VSS nfet_03v3 ad=0.6p pd=3.2u as=0.6p ps=3.2u w=1u l=8u
X2037 VDD DPI_4__VT a_62528_53070# VDD pfet_03v3 ad=2.4p pd=9.2u as=2.4p ps=9.2u w=4u l=5.12u
X2053 a_90162_81648# a_89534_81298# a_89914_81648# VSS nfet_03v3 ad=0.3p pd=2.2u as=0.3p ps=2.2u w=0.5u l=0.64u
X2056 DPI_4__Vthr DPI_4__Vthr VDD VDD pfet_03v3 ad=1.12p pd=4.56u as=1.12p ps=4.56u w=4u l=5.12u
X2065 a_90542_14492# neuron_4__VKdn VSS VSS nfet_03v3 ad=0.6p pd=3.2u as=0.6p ps=3.2u w=1u l=1u
X2077 VDD DPI_4__Vthr DAC_5__Isum_e DAC_5__Isum_e nfet_03v3 ad=2.4p pd=9.2u as=2.4p ps=9.2u w=4u l=5.12u
X2080 VDD neuron_4__VNA a_93976_39284# VDD pfet_03v3 ad=0.6p pd=3.2u as=0.6p ps=3.2u w=1u l=1u
X2093 spike[0] a_90162_14492# a_90542_14492# VSS nfet_03v3 ad=0.3p pd=2.2u as=0.3p ps=2.2u w=0.5u l=0.64u
X2095 a_19914_50454# DAC_7__Vb VSS VSS nfet_03v3 ad=0.6p pd=3.2u as=0.6p ps=3.2u w=1u l=8u
X2096 DPI_4__VT Iref VSS VSS nfet_03v3 ad=0.702p pd=3.54u as=0.702p ps=3.54u w=1.17u l=32u
X2108 a_26214_125050# w[29] a_16310_125100# VSS nfet_03v3 ad=0.3p pd=2.2u as=0.14p ps=1.06u w=0.5u l=0.64u
X2113 a_19914_80658# DAC_7__Vb VSS VSS nfet_03v3 ad=0.6p pd=3.2u as=0.6p ps=3.2u w=1u l=8u
X2115 DPI_4__Vthr DPI_4__Vthr VDD VDD pfet_03v3 ad=1.12p pd=4.56u as=1.12p ps=4.56u w=4u l=5.12u
X2116 a_16310_80708# w[18] a_22014_80658# VSS nfet_03v3 ad=0.14p pd=1.06u as=0.14p ps=1.06u w=0.5u l=0.64u
X2117 spike[3] VSS cap_mim_2f0_m4m5_noshield c_width=10u c_length=10u
X2126 VDD DPI_4__VT a_67078_65198# VDD pfet_03v3 ad=2.4p pd=9.2u as=2.4p ps=9.2u w=4u l=5.12u
X2127 a_16558_80708# spike[0] a_16310_80708# VSS nfet_03v3 ad=0.3p pd=2.2u as=0.3p ps=2.2u w=0.5u l=0.64u
X2130 bias_0__VT_inh bias_0__VT_inh VDD VDD pfet_03v3 ad=0.2464p pd=1.44u as=0.2464p ps=1.44u w=0.88u l=1.12u
X2138 a_16310_80708# w[19] a_19914_80658# VSS nfet_03v3 ad=0.14p pd=1.06u as=0.14p ps=1.06u w=0.5u l=0.64u
X2146 a_16310_64692# w[14] a_22014_64642# VSS nfet_03v3 ad=0.14p pd=1.06u as=0.14p ps=1.06u w=0.5u l=0.64u
X2151 a_16310_13552# w[1] a_26214_13502# VSS nfet_03v3 ad=0.14p pd=1.06u as=0.3p ps=2.2u w=0.5u l=0.64u
X2154 a_16310_125100# w[28] a_34614_125050# VSS nfet_03v3 ad=0.3p pd=2.2u as=0.3p ps=2.2u w=0.5u l=0.64u
X2155 a_34614_125050# DAC_7__Vb VSS VSS nfet_03v3 ad=0.6p pd=3.2u as=0.6p ps=3.2u w=1u l=8u
X2157 a_16558_64692# spike[1] a_16310_64692# VSS nfet_03v3 ad=0.3p pd=2.2u as=0.3p ps=2.2u w=0.5u l=0.64u
X2163 a_16310_64692# w[15] a_19914_64642# VSS nfet_03v3 ad=0.14p pd=1.06u as=0.14p ps=1.06u w=0.5u l=0.64u
X2185 VDD DPI_4__Vthr DPI_4__Vthr VDD pfet_03v3 ad=1.12p pd=4.56u as=1.12p ps=4.56u w=4u l=5.12u
X2198 spike[2] a_90162_51444# a_90542_51444# VSS nfet_03v3 ad=0.3p pd=2.2u as=0.3p ps=2.2u w=0.5u l=0.64u
X2201 VSS neuron_4__Vlk neuron_4__Vlk VSS nfet_03v3 ad=0.28p pd=1.56u as=0.28p ps=1.56u w=1u l=1u
X2213 a_19914_31978# DAC_7__Vb VSS VSS nfet_03v3 ad=0.6p pd=3.2u as=0.6p ps=3.2u w=1u l=8u
X2228 a_16310_80708# w[19] a_19914_80658# VSS nfet_03v3 ad=0.14p pd=1.06u as=0.14p ps=1.06u w=0.5u l=0.64u
X2234 a_19914_64642# DAC_7__Vb VSS VSS nfet_03v3 ad=0.6p pd=3.2u as=0.6p ps=3.2u w=1u l=8u
X2236 VDD DPI_4__Vthr DPI_4__Vthr VDD pfet_03v3 ad=1.12p pd=4.56u as=1.12p ps=4.56u w=4u l=5.12u
X2243 a_19914_94846# DAC_7__Vb VSS VSS nfet_03v3 ad=0.6p pd=3.2u as=0.6p ps=3.2u w=1u l=8u
X2245 a_16310_50504# w[9] a_26214_50454# VSS nfet_03v3 ad=0.14p pd=1.06u as=0.3p ps=2.2u w=0.5u l=0.64u
X2248 VMEM_1 spike[1] a_91170_32968# VSS nfet_03v3 ad=0.3p pd=2.2u as=0.3p ps=2.2u w=0.5u l=11.36u
X2252 a_16310_64692# w[15] a_19914_64642# VSS nfet_03v3 ad=0.14p pd=1.06u as=0.14p ps=1.06u w=0.5u l=0.64u
X2255 DAC_6__Isum_e a_17058_31820# a_16558_32028# VSS nfet_03v3 ad=0.3p pd=2.2u as=0.3p ps=2.2u w=0.5u l=0.64u
X2259 a_26214_110862# DAC_7__Vb VSS VSS nfet_03v3 ad=0.6p pd=3.2u as=0.6p ps=3.2u w=1u l=8u
X2263 VDD a_62528_34594# cap_mim_2f0_m4m5_noshield c_width=22.18u c_length=22.18u
X2264 a_22014_31978# DAC_7__Vb VSS VSS nfet_03v3 ad=0.6p pd=3.2u as=0.6p ps=3.2u w=1u l=8u
X2274 a_17058_31820# s[1] VSS VSS nfet_03v3 ad=0.3p pd=2.2u as=0.3p ps=2.2u w=0.5u l=0.64u
X2280 a_16310_80708# w[19] a_19914_80658# VSS nfet_03v3 ad=0.14p pd=1.06u as=0.3p ps=2.2u w=0.5u l=0.64u
X2304 a_19914_125050# DAC_7__Vb VSS VSS nfet_03v3 ad=0.6p pd=3.2u as=0.6p ps=3.2u w=1u l=8u
X2305 VDD a_88272_20808# a_88272_20808# VDD pfet_03v3 ad=0.3p pd=2.2u as=0.3p ps=2.2u w=0.5u l=8u
X2306 spike[2] VSS cap_mim_2f0_m4m5_noshield c_width=10u c_length=10u
X2309 a_16310_64692# w[15] a_19914_64642# VSS nfet_03v3 ad=0.14p pd=1.06u as=0.3p ps=2.2u w=0.5u l=0.64u
X2321 a_19914_110862# DAC_7__Vb VSS VSS nfet_03v3 ad=0.6p pd=3.2u as=0.6p ps=3.2u w=1u l=8u
X2326 VDD a_4687_155494# neuron_4__VKdn VDD pfet_03v3 ad=7.764p pd=27.08u as=7.764p ps=27.08u w=12.94u l=8u
X2343 DAC_3__Isum_i s[5] a_16558_94896# VSS nfet_03v3 ad=0.3p pd=2.2u as=0.3p ps=2.2u w=0.5u l=0.64u
X2358 VDD a_4687_155494# neuron_4__Vlk VDD pfet_03v3 ad=0.504p pd=2.88u as=0.504p ps=2.88u w=0.84u l=16u
X2362 a_16310_80708# w[18] a_22014_80658# VSS nfet_03v3 ad=0.14p pd=1.06u as=0.3p ps=2.2u w=0.5u l=0.64u
X2364 VDD a_89534_111502# a_90162_111852# VDD pfet_03v3 ad=0.3p pd=2.2u as=0.3p ps=2.2u w=0.5u l=0.64u
X2368 a_22014_13502# DAC_7__Vb VSS VSS nfet_03v3 ad=0.6p pd=3.2u as=0.6p ps=3.2u w=1u l=8u
X2369 VDD a_67078_65198# cap_mim_2f0_m4m5_noshield c_width=22.18u c_length=22.18u
X2376 a_93348_87964# a_90162_81648# spike[3] VDD pfet_03v3 ad=0.3p pd=2.2u as=0.3p ps=2.2u w=0.5u l=0.64u
X2388 a_16310_80708# w[19] a_19914_80658# VSS nfet_03v3 ad=0.14p pd=1.06u as=0.14p ps=1.06u w=0.5u l=0.64u
X2389 a_26214_31978# w[5] a_16310_32028# VSS nfet_03v3 ad=0.3p pd=2.2u as=0.14p ps=1.06u w=0.5u l=0.64u
X2393 a_16310_64692# w[14] a_22014_64642# VSS nfet_03v3 ad=0.14p pd=1.06u as=0.3p ps=2.2u w=0.5u l=0.64u
X2415 a_16310_64692# w[15] a_19914_64642# VSS nfet_03v3 ad=0.14p pd=1.06u as=0.14p ps=1.06u w=0.5u l=0.64u
X2424 a_22014_94846# w[22] a_16310_94896# VSS nfet_03v3 ad=0.14p pd=1.06u as=0.14p ps=1.06u w=0.5u l=0.64u
X2432 VDD DPI_4__Vthr DAC_1__Isum_e DAC_1__Isum_e nfet_03v3 ad=2.4p pd=9.2u as=2.4p ps=9.2u w=4u l=5.12u
X2435 a_19914_110862# DAC_7__Vb VSS VSS nfet_03v3 ad=0.6p pd=3.2u as=0.6p ps=3.2u w=1u l=8u
X2436 a_19914_13502# DAC_7__Vb VSS VSS nfet_03v3 ad=0.6p pd=3.2u as=0.6p ps=3.2u w=1u l=8u
X2437 VDD a_88272_57760# a_88272_57760# VDD pfet_03v3 ad=0.3p pd=2.2u as=0.3p ps=2.2u w=0.5u l=8u
X2441 VSS neuron_4__Vlk neuron_4__Vlk VSS nfet_03v3 ad=0.6p pd=3.2u as=0.28p ps=1.56u w=1u l=1u
X2443 a_19914_50454# DAC_7__Vb VSS VSS nfet_03v3 ad=0.6p pd=3.2u as=0.6p ps=3.2u w=1u l=8u
X2457 VDD DPI_4__VT a_62528_113478# VDD pfet_03v3 ad=2.4p pd=9.2u as=2.4p ps=9.2u w=4u l=5.12u
X2458 a_16310_80708# w[16] a_34614_80658# VSS nfet_03v3 ad=0.3p pd=2.2u as=0.3p ps=2.2u w=0.5u l=0.64u
X2469 a_19914_80658# DAC_7__Vb VSS VSS nfet_03v3 ad=0.6p pd=3.2u as=0.6p ps=3.2u w=1u l=8u
X2472 a_88272_87964# VMEM_3 a_87734_81648# VSS nfet_03v3 ad=2.4p pd=9.2u as=2.4p ps=9.2u w=4u l=2u
X2482 VDD DPI_4__Vthr DPI_4__Vthr VDD pfet_03v3 ad=2.4p pd=9.2u as=1.12p ps=4.56u w=4u l=5.12u
X2491 VDD a_89534_32618# a_90162_32968# VDD pfet_03v3 ad=0.3p pd=2.2u as=0.3p ps=2.2u w=0.5u l=0.64u
X2498 VDD DPI_4__Vthr DPI_4__Vthr VDD pfet_03v3 ad=1.12p pd=4.56u as=1.12p ps=4.56u w=4u l=5.12u
X2499 bias_0__VT_inh bias_0__VT_inh VDD VDD pfet_03v3 ad=0.2464p pd=1.44u as=0.528p ps=2.96u w=0.88u l=1.12u
X2503 VMEM_2 neuron_4__Vlk VSS VSS nfet_03v3 ad=0.6p pd=3.2u as=0.6p ps=3.2u w=1u l=1u
X2506 a_16310_64692# w[12] a_34614_64642# VSS nfet_03v3 ad=0.3p pd=2.2u as=0.3p ps=2.2u w=0.5u l=0.64u
X2515 a_22014_110862# DAC_7__Vb VSS VSS nfet_03v3 ad=0.6p pd=3.2u as=0.6p ps=3.2u w=1u l=8u
X2516 VMEM_4 neuron_4__Vlk VSS VSS nfet_03v3 ad=0.6p pd=3.2u as=0.6p ps=3.2u w=1u l=1u
X2518 DPI_4__Vthr DPI_4__Vthr VDD VDD pfet_03v3 ad=1.12p pd=4.56u as=1.12p ps=4.56u w=4u l=5.12u
X2530 a_22014_50454# DAC_7__Vb VSS VSS nfet_03v3 ad=0.6p pd=3.2u as=0.6p ps=3.2u w=1u l=8u
X2532 VDD neuron_4__VNA a_93976_57760# VDD pfet_03v3 ad=0.6p pd=3.2u as=0.6p ps=3.2u w=1u l=1u
X2542 a_22014_94846# w[22] a_16310_94896# VSS nfet_03v3 ad=0.3p pd=2.2u as=0.14p ps=1.06u w=0.5u l=0.64u
X2545 a_26214_80658# DAC_7__Vb VSS VSS nfet_03v3 ad=0.6p pd=3.2u as=0.6p ps=3.2u w=1u l=8u
X2557 a_16310_110912# w[26] a_22014_110862# VSS nfet_03v3 ad=0.14p pd=1.06u as=0.14p ps=1.06u w=0.5u l=0.64u
X2560 VDD DPI_4__Vthr DPI_4__Vthr VDD pfet_03v3 ad=1.12p pd=4.56u as=1.12p ps=4.56u w=4u l=5.12u
X2561 a_19914_94846# w[23] a_16310_94896# VSS nfet_03v3 ad=0.14p pd=1.06u as=0.14p ps=1.06u w=0.5u l=0.64u
X2564 VDD DPI_4__VT DPI_4__VT VDD pfet_03v3 ad=1.12p pd=4.56u as=1.12p ps=4.56u w=4u l=5.12u
X2570 neuron_4__VIp neuron_4__VIp VSS VSS nfet_03v3 ad=0.6p pd=3.2u as=0.6p ps=3.2u w=1u l=1u
X2587 a_91170_81648# neuron_4__VK VSS VSS nfet_03v3 ad=0.6p pd=3.2u as=0.6p ps=3.2u w=1u l=1u
X2590 a_26214_125050# DAC_7__Vb VSS VSS nfet_03v3 ad=0.6p pd=3.2u as=0.6p ps=3.2u w=1u l=8u
X2592 bias_0__VT_inh bias_0__VT_inh VDD VDD pfet_03v3 ad=0.2464p pd=1.44u as=0.2464p ps=1.44u w=0.88u l=1.12u
X2605 VDD neuron_4__VKup neuron_4__VKup VDD pfet_03v3 ad=0.6p pd=3.2u as=0.6p ps=3.2u w=1u l=8u
X2607 a_19914_64642# DAC_7__Vb VSS VSS nfet_03v3 ad=0.6p pd=3.2u as=0.6p ps=3.2u w=1u l=8u
X2609 a_19914_80658# DAC_7__Vb VSS VSS nfet_03v3 ad=0.6p pd=3.2u as=0.6p ps=3.2u w=1u l=8u
X2613 DAC_7__Isum_e a_17058_13344# a_16558_13552# VSS nfet_03v3 ad=0.3p pd=2.2u as=0.3p ps=2.2u w=0.5u l=0.64u
X2625 a_19914_94846# DAC_7__Vb VSS VSS nfet_03v3 ad=0.6p pd=3.2u as=0.6p ps=3.2u w=1u l=8u
X2626 a_19914_80658# w[19] a_16310_80708# VSS nfet_03v3 ad=0.14p pd=1.06u as=0.14p ps=1.06u w=0.5u l=0.64u
X2635 a_17058_13344# s[0] VSS VSS nfet_03v3 ad=0.3p pd=2.2u as=0.3p ps=2.2u w=0.5u l=0.64u
X2638 VMEM_0 VSS cap_mim_2f0_m4m5_noshield c_width=22.18u c_length=22.18u
X2654 VSS neuron_4__Vlk neuron_4__Vlk VSS nfet_03v3 ad=0.28p pd=1.56u as=0.28p ps=1.56u w=1u l=1u
X2655 a_19914_125050# DAC_7__Vb VSS VSS nfet_03v3 ad=0.6p pd=3.2u as=0.6p ps=3.2u w=1u l=8u
X2656 a_22014_31978# DAC_7__Vb VSS VSS nfet_03v3 ad=0.6p pd=3.2u as=0.6p ps=3.2u w=1u l=8u
X2667 a_19914_94846# w[23] a_16310_94896# VSS nfet_03v3 ad=0.3p pd=2.2u as=0.14p ps=1.06u w=0.5u l=0.64u
X2671 a_19914_64642# w[15] a_16310_64692# VSS nfet_03v3 ad=0.14p pd=1.06u as=0.14p ps=1.06u w=0.5u l=0.64u
X2676 VDD s[3] a_17058_64484# VDD pfet_03v3 ad=0.3p pd=2.2u as=0.3p ps=2.2u w=0.5u l=0.32u
X2685 a_22014_64642# DAC_7__Vb VSS VSS nfet_03v3 ad=0.6p pd=3.2u as=0.6p ps=3.2u w=1u l=8u
X2692 a_90162_111852# a_89534_111502# a_89914_111852# VSS nfet_03v3 ad=0.3p pd=2.2u as=0.3p ps=2.2u w=0.5u l=0.64u
X2694 a_26214_94846# DAC_7__Vb VSS VSS nfet_03v3 ad=0.6p pd=3.2u as=0.6p ps=3.2u w=1u l=8u
X2699 a_67078_95402# a_67078_95402# DAC_3__Isum_i DAC_3__Isum_i nfet_03v3 ad=2.4p pd=9.2u as=2.4p ps=9.2u w=4u l=5.12u
X2702 VDD DPI_4__VT DPI_4__VT VDD pfet_03v3 ad=1.12p pd=4.56u as=1.12p ps=4.56u w=4u l=5.12u
X2705 a_89534_81298# VT a_87734_81648# VSS nfet_03v3 ad=2.4p pd=9.2u as=2.4p ps=9.2u w=4u l=2u
X2711 DPI_4__VT DPI_4__VT VDD VDD pfet_03v3 ad=1.12p pd=4.56u as=1.12p ps=4.56u w=4u l=5.12u
X2715 a_19914_31978# DAC_7__Vb VSS VSS nfet_03v3 ad=0.6p pd=3.2u as=0.6p ps=3.2u w=1u l=8u
X2721 a_89914_32968# neuron_4__VIp VSS VSS nfet_03v3 ad=0.6p pd=3.2u as=0.6p ps=3.2u w=1u l=1u
X2724 DAC_5__Isum_e a_17058_50296# a_16558_50504# VSS nfet_03v3 ad=0.3p pd=2.2u as=0.3p ps=2.2u w=0.5u l=0.64u
X2730 a_16558_110912# spike[2] a_16310_110912# VSS nfet_03v3 ad=0.3p pd=2.2u as=0.3p ps=2.2u w=0.5u l=0.64u
X2733 neuron_4__Vlk neuron_4__Vlk VSS VSS nfet_03v3 ad=0.28p pd=1.56u as=0.6p ps=3.2u w=1u l=1u
X2736 VDD a_4687_155494# a_4687_155494# VDD pfet_03v3 ad=6p pd=21.2u as=6p ps=21.2u w=10u l=8u
X2739 a_17058_50296# s[2] VSS VSS nfet_03v3 ad=0.3p pd=2.2u as=0.3p ps=2.2u w=0.5u l=0.64u
X2741 a_26214_13502# w[1] a_16310_13552# VSS nfet_03v3 ad=0.3p pd=2.2u as=0.14p ps=1.06u w=0.5u l=0.64u
X2748 VDD bias_0__VT_inh bias_0__VT_inh VDD pfet_03v3 ad=0.2464p pd=1.44u as=0.2464p ps=1.44u w=0.88u l=1.12u
X2749 a_19914_125050# DAC_7__Vb VSS VSS nfet_03v3 ad=0.6p pd=3.2u as=0.6p ps=3.2u w=1u l=8u
X2751 a_19914_94846# DAC_7__Vb VSS VSS nfet_03v3 ad=0.6p pd=3.2u as=0.6p ps=3.2u w=1u l=8u
X2755 DPI_4__Vthr DPI_4__Vthr VDD VDD pfet_03v3 ad=1.12p pd=4.56u as=1.12p ps=4.56u w=4u l=5.12u
X2764 a_87734_81648# neuron_4__Vamp_bias VSS VSS nfet_03v3 ad=0.3p pd=2.2u as=0.3p ps=2.2u w=0.5u l=0.64u
X2766 VMEM_0 spike[0] a_91170_14492# VSS nfet_03v3 ad=0.3p pd=2.2u as=0.3p ps=2.2u w=0.5u l=11.36u
X2771 a_19914_110862# DAC_7__Vb VSS VSS nfet_03v3 ad=0.6p pd=3.2u as=0.6p ps=3.2u w=1u l=8u
X2774 DPI_4__VT DPI_4__VT VDD VDD pfet_03v3 ad=1.12p pd=4.56u as=1.12p ps=4.56u w=4u l=5.12u
X2782 DPI_4__VT DPI_4__VT VDD VDD pfet_03v3 ad=1.12p pd=4.56u as=1.12p ps=4.56u w=4u l=5.12u
X2804 a_19914_110862# w[27] a_16310_110912# VSS nfet_03v3 ad=0.14p pd=1.06u as=0.14p ps=1.06u w=0.5u l=0.64u
X2815 DAC_7__Vb DAC_7__Vb VSS VSS nfet_03v3 ad=0.6p pd=3.2u as=0.6p ps=3.2u w=1u l=8u
X2820 a_93976_118168# a_90162_111852# VMEM_4 VDD pfet_03v3 ad=0.3p pd=2.2u as=0.3p ps=2.2u w=0.5u l=0.64u
X2827 VMEM_3 VSS cap_mim_2f0_m4m5_noshield c_width=22.18u c_length=22.18u
X2832 a_19914_13502# DAC_7__Vb VSS VSS nfet_03v3 ad=0.6p pd=3.2u as=0.6p ps=3.2u w=1u l=8u
X2835 DPI_4__Vthr DPI_4__Vthr VDD VDD pfet_03v3 ad=1.12p pd=4.56u as=1.12p ps=4.56u w=4u l=5.12u
X2840 a_22014_125050# DAC_7__Vb VSS VSS nfet_03v3 ad=0.6p pd=3.2u as=0.6p ps=3.2u w=1u l=8u
X2842 a_19914_50454# DAC_7__Vb VSS VSS nfet_03v3 ad=0.6p pd=3.2u as=0.6p ps=3.2u w=1u l=8u
X2843 VDD a_89534_14142# a_90162_14492# VDD pfet_03v3 ad=0.3p pd=2.2u as=0.3p ps=2.2u w=0.5u l=0.64u
X2850 DPI_4__VT DPI_4__VT VDD VDD pfet_03v3 ad=1.12p pd=4.56u as=1.12p ps=4.56u w=4u l=5.12u
X2869 a_26214_50454# w[9] a_16310_50504# VSS nfet_03v3 ad=0.3p pd=2.2u as=0.14p ps=1.06u w=0.5u l=0.64u
X2876 VDD s[7] a_17058_124892# VDD pfet_03v3 ad=0.3p pd=2.2u as=0.3p ps=2.2u w=0.5u l=0.32u
X2885 a_16310_125100# w[30] a_22014_125050# VSS nfet_03v3 ad=0.14p pd=1.06u as=0.14p ps=1.06u w=0.5u l=0.64u
X2888 a_16310_110912# w[27] a_19914_110862# VSS nfet_03v3 ad=0.14p pd=1.06u as=0.3p ps=2.2u w=0.5u l=0.64u
X2891 VMEM_2 spike[2] a_91170_51444# VSS nfet_03v3 ad=0.3p pd=2.2u as=0.3p ps=2.2u w=0.5u l=11.36u
X2898 VDD neuron_4__VKup a_93348_39284# VDD pfet_03v3 ad=0.6p pd=3.2u as=0.6p ps=3.2u w=1u l=1u
X2902 a_26214_13502# DAC_7__Vb VSS VSS nfet_03v3 ad=0.6p pd=3.2u as=0.6p ps=3.2u w=1u l=8u
X2906 a_19914_80658# w[19] a_16310_80708# VSS nfet_03v3 ad=0.14p pd=1.06u as=0.14p ps=1.06u w=0.5u l=0.64u
X2907 a_22014_50454# DAC_7__Vb VSS VSS nfet_03v3 ad=0.6p pd=3.2u as=0.6p ps=3.2u w=1u l=8u
X2911 a_93976_39284# a_90162_32968# VMEM_1 VDD pfet_03v3 ad=0.3p pd=2.2u as=0.3p ps=2.2u w=0.5u l=0.64u
X2922 VDD DPI_4__Vthr DAC_7__Isum_e DAC_7__Isum_e nfet_03v3 ad=2.4p pd=9.2u as=2.4p ps=9.2u w=4u l=5.12u
X2930 VDD DPI_4__VT a_62528_83274# VDD pfet_03v3 ad=2.4p pd=9.2u as=2.4p ps=9.2u w=4u l=5.12u
X2939 a_19914_64642# w[15] a_16310_64692# VSS nfet_03v3 ad=0.14p pd=1.06u as=0.14p ps=1.06u w=0.5u l=0.64u
X2945 Iref Iref VSS VSS nfet_03v3 ad=6p pd=21.2u as=6p ps=21.2u w=10u l=8u
X2946 VDD a_88272_39284# a_89534_32618# VDD pfet_03v3 ad=0.3p pd=2.2u as=0.3p ps=2.2u w=0.5u l=8u
X2949 VDD neuron_4__VNA a_93976_118168# VDD pfet_03v3 ad=0.6p pd=3.2u as=0.6p ps=3.2u w=1u l=1u
X2953 spike[4] a_90162_111852# a_90542_111852# VSS nfet_03v3 ad=0.3p pd=2.2u as=0.3p ps=2.2u w=0.5u l=0.64u
X2955 a_90542_51444# neuron_4__VKdn VSS VSS nfet_03v3 ad=0.6p pd=3.2u as=0.6p ps=3.2u w=1u l=1u
X2962 VDD a_62528_34594# VMEM_1 VDD pfet_03v3 ad=2.4p pd=9.2u as=2.4p ps=9.2u w=4u l=5.12u
X2968 VDD a_89534_51094# a_90162_51444# VDD pfet_03v3 ad=0.3p pd=2.2u as=0.3p ps=2.2u w=0.5u l=0.64u
X2978 VDD DPI_4__Vthr DAC_3__Isum_e DAC_3__Isum_e nfet_03v3 ad=2.4p pd=9.2u as=2.4p ps=9.2u w=4u l=5.12u
X2980 VDD a_67078_95402# a_62978_89578# VDD pfet_03v3 ad=2.4p pd=9.2u as=2.4p ps=9.2u w=4u l=5.12u
X2987 VMEM_4 VSS cap_mim_2f0_m4m5_noshield c_width=22.18u c_length=22.18u
X2988 a_19914_64642# DAC_7__Vb VSS VSS nfet_03v3 ad=0.6p pd=3.2u as=0.6p ps=3.2u w=1u l=8u
X2991 a_19914_80658# DAC_7__Vb VSS VSS nfet_03v3 ad=0.6p pd=3.2u as=0.6p ps=3.2u w=1u l=8u
X2994 VDD DPI_4__VT DPI_4__VT VDD pfet_03v3 ad=1.12p pd=4.56u as=1.12p ps=4.56u w=4u l=5.12u
X3032 VDD DPI_4__Vthr DPI_4__Vthr VDD pfet_03v3 ad=1.12p pd=4.56u as=1.12p ps=4.56u w=4u l=5.12u
X3038 a_16310_94896# w[22] a_22014_94846# VSS nfet_03v3 ad=0.14p pd=1.06u as=0.14p ps=1.06u w=0.5u l=0.64u
X3045 a_16558_125100# spike[3] a_16310_125100# VSS nfet_03v3 ad=0.3p pd=2.2u as=0.3p ps=2.2u w=0.5u l=0.64u
X3046 a_22014_64642# DAC_7__Vb VSS VSS nfet_03v3 ad=0.6p pd=3.2u as=0.6p ps=3.2u w=1u l=8u
X3055 a_16558_94896# spike[1] a_16310_94896# VSS nfet_03v3 ad=0.3p pd=2.2u as=0.3p ps=2.2u w=0.5u l=0.64u
X3063 a_16310_94896# w[23] a_19914_94846# VSS nfet_03v3 ad=0.14p pd=1.06u as=0.14p ps=1.06u w=0.5u l=0.64u
X3065 VDD a_67078_125606# cap_mim_2f0_m4m5_noshield c_width=22.18u c_length=22.18u
X3081 a_19914_125050# DAC_7__Vb VSS VSS nfet_03v3 ad=0.6p pd=3.2u as=0.6p ps=3.2u w=1u l=8u
X3082 a_19914_110862# DAC_7__Vb VSS VSS nfet_03v3 ad=0.6p pd=3.2u as=0.6p ps=3.2u w=1u l=8u
X3092 a_19914_31978# DAC_7__Vb VSS VSS nfet_03v3 ad=0.6p pd=3.2u as=0.6p ps=3.2u w=1u l=8u
X3094 spike[3] a_90162_81648# a_90542_81648# VSS nfet_03v3 ad=0.3p pd=2.2u as=0.3p ps=2.2u w=0.5u l=0.64u
X3098 a_16310_110912# w[27] a_19914_110862# VSS nfet_03v3 ad=0.14p pd=1.06u as=0.14p ps=1.06u w=0.5u l=0.64u
X3103 a_19914_125050# w[31] a_16310_125100# VSS nfet_03v3 ad=0.14p pd=1.06u as=0.14p ps=1.06u w=0.5u l=0.64u
X3105 VDD DPI_4__VT DPI_4__VT VDD pfet_03v3 ad=2.4p pd=9.2u as=1.12p ps=4.56u w=4u l=5.12u
X3109 VDD a_67078_95402# cap_mim_2f0_m4m5_noshield c_width=22.18u c_length=22.18u
X3110 a_22014_13502# DAC_7__Vb VSS VSS nfet_03v3 ad=0.6p pd=3.2u as=0.6p ps=3.2u w=1u l=8u
X3122 a_19914_94846# DAC_7__Vb VSS VSS nfet_03v3 ad=0.6p pd=3.2u as=0.6p ps=3.2u w=1u l=8u
X3123 VDD DPI_4__Vthr DAC_5__Isum_i DAC_5__Isum_i nfet_03v3 ad=2.4p pd=9.2u as=2.4p ps=9.2u w=4u l=5.12u
X3126 spike[4] VSS cap_mim_2f0_m4m5_noshield c_width=10u c_length=10u
X3128 VDD a_62528_83274# cap_mim_2f0_m4m5_noshield c_width=22.18u c_length=22.18u
X3129 bias_0__VT_inh bias_0__VT_inh VDD VDD pfet_03v3 ad=0.2464p pd=1.44u as=0.2464p ps=1.44u w=0.88u l=1.12u
X3131 VDD s[0] a_17058_13344# VDD pfet_03v3 ad=0.3p pd=2.2u as=0.3p ps=2.2u w=0.5u l=0.32u
X3142 a_16310_80708# w[17] a_26214_80658# VSS nfet_03v3 ad=0.14p pd=1.06u as=0.3p ps=2.2u w=0.5u l=0.64u
X3144 a_26214_31978# DAC_7__Vb VSS VSS nfet_03v3 ad=0.6p pd=3.2u as=0.6p ps=3.2u w=1u l=8u
X3147 a_62528_34594# a_62528_34594# DAC_6__Isum_e DAC_6__Isum_e nfet_03v3 ad=2.4p pd=9.2u as=2.4p ps=9.2u w=4u l=5.12u
X3150 a_16310_94896# w[23] a_19914_94846# VSS nfet_03v3 ad=0.14p pd=1.06u as=0.14p ps=1.06u w=0.5u l=0.64u
X3158 DPI_4__Vthr DPI_4__Vthr VDD VDD pfet_03v3 ad=1.12p pd=4.56u as=1.12p ps=4.56u w=4u l=5.12u
X3173 a_16310_125100# w[31] a_19914_125050# VSS nfet_03v3 ad=0.14p pd=1.06u as=0.3p ps=2.2u w=0.5u l=0.64u
X3176 a_16310_64692# w[13] a_26214_64642# VSS nfet_03v3 ad=0.14p pd=1.06u as=0.3p ps=2.2u w=0.5u l=0.64u
X3177 VDD neuron_4__VNA a_93976_20808# VDD pfet_03v3 ad=0.6p pd=3.2u as=0.6p ps=3.2u w=1u l=1u
X3188 VDD DPI_4__VT a_67078_95402# VDD pfet_03v3 ad=2.4p pd=9.2u as=2.4p ps=9.2u w=4u l=5.12u
X3210 a_16310_94896# w[23] a_19914_94846# VSS nfet_03v3 ad=0.14p pd=1.06u as=0.3p ps=2.2u w=0.5u l=0.64u
X3219 DPI_4__Vthr DPI_4__Vthr VDD VDD pfet_03v3 ad=1.12p pd=4.56u as=1.12p ps=4.56u w=4u l=5.12u
X3221 a_89914_14492# neuron_4__VIp VSS VSS nfet_03v3 ad=0.6p pd=3.2u as=0.6p ps=3.2u w=1u l=1u
X3223 a_93976_20808# a_90162_14492# VMEM_0 VDD pfet_03v3 ad=0.3p pd=2.2u as=0.3p ps=2.2u w=0.5u l=0.64u
X3231 VDD bias_0__VT_inh bias_0__VT_inh VDD pfet_03v3 ad=0.2464p pd=1.44u as=0.2464p ps=1.44u w=0.88u l=1.12u
X3236 DPI_4__VT DPI_4__VT VDD VDD pfet_03v3 ad=1.12p pd=4.56u as=1.12p ps=4.56u w=4u l=5.12u
X3249 a_26214_110862# DAC_7__Vb VSS VSS nfet_03v3 ad=0.6p pd=3.2u as=0.6p ps=3.2u w=1u l=8u
X3250 a_34614_13502# DAC_7__Vb VSS VSS nfet_03v3 ad=0.6p pd=3.2u as=0.6p ps=3.2u w=1u l=8u
X3257 a_22014_50454# DAC_7__Vb VSS VSS nfet_03v3 ad=0.6p pd=3.2u as=0.6p ps=3.2u w=1u l=8u
X3259 VDD DPI_4__Vthr DAC_1__Isum_i DAC_1__Isum_i nfet_03v3 ad=2.4p pd=9.2u as=2.4p ps=9.2u w=4u l=5.12u
X3260 VDD a_88272_20808# a_89534_14142# VDD pfet_03v3 ad=0.3p pd=2.2u as=0.3p ps=2.2u w=0.5u l=8u
X3265 DAC_1__Isum_e a_17058_110704# a_16558_110912# VSS nfet_03v3 ad=0.3p pd=2.2u as=0.3p ps=2.2u w=0.5u l=0.64u
C0 VDD a_19914_31978# 0.77619f
C1 a_90542_81648# VMEM_3 0.25888f
C2 pulse[0] w[6] 0.02041f
C3 w[17] w[2] 0.67334f
C4 w[14] w[0] 0.05157f
C5 VDD a_89534_111502# 6.10375f
C6 w[2] s[3] 0.01984f
C7 w[8] w[7] 2.90594f
C8 w[17] w[3] 0.2139f
C9 w[19] w[20] 5.62387f
C10 w[3] s[3] 0.01984f
C11 DAC_3__Isum_i a_16558_94896# 1.32914f
C12 w[11] s[6] 0.0554f
C13 DAC_5__Isum_e DAC_5__Isum_i 11.3441f
C14 w[12] a_34614_64642# 0.04246f
C15 w[11] w[18] 0.13822f
C16 w[17] w[1] 0.21921f
C17 VDD w[4] 0.37805f
C18 w[20] w[30] 0.12099f
C19 s[4] w[4] 0.06038f
C20 w[8] w[6] 0.50908f
C21 w[1] s[3] 0.02161f
C22 s[1] pulse[1] 6.13764f
C23 s[5] s[2] 0.23942f
C24 DAC_3__Isum_i a_19914_94846# 0.01896f
C25 a_88272_87964# spike[3] 0.52077f
C26 w[15] s[2] 0.08722f
C27 neuron_4__VKdn VMEM_4 0.31794f
C28 w[12] w[31] 0.15739f
C29 a_88272_118168# neuron_4__VNA 0.33887f
C30 a_90542_81648# a_88272_87964# 0.01339f
C31 w[23] w[7] 0.09899f
C32 VMEM_0 a_93348_20808# 0.12888f
C33 spike[0] w[15] 0.06185f
C34 w[9] VDD 0.28285f
C35 s[7] a_16558_125100# 0.04246f
C36 w[13] w[21] 0.18395f
C37 w[9] s[4] 0.05345f
C38 a_19914_64642# a_34614_64642# 0.16484f
C39 a_62528_53070# spike[1] 0.0263f
C40 VMEM_4 DAC_1__Isum_i 0.58594f
C41 neuron_4__VNA neuron_4__VIp 5.32349f
C42 VT neuron_4__VIp 23.9581f
C43 w[27] w[20] 0.13155f
C44 w[23] w[6] 0.13473f
C45 a_93976_87964# a_93348_87964# 0.53841f
C46 a_16310_64692# a_22014_64642# 15.0391f
C47 VDD a_93348_20808# 2.79898f
C48 neuron_4__VNA a_90162_81648# 0.40563f
C49 w[20] w[7] 2.49058f
C50 VT a_90162_81648# 0.07055f
C51 a_34614_64642# DAC_5__Isum_i 0.11679f
C52 VMEM_4 a_93976_118168# 0.93986f
C53 w[13] w[18] 0.17895f
C54 w[13] s[6] 0.0664f
C55 a_90162_111852# VMEM_4 0.29575f
C56 a_62978_89578# a_67078_95402# 9.93393f
C57 a_16310_64692# w[15] 0.364f
C58 w[28] VDD 0.17444f
C59 w[9] w[4] 0.09323f
C60 w[19] s[5] 0.85638f
C61 w[28] s[4] 0.15f
C62 w[27] w[25] 0.0901f
C63 a_34614_31978# DAC_7__Vb 0.093f
C64 w[19] w[15] 0.20164f
C65 DAC_6__Isum_e a_16310_32028# 0.07931f
C66 spike[1] spike[2] 6.65476f
C67 w[20] w[6] 0.13182f
C68 w[25] w[7] 0.10722f
C69 w[14] w[5] 0.2566f
C70 w[12] w[5] 0.01575f
C71 a_87734_14492# VT 0.26497f
C72 a_89534_51094# VMEM_2 3.23701f
C73 s[5] w[30] 0.14594f
C74 a_22014_110862# DAC_7__Vb 0.37182f
C75 VMEM_3 neuron_4__VIp 0.24351f
C76 w[30] w[15] 0.13163f
C77 DAC_1__Isum_i a_34614_125050# 0.11679f
C78 spike[1] s[2] 0.31284f
C79 w[25] w[6] 0.14454f
C80 a_88272_39284# neuron_4__VKup 3.24408f
C81 a_90162_81648# VMEM_3 0.29575f
C82 w[16] w[17] 7.05645f
C83 a_22014_125050# DAC_1__Isum_i 12.8867f
C84 a_90542_51444# spike[2] 1.35619f
C85 a_87734_32968# a_89914_32968# 0.02914f
C86 neuron_4__Vamp_bias spike[1] 0.14219f
C87 w[16] s[3] 0.10096f
C88 a_93976_87964# spike[3] 0.28806f
C89 w[12] w[24] 0.13231f
C90 neuron_4__VKup a_90162_51444# 0.84828f
C91 w[8] w[22] 2.15834f
C92 spike[0] spike[1] 23.8091f
C93 s[7] VDD 1.73122f
C94 neuron_4__Vamp_bias a_87734_81648# 0.05117f
C95 s[7] s[4] 0.15616f
C96 VDD a_62528_53070# 11.5972f
C97 a_17058_80500# a_34614_80658# 0.75055f
C98 VDD a_62978_119782# 4.61125f
C99 a_16310_110912# spike[2] 0.04246f
C100 VMEM_2 a_87734_51444# 0.27205f
C101 a_62528_53070# DPI_4__Vthr 1.69204f
C102 DAC_3__Isum_i a_26214_80658# 10.8659f
C103 w[27] s[5] 0.1522f
C104 a_19914_80658# DAC_3__Isum_i 0.01896f
C105 VMEM_2 a_62978_59374# 0.20517f
C106 w[28] w[9] 9.40912f
C107 neuron_4__VK a_91170_81648# 0.04013f
C108 s[5] w[7] 0.84418f
C109 w[27] w[15] 0.13163f
C110 a_88272_87964# a_90162_81648# 4.40172f
C111 s[6] w[26] 0.43307f
C112 w[15] w[7] 0.08504f
C113 s[5] s[0] 0.13139f
C114 a_16310_64692# spike[1] 0.04246f
C115 w[0] w[10] 0.10775f
C116 s[7] w[4] 0.05354f
C117 w[19] spike[1] 0.08275f
C118 VDD spike[2] 2.48499f
C119 VMEM_0 neuron_4__Vamp_bias 1.99513f
C120 DPI_4__Vthr spike[2] 0.15537f
C121 s[5] w[6] 0.52902f
C122 w[23] w[22] 20.4549f
C123 Iref neuron_4__VKup 0.56184f
C124 spike[0] VMEM_0 2.78018f
C125 w[11] w[17] 0.1757f
C126 s[2] s[4] 0.15919f
C127 VDD s[2] 2.29869f
C128 w[21] w[8] 2.23739f
C129 a_16310_50504# a_16558_50504# 1.6884f
C130 w[11] s[3] 0.01984f
C131 VDD neuron_4__Vamp_bias 12.8089f
C132 pulse[1] a_16310_32028# 0.04246f
C133 VDD a_17058_31820# 8.97515f
C134 a_16558_125100# spike[3] 0.01869f
C135 spike[1] spike[3] 0.08383f
C136 neuron_4__Vamp_bias DPI_4__Vthr 0.4633f
C137 neuron_4__VK bias_0__VT_inh 0.14931f
C138 w[20] w[22] 0.36053f
C139 neuron_4__Vlk a_4687_155494# 0.27761f
C140 a_26214_125050# DAC_1__Isum_e 2.06134f
C141 w[11] a_17058_50296# 1.52978f
C142 a_22014_50454# a_17058_50296# 0.05882f
C143 w[9] s[7] 0.04615f
C144 neuron_4__VK spike[4] 0.08809f
C145 a_17058_31820# a_19914_31978# 0.11443f
C146 w[18] w[8] 8.85615f
C147 neuron_4__Vamp_bias a_89534_111502# 0.07771f
C148 VDD spike[0] 2.85868f
C149 w[8] s[6] 0.04224f
C150 VDD a_93976_57760# 2.94927f
C151 spike[0] s[4] 1.01f
C152 spike[0] DPI_4__Vthr 1.75824f
C153 s[2] w[4] 3.47891f
C154 a_26214_31978# w[5] 0.08445f
C155 bias_0__VT_inh DAC_7__Vb 0.18693f
C156 DAC_1__Isum_e a_34614_110862# 6.81042f
C157 a_89534_14142# VT 0.51489f
C158 DPI_4__VT bias_0__VT_inh 37.2967f
C159 w[13] a_26214_64642# 0.08445f
C160 DAC_7__Vb w[14] 7.07258f
C161 a_16558_94896# a_16310_94896# 1.6884f
C162 neuron_4__VNA a_89534_14142# 0.16899f
C163 w[12] DAC_7__Vb 7.11999f
C164 VDD a_93348_87964# 2.79898f
C165 w[27] spike[1] 13.1236f
C166 w[28] s[7] 1.41835f
C167 w[21] w[23] 0.0901f
C168 VMEM_2 a_88272_57760# 1.71072f
C169 a_16310_64692# VDD 0.54717f
C170 w[19] VDD 0.36147f
C171 w[19] s[4] 0.41113f
C172 a_19914_94846# a_16310_94896# 17.2602f
C173 a_93976_87964# a_90162_81648# 0.04621f
C174 a_16558_80708# DAC_3__Isum_e 2.10366f
C175 a_16558_125100# DAC_1__Isum_e 2.10366f
C176 w[9] s[2] 0.51263f
C177 w[13] w[17] 0.24264f
C178 VMEM_2 DAC_5__Isum_i 0.58594f
C179 w[23] s[6] 0.05859f
C180 VDD w[30] 0.17671f
C181 w[13] s[3] 0.81342f
C182 w[20] w[21] 13.5667f
C183 w[5] w[10] 0.21447f
C184 a_89914_111852# VMEM_4 0.1368f
C185 w[30] s[4] 0.14125f
C186 a_22014_80658# a_16310_80708# 15.0391f
C187 w[19] w[4] 1.69091f
C188 VDD spike[3] 5.87802f
C189 w[9] spike[0] 0.1426f
C190 a_19914_64642# DAC_7__Vb 0.74342f
C191 DAC_5__Isum_e a_26214_50454# 2.06134f
C192 s[5] w[22] 0.40861f
C193 w[28] s[2] 0.27687f
C194 DPI_4__Vthr spike[3] 4.94053f
C195 w[20] s[6] 0.05764f
C196 w[27] a_16310_110912# 0.364f
C197 w[15] w[22] 0.1239f
C198 w[24] w[10] 8.23383f
C199 a_26214_110862# a_19914_110862# 0.27118f
C200 VDD a_90542_81648# 0.15438f
C201 VDD a_16558_32028# 1.5403f
C202 spike[0] a_93348_20808# 1.98323f
C203 a_89534_14142# a_90162_14492# 14.8965f
C204 w[14] w[2] 0.57764f
C205 w[25] s[6] 0.4394f
C206 VDD a_22014_94846# 0.42217f
C207 w[14] w[3] 0.44787f
C208 VDD w[27] 0.27298f
C209 a_22014_80658# w[18] 0.25032f
C210 DAC_1__Isum_e a_16310_110912# 0.07931f
C211 w[27] s[4] 0.14125f
C212 w[14] w[1] 0.29531f
C213 a_87734_111852# VMEM_4 0.27205f
C214 VMEM_0 a_91170_14492# 3.31883f
C215 VDD w[7] 0.40925f
C216 w[9] w[19] 0.13731f
C217 a_62528_113478# VMEM_4 4.23596f
C218 a_93348_118168# VDD 2.79898f
C219 spike[1] neuron_4__VIp 0.1535f
C220 s[4] w[7] 2.47243f
C221 VDD s[0] 2.00974f
C222 neuron_4__Vlk VT 7.82613f
C223 neuron_4__VNA neuron_4__Vlk 4.26834f
C224 a_19914_31978# w[7] 0.56837f
C225 s[4] s[0] 0.13131f
C226 a_17058_50296# a_34614_50454# 0.75055f
C227 neuron_4__VKdn Iref 0.30659f
C228 s[7] s[2] 2.11172f
C229 VDD w[6] 0.32954f
C230 a_89914_81648# a_91170_81648# 0.26264f
C231 VDD DAC_1__Isum_e 18.1312f
C232 s[4] w[6] 0.08012f
C233 DPI_4__Vthr DAC_1__Isum_e 2.8953f
C234 a_19914_94846# DAC_7__Vb 0.74342f
C235 s[3] w[26] 0.07573f
C236 VDD a_91170_14492# 0.17724f
C237 w[21] s[5] 0.4075f
C238 a_16558_80708# s[4] 0.04246f
C239 a_16558_80708# VDD 0.21115f
C240 a_26214_31978# DAC_7__Vb 0.18591f
C241 w[21] w[15] 0.28914f
C242 w[7] w[4] 2.52537f
C243 pulse[1] w[0] 0.05891f
C244 neuron_4__VKdn neuron_4__VKup 11.3446f
C245 w[28] w[30] 0.08348f
C246 w[6] w[4] 0.26424f
C247 s[5] s[6] 1.4624f
C248 spike[1] w[22] 0.21228f
C249 spike[0] a_62528_53070# 0.12569f
C250 s[5] w[18] 0.84607f
C251 neuron_4__Vlk VMEM_3 0.30075f
C252 VMEM_1 neuron_4__VK 0.35297f
C253 w[18] w[15] 0.11331f
C254 w[15] s[6] 0.07061f
C255 pulse[0] s[3] 0.36428f
C256 w[28] spike[3] 0.08662f
C257 VDD a_88272_118168# 10.7242f
C258 neuron_4__Vamp_bias spike[2] 0.67858f
C259 VMEM_0 neuron_4__VIp 0.18393f
C260 w[9] w[27] 9.52949f
C261 w[9] w[7] 0.18752f
C262 a_88272_118168# a_89534_111502# 0.68101f
C263 spike[0] spike[2] 0.07991f
C264 w[8] w[17] 1.16632f
C265 spike[2] a_93976_57760# 0.28806f
C266 w[8] s[3] 0.01984f
C267 VMEM_1 DPI_4__VT 0.36737f
C268 DAC_3__Isum_e a_16310_80708# 0.07931f
C269 a_90162_111852# neuron_4__VKup 0.83865f
C270 DAC_7__Vb w[10] 1.39109f
C271 w[19] s[7] 0.04411f
C272 a_91170_111852# spike[4] 1.13486f
C273 VDD neuron_4__VIp 31.9341f
C274 VT a_88272_20808# 0.01016f
C275 DAC_3__Isum_i a_67078_95402# 6.12556f
C276 neuron_4__VNA a_88272_20808# 0.33796f
C277 w[9] w[6] 0.26824f
C278 DPI_4__Vthr neuron_4__VIp 0.23729f
C279 w[28] w[27] 17.8398f
C280 VDD a_90162_81648# 3.97006f
C281 VMEM_0 a_87734_14492# 0.27205f
C282 spike[0] s[2] 1.67979f
C283 a_16310_50504# a_17058_50296# 0.10497f
C284 s[7] w[30] 0.41245f
C285 a_34614_94846# a_19914_94846# 0.16484f
C286 w[28] w[7] 0.09825f
C287 neuron_4__VIp a_89534_111502# 0.07935f
C288 w[12] w[16] 25.6928f
C289 spike[0] neuron_4__Vamp_bias 0.82345f
C290 VDD a_90542_111852# 0.15438f
C291 s[7] spike[3] 1.10853f
C292 w[21] spike[1] 0.2726f
C293 a_62978_119782# spike[3] 0.09204f
C294 w[28] w[6] 3.56342f
C295 VDD a_87734_14492# 0.22723f
C296 a_17058_64484# a_16558_64692# 0.11824f
C297 a_90162_14492# a_89914_14492# 1.31172f
C298 VDD a_67078_125606# 12.1331f
C299 w[23] s[3] 0.08448f
C300 DAC_3__Isum_i a_34614_80658# 0.11679f
C301 VDD w[22] 0.40004f
C302 pulse[1] w[5] 4.1238f
C303 DPI_4__Vthr a_67078_125606# 1.85716f
C304 w[19] s[2] 0.23419f
C305 spike[1] w[18] 0.06863f
C306 s[4] w[22] 0.14059f
C307 a_17058_13344# DAC_7__Isum_e 14.2174f
C308 VDD a_93348_57760# 2.79898f
C309 spike[2] spike[3] 11.5303f
C310 s[7] w[27] 0.0616f
C311 w[30] s[2] 3.33972f
C312 DAC_7__Vb a_26214_80658# 0.18591f
C313 a_26214_94846# a_19914_94846# 0.27118f
C314 s[7] w[7] 0.18838f
C315 a_16310_125100# a_34614_125050# 1.31469f
C316 a_19914_80658# DAC_7__Vb 0.74342f
C317 w[2] w[10] 1.75867f
C318 VMEM_1 a_89914_32968# 0.1368f
C319 DPI_4__VT a_62528_83274# 1.39296f
C320 a_22014_125050# a_16310_125100# 15.0391f
C321 a_22014_13502# DAC_7__Vb 0.37182f
C322 a_62528_34594# VMEM_1 4.24606f
C323 a_16558_94896# a_17058_94688# 0.11824f
C324 w[20] s[3] 0.07787f
C325 w[19] spike[0] 0.2344f
C326 s[7] s[0] 0.34988f
C327 w[22] w[4] 7.62193f
C328 w[3] w[10] 0.92469f
C329 a_19914_110862# a_22014_110862# 0.57119f
C330 DAC_3__Isum_i a_62978_89578# 0.15462f
C331 a_90542_14492# neuron_4__VKdn 0.04013f
C332 a_90162_14492# a_88272_20808# 4.40172f
C333 neuron_4__VK VMEM_4 2.52795f
C334 w[24] pulse[1] 0.10938f
C335 a_87734_32968# VT 0.26497f
C336 neuron_4__Vamp_bias spike[3] 5.06112f
C337 w[25] a_26214_110862# 0.08445f
C338 s[7] w[6] 2.10799f
C339 VDD a_16310_80708# 0.54717f
C340 w[11] w[14] 0.20944f
C341 w[1] w[10] 0.11552f
C342 w[25] s[3] 0.07573f
C343 w[11] w[12] 0.12822f
C344 a_19914_94846# a_17058_94688# 0.11443f
C345 w[27] spike[2] 0.07426f
C346 DAC_3__Isum_i a_17058_80500# 0.05814f
C347 spike[0] spike[3] 0.08383f
C348 VDD a_16558_50504# 0.21115f
C349 DPI_4__VT VMEM_4 0.29967f
C350 VDD w[21] 0.97279f
C351 a_26214_64642# a_22014_64642# 0.29412f
C352 DAC_1__Isum_i a_16558_110912# 1.32914f
C353 a_16558_32028# a_17058_31820# 0.11824f
C354 w[21] s[4] 0.12314f
C355 w[27] s[2] 0.25231f
C356 w[9] w[22] 0.1061f
C357 a_22014_110862# w[26] 0.25032f
C358 s[2] w[7] 0.3556f
C359 a_93348_87964# spike[3] 1.98323f
C360 a_22014_31978# a_16310_32028# 15.0391f
C361 s[2] s[0] 0.4417f
C362 VDD w[18] 0.41944f
C363 w[18] s[4] 0.40259f
C364 a_17058_31820# w[7] 1.52889f
C365 s[6] s[4] 19.1151f
C366 VDD s[6] 1.71199f
C367 DAC_7__Vb a_19914_13502# 0.74342f
C368 a_34614_13502# DAC_7__Isum_e 6.81042f
C369 VMEM_0 a_89534_14142# 3.23701f
C370 w[21] w[4] 7.74471f
C371 a_4687_155494# bias_0__VT_inh 0.15431f
C372 s[2] w[6] 0.4714f
C373 s[5] w[17] 0.04325f
C374 a_22014_13502# w[2] 0.25032f
C375 DAC_7__Vb a_34614_125050# 0.093f
C376 a_22014_125050# DAC_7__Vb 0.37182f
C377 w[15] w[17] 0.11105f
C378 s[5] s[3] 23.6701f
C379 w[30] spike[3] 0.08662f
C380 a_22014_50454# DAC_5__Isum_i 12.8867f
C381 w[18] w[4] 0.18181f
C382 w[15] s[3] 0.54536f
C383 s[6] w[4] 0.05028f
C384 a_62528_34594# DAC_6__Isum_e 7.7433f
C385 w[13] w[12] 10.3995f
C386 VDD a_89534_14142# 6.10103f
C387 w[13] w[14] 7.70973f
C388 a_17058_110704# a_16558_110912# 0.11824f
C389 spike[0] a_91170_14492# 1.13486f
C390 a_16558_80708# spike[0] 0.01869f
C391 a_26214_50454# DAC_7__Vb 0.18591f
C392 w[9] w[21] 0.10592f
C393 w[19] w[7] 0.20144f
C394 a_89534_51094# VT 0.51489f
C395 neuron_4__Vlk spike[1] 1.96098f
C396 pulse[1] DAC_7__Vb 0.28658f
C397 w[31] w[29] 0.0901f
C398 spike[2] neuron_4__VIp 0.15056f
C399 a_89534_51094# neuron_4__VNA 0.16897f
C400 a_90542_81648# spike[3] 1.35619f
C401 a_26214_110862# a_34614_110862# 7.01128f
C402 s[7] w[22] 0.05286f
C403 a_90162_111852# a_93976_118168# 0.04621f
C404 w[30] w[7] 0.13006f
C405 w[9] s[6] 0.05345f
C406 w[19] w[6] 0.11764f
C407 w[9] w[18] 0.11981f
C408 a_67078_125606# a_62978_119782# 9.93393f
C409 a_19914_13502# w[3] 0.56837f
C410 neuron_4__Vamp_bias neuron_4__VIp 4.29879f
C411 w[30] w[6] 1.54572f
C412 neuron_4__Vamp_bias a_90162_81648# 0.08699f
C413 DAC_1__Isum_i a_17058_110704# 0.05814f
C414 w[28] s[6] 0.13861f
C415 spike[0] neuron_4__VIp 0.15097f
C416 DAC_1__Isum_e spike[3] 0.25849f
C417 a_19914_50454# DAC_7__Vb 0.74342f
C418 a_89534_32618# a_89914_32968# 0.60758f
C419 spike[1] w[17] 0.07635f
C420 spike[1] s[3] 1.75633f
C421 a_87734_51444# VT 0.26497f
C422 a_62528_16118# DAC_7__Isum_e 7.71728f
C423 spike[2] a_93348_57760# 1.98323f
C424 VMEM_0 neuron_4__Vlk 0.22624f
C425 a_87734_14492# neuron_4__Vamp_bias 0.05117f
C426 DAC_5__Isum_e a_16558_64692# 2.10366f
C427 w[29] w[5] 2.48789f
C428 s[2] w[22] 0.5827f
C429 s[1] w[0] 1.06512f
C430 w[12] w[26] 0.12374f
C431 w[27] w[7] 0.09825f
C432 a_17058_64484# DAC_5__Isum_e 14.2174f
C433 a_17058_124892# a_34614_125050# 0.75055f
C434 a_22014_125050# a_17058_124892# 0.05882f
C435 a_93348_87964# a_90162_81648# 0.37248f
C436 pulse[1] w[2] 0.4478f
C437 s[7] w[21] 0.04411f
C438 VMEM_3 a_91170_81648# 3.31883f
C439 w[11] w[10] 7.97218f
C440 pulse[1] w[3] 0.20113f
C441 a_22014_50454# w[10] 0.25032f
C442 w[27] w[6] 3.1781f
C443 VDD neuron_4__Vlk 4.92447f
C444 neuron_4__Vlk DPI_4__Vthr 10.1641f
C445 w[7] w[6] 7.64961f
C446 neuron_4__VNA bias_0__VT_inh 0.41113f
C447 spike[0] w[22] 13.1745f
C448 pulse[1] w[1] 0.36301f
C449 spike[4] VT 0.07353f
C450 a_91170_111852# VMEM_4 3.31883f
C451 VMEM_0 a_89914_14492# 0.1368f
C452 neuron_4__Vlk a_89534_111502# 0.03125f
C453 s[7] s[6] 49.5553f
C454 VDD a_26214_64642# 0.26038f
C455 s[7] w[18] 0.04557f
C456 a_93348_57760# a_93976_57760# 0.53841f
C457 a_16310_110912# a_26214_110862# 1.78781f
C458 a_34614_50454# DAC_5__Isum_i 0.11679f
C459 neuron_4__VIp spike[3] 0.15542f
C460 a_22014_13502# a_17058_13344# 0.05882f
C461 w[8] w[14] 0.21139f
C462 a_16310_125100# w[29] 0.10002f
C463 a_90162_81648# spike[3] 9.68412f
C464 VDD a_89914_14492# 0.14568f
C465 a_16558_50504# s[2] 0.04246f
C466 VMEM_2 a_90162_51444# 0.29575f
C467 a_89534_81298# neuron_4__VKup 0.14153f
C468 w[21] s[2] 0.74477f
C469 VDD a_26214_110862# 0.26038f
C470 spike[0] a_16310_80708# 0.04246f
C471 w[17] s[4] 0.50877f
C472 VDD w[17] 1.98621f
C473 a_17058_64484# a_34614_64642# 0.75055f
C474 spike[2] s[6] 1.13659f
C475 s[4] s[3] 0.42086f
C476 VDD s[3] 2.01963f
C477 a_90542_81648# a_90162_81648# 0.67211f
C478 VMEM_0 a_88272_20808# 1.71072f
C479 a_88272_57760# VT 0.01402f
C480 neuron_4__VNA a_88272_57760# 0.33945f
C481 VDD a_17058_50296# 8.89784f
C482 DPI_4__VT a_67078_95402# 2.17032f
C483 spike[0] a_16558_50504# 0.01869f
C484 spike[0] w[21] 0.13904f
C485 s[2] s[6] 0.11693f
C486 w[18] s[2] 0.22943f
C487 a_67078_125606# spike[3] 0.38425f
C488 w[17] w[4] 0.86523f
C489 a_90542_51444# a_89914_51444# 1.82301f
C490 w[4] s[3] 0.01984f
C491 s[1] w[5] 3.83146f
C492 VDD a_88272_20808# 10.718f
C493 w[12] w[23] 0.13231f
C494 w[19] a_16310_80708# 0.364f
C495 spike[0] w[18] 0.22565f
C496 a_17058_13344# a_19914_13502# 0.11443f
C497 a_34614_80658# DAC_7__Vb 0.093f
C498 w[22] a_22014_94846# 0.25032f
C499 w[19] w[21] 1.60931f
C500 neuron_4__Vamp_bias a_89534_14142# 0.07771f
C501 w[20] w[14] 4.81571f
C502 a_16310_50504# DAC_5__Isum_i 1.77847f
C503 a_22014_13502# a_34614_13502# 0.11882f
C504 w[12] w[20] 0.11913f
C505 pulse[1] w[16] 0.19476f
C506 a_34614_110862# a_22014_110862# 0.11882f
C507 DAC_7__Vb w[29] 1.30647f
C508 w[22] w[7] 0.10904f
C509 neuron_4__VK a_91170_32968# 0.04013f
C510 w[9] w[17] 0.13289f
C511 neuron_4__VK Iref 0.26158f
C512 VMEM_2 neuron_4__VKup 0.0647f
C513 w[9] s[3] 0.02161f
C514 a_90162_111852# a_89914_111852# 1.31172f
C515 spike[0] a_89534_14142# 0.14351f
C516 a_88272_118168# neuron_4__VIp 0.01472f
C517 w[19] s[6] 0.04109f
C518 w[12] w[25] 0.12367f
C519 w[19] w[18] 18.741f
C520 w[22] w[6] 0.1344f
C521 VDD a_89914_51444# 0.14568f
C522 Iref DAC_7__Vb 0.54839f
C523 neuron_4__VK neuron_4__VKup 9.50609f
C524 DPI_4__VT Iref 0.23534f
C525 w[30] s[6] 0.12975f
C526 a_88272_39284# a_89914_32968# 0.09468f
C527 a_88272_118168# a_90542_111852# 0.01339f
C528 w[28] s[3] 0.0959f
C529 a_17058_80500# DAC_7__Vb 0.04761f
C530 w[10] w[26] 9.65917f
C531 neuron_4__VKup DAC_7__Vb 0.17425f
C532 s[6] spike[3] 0.25978f
C533 a_87734_32968# VDD 0.22723f
C534 DPI_4__VT neuron_4__VKup 1.96461f
C535 a_34614_13502# a_19914_13502# 0.16484f
C536 VMEM_1 VT 4.14207f
C537 a_22014_50454# a_26214_50454# 0.29412f
C538 w[21] w[7] 2.90342f
C539 VMEM_1 neuron_4__VNA 2.65322f
C540 a_22014_64642# w[14] 0.25032f
C541 pulse[0] w[10] 0.08796f
C542 w[11] pulse[1] 0.38533f
C543 neuron_4__Vlk spike[2] 2.3397f
C544 s[5] w[14] 0.17784f
C545 a_16558_80708# a_16310_80708# 1.6884f
C546 w[12] s[5] 0.30524f
C547 w[15] w[14] 7.35219f
C548 w[27] s[6] 0.41594f
C549 w[12] w[15] 0.22468f
C550 s[7] w[17] 0.04557f
C551 w[21] w[6] 0.1169f
C552 w[18] w[7] 0.20322f
C553 s[6] w[7] 0.17829f
C554 w[23] a_19914_94846# 0.56837f
C555 w[8] w[10] 0.27736f
C556 s[7] s[3] 0.13488f
C557 w[29] w[1] 0.14293f
C558 a_16310_110912# a_22014_110862# 15.0391f
C559 s[6] s[0] 0.11775f
C560 neuron_4__Vlk neuron_4__Vamp_bias 4.68277f
C561 a_16310_50504# w[10] 0.18228f
C562 VDD a_34614_31978# 0.30771f
C563 s[1] DAC_7__Vb 6.94494f
C564 a_91170_32968# a_89914_32968# 0.26264f
C565 a_16310_13552# DAC_7__Isum_e 0.07931f
C566 s[6] w[6] 0.06793f
C567 a_34614_125050# a_19914_125050# 0.16484f
C568 w[18] w[6] 0.11674f
C569 a_22014_125050# a_19914_125050# 0.57119f
C570 a_34614_31978# a_19914_31978# 0.16484f
C571 a_22014_50454# a_19914_50454# 0.57119f
C572 spike[0] neuron_4__Vlk 1.95845f
C573 w[11] a_19914_50454# 0.56837f
C574 VDD a_22014_110862# 0.42217f
C575 a_19914_64642# a_22014_64642# 0.57119f
C576 a_34614_31978# w[4] 0.04246f
C577 a_26214_13502# DAC_7__Isum_e 2.06134f
C578 a_22014_64642# DAC_5__Isum_i 12.8867f
C579 s[2] w[17] 3.30276f
C580 a_19914_64642# w[15] 0.56837f
C581 a_22014_31978# DAC_7__Vb 0.37182f
C582 w[23] w[10] 8.21839f
C583 a_16310_32028# w[5] 0.10002f
C584 w[13] pulse[1] 0.42546f
C585 s[2] s[3] 0.71596f
C586 DAC_5__Isum_e a_34614_64642# 6.81042f
C587 a_16310_125100# DAC_1__Isum_i 1.77847f
C588 VDD a_89534_51094# 6.10092f
C589 spike[0] a_89914_14492# 0.04786f
C590 spike[1] spike[4] 0.09117f
C591 a_17058_50296# s[2] 3.46922f
C592 a_16310_64692# a_26214_64642# 1.78781f
C593 spike[1] w[14] 0.14659f
C594 VMEM_1 a_90162_32968# 0.29575f
C595 w[12] spike[1] 0.14475f
C596 spike[0] w[17] 0.22965f
C597 VMEM_2 neuron_4__VKdn 0.23672f
C598 spike[0] s[3] 0.05589f
C599 w[20] w[10] 0.12307f
C600 neuron_4__VNA VMEM_4 0.13915f
C601 s[5] a_16558_94896# 0.04246f
C602 VMEM_4 VT 1.63653f
C603 s[1] w[2] 0.95652f
C604 spike[0] a_17058_50296# 0.37995f
C605 a_34614_80658# w[16] 0.04246f
C606 neuron_4__Vlk spike[3] 1.97173f
C607 a_62528_83274# VMEM_3 4.23834f
C608 s[1] w[3] 0.51052f
C609 neuron_4__VK neuron_4__VKdn 33.7106f
C610 VDD a_91170_81648# 0.17724f
C611 w[25] w[10] 0.13265f
C612 w[16] w[29] 0.14051f
C613 s[1] w[1] 0.32531f
C614 w[21] w[22] 15.26f
C615 spike[0] a_88272_20808# 0.52077f
C616 VDD a_87734_51444# 0.22723f
C617 w[19] w[17] 0.09024f
C618 a_26214_50454# a_34614_50454# 7.01128f
C619 neuron_4__VKdn DAC_7__Vb 0.34214f
C620 w[19] s[3] 0.0986f
C621 VDD a_62978_59374# 4.6034f
C622 DPI_4__VT neuron_4__VKdn 0.28477f
C623 spike[2] a_89914_51444# 0.04786f
C624 s[6] w[22] 0.04984f
C625 w[30] s[3] 0.09957f
C626 VMEM_0 DAC_7__Isum_e 0.0248f
C627 VMEM_2 a_67078_65198# 6.40836f
C628 neuron_4__VNA a_89534_32618# 0.16882f
C629 a_89534_32618# VT 0.51489f
C630 DAC_1__Isum_i DAC_7__Vb 0.21628f
C631 pulse[1] w[26] 0.14437f
C632 a_16558_13552# a_17058_13344# 0.11824f
C633 spike[1] DAC_5__Isum_i 0.17987f
C634 VMEM_1 a_90542_32968# 0.25888f
C635 a_90542_51444# a_88272_57760# 0.01339f
C636 VDD bias_0__VT_inh 21.1493f
C637 VMEM_2 a_91170_51444# 3.31883f
C638 DPI_4__Vthr bias_0__VT_inh 8.76137f
C639 VDD spike[4] 1.82099f
C640 a_87734_14492# a_89534_14142# 0.9311f
C641 s[4] w[14] 0.0789f
C642 VDD w[14] 0.33487f
C643 DAC_3__Isum_e a_16558_94896# 2.10366f
C644 w[12] s[4] 0.07848f
C645 w[12] VDD 0.32741f
C646 VDD DAC_7__Isum_e 19.7697f
C647 s[5] w[10] 0.04442f
C648 a_34614_50454# a_19914_50454# 0.16484f
C649 DPI_4__Vthr DAC_7__Isum_e 2.8953f
C650 a_90162_111852# DPI_4__VT 0.24171f
C651 spike[4] a_89534_111502# 0.14351f
C652 DAC_3__Isum_i a_16310_94896# 1.77847f
C653 neuron_4__VK a_91170_51444# 0.04013f
C654 a_87734_111852# a_89914_111852# 0.02914f
C655 a_16558_94896# spike[1] 0.01869f
C656 w[18] a_16310_80708# 0.18228f
C657 pulse[1] pulse[0] 0.15952f
C658 a_87734_32968# neuron_4__Vamp_bias 0.05117f
C659 DPI_4__VT a_67078_65198# 1.9254f
C660 w[11] w[29] 0.15868f
C661 a_22014_80658# a_26214_80658# 0.29412f
C662 a_22014_80658# a_19914_80658# 0.57119f
C663 w[27] s[3] 0.0871f
C664 w[17] w[7] 0.25906f
C665 w[12] w[4] 0.20404f
C666 w[14] w[4] 1.07551f
C667 w[7] s[3] 0.02021f
C668 a_26214_50454# a_16310_50504# 1.78781f
C669 w[21] s[6] 0.04109f
C670 pulse[1] w[8] 0.27587f
C671 s[0] s[3] 0.27569f
C672 w[17] w[6] 0.13469f
C673 a_91170_14492# a_89914_14492# 0.26264f
C674 a_17058_110704# DAC_7__Vb 0.02265f
C675 VDD a_88272_57760# 10.7087f
C676 DAC_1__Isum_e a_26214_110862# 2.06134f
C677 w[6] s[3] 0.02161f
C678 w[0] w[5] 0.01722f
C679 VDD a_19914_64642# 0.75723f
C680 w[18] s[6] 0.04109f
C681 neuron_4__Vlk neuron_4__VIp 7.23827f
C682 VDD DAC_5__Isum_i 15.1982f
C683 a_34614_31978# a_17058_31820# 0.75055f
C684 w[9] w[14] 0.10318f
C685 DPI_4__Vthr DAC_5__Isum_i 2.8953f
C686 VMEM_1 spike[1] 2.79261f
C687 w[23] pulse[1] 0.12687f
C688 a_90162_32968# a_89534_32618# 14.8965f
C689 a_16310_50504# a_19914_50454# 17.2602f
C690 a_89534_51094# spike[2] 0.14351f
C691 DAC_1__Isum_i a_17058_124892# 0.05814f
C692 DAC_5__Isum_e VMEM_2 0.0248f
C693 VDD a_16558_94896# 0.21115f
C694 w[13] w[29] 0.20926f
C695 w[28] w[12] 0.14207f
C696 a_89914_14492# neuron_4__VIp 0.04013f
C697 a_16310_13552# a_22014_13502# 15.0391f
C698 a_4687_155494# Iref 13.2576f
C699 w[20] pulse[1] 0.10382f
C700 a_89534_51094# neuron_4__Vamp_bias 0.10647f
C701 VDD a_19914_94846# 0.75723f
C702 VDD a_26214_31978# 11.1263f
C703 s[1] w[11] 3.15536f
C704 a_4687_155494# neuron_4__VKup 0.15253f
C705 a_93348_39284# VMEM_1 0.12888f
C706 w[25] pulse[1] 0.12687f
C707 a_26214_31978# a_19914_31978# 0.27118f
C708 a_22014_13502# a_26214_13502# 0.29412f
C709 a_87734_14492# a_89914_14492# 0.02914f
C710 DAC_3__Isum_e a_62528_83274# 7.73296f
C711 DAC_3__Isum_e a_26214_80658# 2.06134f
C712 s[7] w[14] 0.07159f
C713 a_16310_125100# w[31] 0.364f
C714 w[12] s[7] 0.07255f
C715 VMEM_1 VDD 4.51808f
C716 w[22] s[3] 0.07573f
C717 a_16310_13552# a_19914_13502# 17.2602f
C718 neuron_4__VNA a_88272_39284# 0.33701f
C719 VMEM_1 DPI_4__Vthr 0.21793f
C720 neuron_4__Vamp_bias a_87734_51444# 0.05117f
C721 VDD w[10] 0.28806f
C722 s[4] w[10] 0.05345f
C723 DAC_3__Isum_i a_34614_94846# 0.11679f
C724 a_87734_14492# a_88272_20808# 2.33814f
C725 VT a_90162_51444# 0.07035f
C726 spike[4] spike[2] 2.22178f
C727 w[24] w[5] 0.12554f
C728 neuron_4__VNA a_90162_51444# 0.40573f
C729 a_26214_125050# a_34614_125050# 7.01128f
C730 a_26214_125050# a_22014_125050# 0.29412f
C731 DAC_7__Vb w[0] 7.20632f
C732 a_26214_13502# a_19914_13502# 0.27118f
C733 s[5] pulse[1] 0.11623f
C734 w[17] a_16310_80708# 0.10002f
C735 pulse[1] w[15] 0.44632f
C736 VMEM_3 a_67078_95402# 6.40836f
C737 a_34614_64642# DAC_7__Vb 0.093f
C738 w[4] w[10] 0.10721f
C739 a_89914_51444# neuron_4__VIp 0.04013f
C740 neuron_4__Vamp_bias bias_0__VT_inh 10.2373f
C741 s[2] w[14] 0.21552f
C742 neuron_4__Vamp_bias spike[4] 0.25184f
C743 w[12] s[2] 0.31326f
C744 a_16558_13552# pulse[0] 0.01869f
C745 spike[0] spike[4] 2.71454f
C746 w[21] s[3] 0.08985f
C747 spike[0] w[14] 0.06204f
C748 a_26214_94846# DAC_3__Isum_i 10.8659f
C749 w[12] spike[0] 0.05766f
C750 a_17058_50296# a_16558_50504# 0.11824f
C751 a_88272_57760# spike[2] 0.52077f
C752 w[8] w[29] 0.14307f
C753 w[31] DAC_7__Vb 1.37791f
C754 neuron_4__VNA Iref 0.50943f
C755 spike[3] a_91170_81648# 1.13486f
C756 VDD a_62528_83274# 11.7541f
C757 w[9] w[10] 9.82583f
C758 w[18] w[17] 39.1806f
C759 VDD a_26214_80658# 0.26038f
C760 a_19914_80658# VDD 0.75723f
C761 w[17] s[6] 0.04109f
C762 w[18] s[3] 0.08459f
C763 spike[1] a_89534_32618# 0.14351f
C764 DPI_4__Vthr a_62528_83274# 1.25274f
C765 s[6] s[3] 0.0907f
C766 VDD a_22014_13502# 13.3088f
C767 a_62528_113478# DPI_4__VT 1.38978f
C768 VT neuron_4__VKup 6.84349f
C769 a_90542_81648# a_91170_81648# 1.47502f
C770 VDD DAC_6__Isum_e 19.215f
C771 a_16310_64692# w[14] 0.18228f
C772 DAC_3__Isum_i a_17058_94688# 0.05814f
C773 DPI_4__Vthr DAC_6__Isum_e 2.8953f
C774 neuron_4__VNA neuron_4__VKup 72.6787f
C775 a_16310_64692# w[12] 0.01848f
C776 a_88272_57760# neuron_4__Vamp_bias 0.04161f
C777 w[19] w[14] 8.90374f
C778 a_89534_14142# a_89914_14492# 0.60758f
C779 w[12] w[19] 0.14994f
C780 a_90162_32968# a_88272_39284# 4.40172f
C781 w[2] w[0] 1.79445f
C782 a_62978_89578# VMEM_3 0.20517f
C783 s[2] DAC_5__Isum_i 0.01848f
C784 w[3] w[0] 0.33143f
C785 VDD VMEM_4 5.13844f
C786 DPI_4__Vthr VMEM_4 3.5521f
C787 w[12] w[30] 0.45575f
C788 a_4687_155494# neuron_4__VKdn 1.13015f
C789 w[1] w[0] 6.6254f
C790 VMEM_4 a_89534_111502# 3.23701f
C791 spike[4] spike[3] 14.2794f
C792 DAC_7__Vb w[5] 1.85276f
C793 VMEM_3 neuron_4__VKup 0.24846f
C794 w[20] w[29] 0.12114f
C795 VDD a_19914_13502# 0.77619f
C796 a_89534_14142# a_88272_20808# 0.68101f
C797 s[1] pulse[0] 0.5167f
C798 a_16310_64692# a_19914_64642# 17.2602f
C799 DAC_1__Isum_i a_19914_125050# 0.01896f
C800 w[24] DAC_7__Vb 7.12995f
C801 s[7] w[10] 0.04615f
C802 w[31] w[1] 0.62265f
C803 a_22014_125050# VDD 0.42217f
C804 VDD a_34614_125050# 0.19093f
C805 VDD a_89534_32618# 6.10087f
C806 a_22014_80658# a_34614_80658# 0.11882f
C807 a_16310_64692# DAC_5__Isum_i 1.77847f
C808 a_90162_14492# neuron_4__VKup 0.84327f
C809 w[12] w[27] 0.13267f
C810 a_90542_32968# a_88272_39284# 0.01339f
C811 a_26214_31978# a_17058_31820# 0.06004f
C812 s[1] w[8] 0.20184f
C813 a_93348_118168# spike[4] 1.98323f
C814 w[14] w[7] 0.26982f
C815 a_17058_124892# w[31] 1.50762f
C816 w[14] s[0] 0.08734f
C817 a_88272_87964# neuron_4__VKup 3.24806f
C818 a_93976_39284# neuron_4__VNA 0.04168f
C819 a_90162_32968# neuron_4__VKup 0.83895f
C820 VDD a_26214_50454# 0.26038f
C821 w[14] w[6] 0.1257f
C822 DAC_1__Isum_i a_19914_110862# 0.01896f
C823 VDD pulse[1] 1.09432f
C824 pulse[1] s[4] 0.12622f
C825 w[2] w[5] 0.86676f
C826 a_91170_111852# a_89914_111852# 0.26264f
C827 w[3] w[5] 0.703f
C828 VMEM_2 neuron_4__VK 2.69771f
C829 VMEM_1 neuron_4__Vamp_bias 1.79838f
C830 s[2] w[10] 0.51508f
C831 a_22014_80658# a_17058_80500# 0.05882f
C832 w[1] w[5] 0.38186f
C833 s[5] w[29] 0.1548f
C834 VMEM_1 spike[0] 0.02577f
C835 a_88272_118168# spike[4] 0.52077f
C836 pulse[1] w[4] 0.72551f
C837 VMEM_2 DPI_4__VT 0.91683f
C838 w[15] w[29] 0.14038f
C839 a_34614_94846# a_16310_94896# 1.31469f
C840 w[24] w[3] 0.1234f
C841 spike[0] w[10] 0.14404f
C842 a_90542_32968# a_91170_32968# 1.47502f
C843 VDD a_19914_50454# 0.75723f
C844 neuron_4__VK DAC_7__Vb 0.23331f
C845 w[24] w[1] 0.12274f
C846 bias_0__VT_inh neuron_4__VIp 0.15808f
C847 neuron_4__VKdn VT 10.7473f
C848 a_16310_13552# a_16558_13552# 1.6884f
C849 neuron_4__VNA neuron_4__VKdn 0.86753f
C850 neuron_4__VK DPI_4__VT 0.57081f
C851 spike[4] neuron_4__VIp 0.11374f
C852 a_26214_125050# w[29] 0.08445f
C853 w[28] a_34614_125050# 0.04246f
C854 a_17058_110704# a_19914_110862# 0.11443f
C855 w[9] a_26214_50454# 0.08445f
C856 w[16] w[31] 0.15971f
C857 spike[1] a_88272_39284# 0.52077f
C858 w[9] pulse[1] 0.22312f
C859 w[17] s[3] 0.0941f
C860 VMEM_4 a_62978_119782# 0.20517f
C861 DPI_4__VT DAC_7__Vb 0.73397f
C862 w[19] w[10] 0.1365f
C863 spike[4] a_90542_111852# 1.35619f
C864 a_19914_94846# a_22014_94846# 0.57119f
C865 a_93976_39284# a_90162_32968# 0.04621f
C866 DAC_3__Isum_e a_34614_80658# 6.81042f
C867 a_88272_20808# a_89914_14492# 0.09468f
C868 a_16310_125100# a_17058_124892# 0.10497f
C869 neuron_4__VKdn VMEM_3 0.28005f
C870 a_90542_14492# a_90162_14492# 0.67211f
C871 a_26214_94846# a_16310_94896# 1.78781f
C872 a_90162_111852# VT 0.07035f
C873 w[28] pulse[1] 2.84565f
C874 neuron_4__VNA a_93976_118168# 0.04168f
C875 w[11] w[0] 1.23705f
C876 VMEM_4 spike[2] 0.30362f
C877 a_90162_111852# neuron_4__VNA 0.40674f
C878 w[22] w[14] 12.6455f
C879 w[12] w[22] 0.12365f
C880 a_90542_51444# a_90162_51444# 0.67211f
C881 DAC_6__Isum_e a_17058_31820# 14.2174f
C882 neuron_4__Vamp_bias VMEM_4 1.43574f
C883 a_17058_94688# a_16310_94896# 0.10497f
C884 w[16] w[5] 0.01623f
C885 a_89914_81648# a_89534_81298# 0.60758f
C886 s[1] s[5] 0.2294f
C887 a_34614_94846# DAC_7__Vb 0.093f
C888 a_34614_13502# w[0] 0.04246f
C889 spike[1] a_91170_32968# 1.13486f
C890 VDD a_67078_95402# 11.6719f
C891 DAC_3__Isum_e a_17058_80500# 14.2174f
C892 w[11] w[31] 7.751f
C893 DAC_7__Vb w[2] 1.78926f
C894 w[27] w[10] 9.5467f
C895 DAC_7__Vb w[3] 1.44243f
C896 DPI_4__Vthr a_67078_95402# 1.73852f
C897 a_19914_80658# w[19] 0.56837f
C898 VDD a_88272_39284# 10.7084f
C899 w[7] w[10] 0.17938f
C900 s[7] pulse[1] 0.14625f
C901 w[24] w[16] 0.14051f
C902 a_62528_34594# DPI_4__VT 2.10536f
C903 DAC_7__Vb w[1] 1.4798f
C904 spike[1] neuron_4__VKup 0.06046f
C905 a_17058_13344# w[5] 0.04954f
C906 VDD a_90162_51444# 3.95789f
C907 w[6] w[10] 0.11345f
C908 w[21] w[14] 14.9979f
C909 DAC_5__Isum_e a_34614_50454# 6.81042f
C910 w[12] w[21] 0.12906f
C911 neuron_4__Vamp_bias a_89534_32618# 0.07771f
C912 VDD a_34614_80658# 0.19093f
C913 a_17058_64484# a_22014_64642# 0.05882f
C914 w[12] s[6] 0.06614f
C915 w[18] w[14] 0.12269f
C916 w[12] w[18] 0.12075f
C917 s[6] w[14] 0.06858f
C918 a_26214_94846# DAC_7__Vb 0.18591f
C919 s[4] w[29] 0.15f
C920 VDD w[29] 0.17437f
C921 VDD a_16558_13552# 1.5403f
C922 a_17058_64484# w[15] 1.53032f
C923 w[11] w[5] 2.89303f
C924 pulse[1] s[2] 1.8573f
C925 a_93348_39284# neuron_4__VKup 0.04013f
C926 a_16558_32028# DAC_6__Isum_e 2.10366f
C927 w[31] a_19914_125050# 0.56837f
C928 VMEM_4 spike[3] 0.42158f
C929 w[13] w[31] 0.22079f
C930 VDD a_62978_89578# 4.6034f
C931 pulse[1] a_17058_31820# 0.37995f
C932 VDD a_91170_32968# 0.17724f
C933 VDD Iref 0.93193f
C934 w[3] w[2] 7.18298f
C935 a_17058_94688# DAC_7__Vb 0.01484f
C936 neuron_4__VKdn a_90542_32968# 0.04013f
C937 DPI_4__Vthr Iref 0.69616f
C938 VMEM_1 neuron_4__VIp 0.25802f
C939 w[11] w[24] 0.14005f
C940 a_91170_111852# neuron_4__VK 0.04013f
C941 VDD a_17058_80500# 8.84723f
C942 w[2] w[1] 7.14561f
C943 a_16558_50504# DAC_5__Isum_i 1.32914f
C944 a_17058_80500# s[4] 3.46922f
C945 VDD neuron_4__VKup 14.8366f
C946 w[3] w[1] 0.83336f
C947 DAC_3__Isum_i VMEM_3 0.58594f
C948 DPI_4__Vthr neuron_4__VKup 3.49436f
C949 a_22014_125050# w[30] 0.25032f
C950 a_26214_110862# a_22014_110862# 0.29412f
C951 a_93976_39284# spike[1] 0.28806f
C952 DAC_5__Isum_e a_16310_50504# 0.07931f
C953 neuron_4__VKup a_89534_111502# 0.14581f
C954 a_93348_118168# VMEM_4 0.12888f
C955 a_26214_94846# a_34614_94846# 7.01128f
C956 w[16] DAC_7__Vb 7.05203f
C957 w[19] pulse[1] 0.10988f
C958 DAC_1__Isum_e VMEM_4 0.0248f
C959 w[22] w[10] 0.11402f
C960 spike[1] a_16558_64692# 0.01869f
C961 a_17058_64484# spike[1] 0.37995f
C962 w[0] pulse[0] 0.56155f
C963 a_34614_94846# a_17058_94688# 0.75055f
C964 a_26214_125050# DAC_1__Isum_i 10.8659f
C965 a_93348_39284# a_93976_39284# 0.53841f
C966 w[28] w[29] 32.4394f
C967 s[1] s[4] 0.21024f
C968 s[1] VDD 2.69416f
C969 w[13] w[24] 0.20051f
C970 a_34614_110862# DAC_1__Isum_i 0.11679f
C971 w[8] w[0] 0.19117f
C972 a_88272_118168# VMEM_4 1.71072f
C973 pulse[1] a_16558_32028# 0.01869f
C974 spike[1] neuron_4__VKdn 0.15271f
C975 neuron_4__Vlk bias_0__VT_inh 0.17447f
C976 DAC_1__Isum_e a_34614_125050# 6.81042f
C977 neuron_4__Vlk spike[4] 1.91288f
C978 a_93348_20808# neuron_4__VKup 0.04013f
C979 a_16310_125100# a_19914_125050# 17.2602f
C980 s[1] w[4] 1.07609f
C981 a_22014_80658# DAC_3__Isum_i 12.8867f
C982 a_93976_39284# VDD 2.94927f
C983 a_22014_50454# DAC_7__Vb 0.37182f
C984 VDD a_22014_31978# 13.3088f
C985 w[27] pulse[1] 0.14437f
C986 w[11] DAC_7__Vb 2.73822f
C987 VMEM_4 neuron_4__VIp 0.25899f
C988 a_90542_51444# neuron_4__VKdn 0.04013f
C989 VMEM_0 a_90542_14492# 0.25888f
C990 pulse[1] w[7] 4.0591f
C991 a_26214_94846# a_17058_94688# 0.06004f
C992 a_87734_111852# VT 0.26497f
C993 w[21] w[10] 0.11336f
C994 a_22014_31978# a_19914_31978# 0.57119f
C995 a_16558_125100# DAC_1__Isum_i 1.32914f
C996 a_16310_110912# a_16558_110912# 1.6884f
C997 pulse[1] s[0] 2.04666f
C998 w[8] w[31] 0.38925f
C999 s[7] w[29] 0.43857f
C1000 spike[2] a_90162_51444# 9.68412f
C1001 w[5] w[26] 0.14329f
C1002 pulse[1] w[6] 0.28684f
C1003 VMEM_4 a_90542_111852# 0.25888f
C1004 a_17058_64484# VDD 8.92389f
C1005 VDD a_16558_64692# 0.21115f
C1006 w[18] w[10] 0.11889f
C1007 s[6] w[10] 0.05345f
C1008 VDD a_90542_14492# 0.15438f
C1009 a_89534_51094# a_89914_51444# 0.60758f
C1010 a_34614_110862# a_17058_110704# 0.75055f
C1011 s[1] w[9] 0.19948f
C1012 VDD a_16558_110912# 0.21115f
C1013 VMEM_0 neuron_4__VKdn 0.18457f
C1014 a_17058_13344# w[3] 1.50762f
C1015 a_34614_13502# DAC_7__Vb 0.093f
C1016 neuron_4__Vamp_bias a_90162_51444# 0.08988f
C1017 w[17] w[14] 0.13249f
C1018 neuron_4__VK a_4687_155494# 0.91781f
C1019 DAC_3__Isum_i s[5] 0.01848f
C1020 VMEM_4 a_67078_125606# 6.41445f
C1021 w[12] w[17] 0.28446f
C1022 w[14] s[3] 0.35769f
C1023 w[12] s[3] 27.0014f
C1024 w[24] w[26] 0.08348f
C1025 a_93976_57760# a_90162_51444# 0.04621f
C1026 a_26214_80658# a_16310_80708# 1.78781f
C1027 a_19914_80658# a_16310_80708# 17.2602f
C1028 VDD neuron_4__VKdn 4.63085f
C1029 a_4687_155494# DAC_7__Vb 0.32361f
C1030 a_16310_110912# DAC_1__Isum_i 1.77847f
C1031 a_19914_64642# a_26214_64642# 0.27118f
C1032 DPI_4__Vthr neuron_4__VKdn 0.25644f
C1033 s[2] w[29] 0.2803f
C1034 a_4687_155494# DPI_4__VT 0.13964f
C1035 DAC_7__Vb a_19914_125050# 0.74342f
C1036 w[11] w[2] 0.99768f
C1037 w[13] DAC_7__Vb 1.45f
C1038 w[8] w[5] 1.04482f
C1039 a_90542_51444# a_91170_51444# 1.47502f
C1040 neuron_4__VKdn a_89534_111502# 0.04669f
C1041 a_26214_64642# DAC_5__Isum_i 10.8659f
C1042 VT a_89534_81298# 0.51506f
C1043 neuron_4__VNA a_89534_81298# 0.1689f
C1044 w[11] w[3] 0.37686f
C1045 a_87734_51444# a_89914_51444# 0.02914f
C1046 w[20] w[31] 0.16727f
C1047 VDD DAC_1__Isum_i 18.3562f
C1048 spike[2] neuron_4__VKup 5.15232f
C1049 w[11] w[1] 0.34334f
C1050 neuron_4__Vamp_bias Iref 0.27353f
C1051 DPI_4__Vthr DAC_1__Isum_i 2.8953f
C1052 w[24] w[8] 0.11022f
C1053 a_90162_111852# VDD 3.96172f
C1054 VDD a_93976_118168# 2.94927f
C1055 a_19914_110862# DAC_7__Vb 0.74342f
C1056 DAC_3__Isum_i DAC_3__Isum_e 11.4443f
C1057 neuron_4__Vamp_bias neuron_4__VKup 4.71551f
C1058 s[3] DAC_5__Isum_i 0.01848f
C1059 s[1] s[7] 0.19273f
C1060 a_89534_81298# VMEM_3 3.23701f
C1061 a_90162_111852# a_89534_111502# 14.8965f
C1062 VDD a_67078_65198# 11.616f
C1063 w[23] w[5] 0.1325f
C1064 a_16310_110912# a_17058_110704# 0.10497f
C1065 spike[0] a_17058_80500# 0.37995f
C1066 a_17058_50296# DAC_5__Isum_i 0.05814f
C1067 DPI_4__Vthr a_67078_65198# 2.11209f
C1068 a_22014_64642# a_34614_64642# 0.11882f
C1069 s[5] w[0] 0.59186f
C1070 spike[0] neuron_4__VKup 0.05793f
C1071 VDD a_91170_51444# 0.17724f
C1072 pulse[1] w[22] 0.12687f
C1073 a_34614_50454# DAC_7__Vb 0.093f
C1074 VDD a_16310_32028# 2.32564f
C1075 w[30] w[29] 32.9732f
C1076 a_19914_31978# a_16310_32028# 17.2602f
C1077 w[20] w[5] 0.13044f
C1078 VDD a_17058_110704# 8.84723f
C1079 a_62528_16118# DPI_4__VT 2.10107f
C1080 a_93348_87964# neuron_4__VKup 0.04013f
C1081 VMEM_2 neuron_4__VNA 5.06114f
C1082 w[24] w[23] 15.6775f
C1083 VMEM_2 VT 1.82205f
C1084 DAC_7__Vb w[26] 1.45018f
C1085 a_16310_13552# w[0] 0.01848f
C1086 DAC_5__Isum_e spike[1] 2.04271f
C1087 neuron_4__VNA a_93976_20808# 0.04168f
C1088 VMEM_1 neuron_4__Vlk 0.29877f
C1089 w[29] spike[3] 0.08662f
C1090 w[23] a_16310_94896# 0.364f
C1091 a_16310_32028# w[4] 0.01848f
C1092 a_88272_87964# a_89534_81298# 0.68101f
C1093 w[19] a_17058_80500# 1.50762f
C1094 s[1] s[2] 1.95246f
C1095 w[25] w[5] 0.14311f
C1096 neuron_4__VK VT 3.45873f
C1097 s[5] w[31] 0.1587f
C1098 neuron_4__VNA neuron_4__VK 36.2265f
C1099 a_17058_124892# a_19914_125050# 0.11443f
C1100 w[20] w[24] 0.26009f
C1101 a_88272_57760# a_89914_51444# 0.09468f
C1102 w[15] w[31] 0.1464f
C1103 s[1] a_17058_31820# 3.46922f
C1104 DAC_7__Vb pulse[0] 0.08662f
C1105 w[20] a_16310_94896# 0.01848f
C1106 neuron_4__VNA DAC_7__Vb 0.17425f
C1107 neuron_4__VNA DPI_4__VT 26.1738f
C1108 w[25] w[24] 22.2157f
C1109 w[21] pulse[1] 0.12705f
C1110 neuron_4__VKup spike[3] 0.07591f
C1111 w[29] w[7] 0.12131f
C1112 a_16558_13552# s[0] 0.04246f
C1113 w[8] DAC_7__Vb 7.37243f
C1114 VDD DAC_3__Isum_i 15.2407f
C1115 a_89534_51094# a_87734_51444# 0.9311f
C1116 a_22014_31978# a_17058_31820# 0.05882f
C1117 neuron_4__VK VMEM_3 0.94229f
C1118 w[17] w[10] 0.13197f
C1119 DAC_3__Isum_i s[4] 0.01848f
C1120 DAC_3__Isum_i DPI_4__Vthr 2.8953f
C1121 pulse[1] w[18] 0.108f
C1122 w[10] s[3] 0.02161f
C1123 w[29] w[6] 1.55346f
C1124 pulse[1] s[6] 0.11668f
C1125 spike[2] a_16558_110912# 0.01869f
C1126 w[11] a_17058_13344# 0.03003f
C1127 s[5] w[5] 0.05396f
C1128 a_90162_14492# a_93976_20808# 0.04621f
C1129 w[15] w[5] 0.09262f
C1130 w[3] w[26] 1.55934f
C1131 VDD DAC_5__Isum_e 21.4185f
C1132 DPI_4__VT VMEM_3 0.60257f
C1133 DAC_5__Isum_e DPI_4__Vthr 2.8953f
C1134 s[7] DAC_1__Isum_i 0.01848f
C1135 a_93348_118168# neuron_4__VKup 0.04013f
C1136 neuron_4__VK a_90162_14492# 0.03291f
C1137 DAC_1__Isum_i a_62978_119782# 0.16326f
C1138 w[1] w[26] 0.13813f
C1139 neuron_4__VKdn spike[2] 0.16731f
C1140 w[23] DAC_7__Vb 1.45633f
C1141 spike[0] a_90542_14492# 1.35619f
C1142 s[5] w[24] 0.38296f
C1143 w[2] pulse[0] 0.10229f
C1144 a_17058_13344# a_34614_13502# 0.75055f
C1145 w[24] w[15] 0.13181f
C1146 w[3] pulse[0] 0.99085f
C1147 w[13] w[16] 0.24255f
C1148 neuron_4__Vlk VMEM_4 0.51029f
C1149 a_16558_80708# a_17058_80500# 0.11824f
C1150 neuron_4__Vamp_bias neuron_4__VKdn 21.5086f
C1151 s[1] a_16558_32028# 0.04246f
C1152 w[1] pulse[0] 0.08662f
C1153 a_62528_53070# a_67078_65198# 0.15017f
C1154 w[8] w[2] 0.15232f
C1155 a_16310_64692# a_16558_64692# 1.6884f
C1156 w[17] a_26214_80658# 0.08445f
C1157 w[20] DAC_7__Vb 7.49763f
C1158 a_16310_64692# a_17058_64484# 0.10497f
C1159 spike[0] neuron_4__VKdn 0.15019f
C1160 w[8] w[3] 0.57717f
C1161 VDD a_89914_111852# 0.14568f
C1162 s[4] w[0] 0.06043f
C1163 VDD w[0] 0.0835f
C1164 a_88272_118168# neuron_4__VKup 3.24448f
C1165 w[8] w[1] 0.09841f
C1166 s[1] w[7] 5.59897f
C1167 Iref neuron_4__VIp 20.5274f
C1168 a_89534_51094# a_88272_57760# 0.68101f
C1169 VDD a_34614_64642# 0.19093f
C1170 w[25] DAC_7__Vb 1.45062f
C1171 s[1] s[0] 0.65954f
C1172 a_93348_57760# a_90162_51444# 0.37248f
C1173 w[24] a_34614_110862# 0.04246f
C1174 a_89914_111852# a_89534_111502# 0.60758f
C1175 a_22014_80658# DAC_7__Vb 0.37182f
C1176 a_87734_32968# VMEM_1 0.27205f
C1177 a_91170_51444# spike[2] 1.13486f
C1178 a_26214_125050# a_16310_125100# 1.78781f
C1179 a_90162_111852# neuron_4__Vamp_bias 0.06057f
C1180 s[1] w[6] 0.60645f
C1181 neuron_4__VKup neuron_4__VIp 1.82963f
C1182 a_34614_31978# a_26214_31978# 7.01128f
C1183 spike[2] a_17058_110704# 0.37995f
C1184 a_90162_81648# neuron_4__VKup 0.836f
C1185 VDD w[31] 0.28982f
C1186 w[23] w[3] 0.24784f
C1187 w[31] s[4] 0.1745f
C1188 w[24] spike[1] 0.13423f
C1189 DAC_3__Isum_e a_16310_94896# 0.07931f
C1190 w[16] w[26] 0.12301f
C1191 w[23] w[1] 0.13157f
C1192 a_17058_31820# a_16310_32028# 0.10497f
C1193 VDD a_87734_111852# 0.22723f
C1194 VDD a_62528_113478# 11.805f
C1195 w[20] a_34614_94846# 0.04246f
C1196 w[12] w[14] 0.2472f
C1197 spike[1] a_16310_94896# 0.04246f
C1198 a_22014_31978# w[6] 0.25032f
C1199 DPI_4__Vthr a_62528_113478# 1.25274f
C1200 a_88272_57760# a_87734_51444# 2.33814f
C1201 a_22014_64642# DAC_7__Vb 0.37182f
C1202 a_34614_80658# a_16310_80708# 1.31469f
C1203 neuron_4__VKdn spike[3] 0.1789f
C1204 a_87734_81648# a_89534_81298# 0.9311f
C1205 a_87734_111852# a_89534_111502# 0.9311f
C1206 w[9] w[0] 0.29893f
C1207 s[5] DAC_7__Vb 6.48874f
C1208 a_90162_32968# a_89914_32968# 1.31172f
C1209 w[15] DAC_7__Vb 1.50623f
C1210 a_16558_125100# a_16310_125100# 1.6884f
C1211 a_90542_81648# neuron_4__VKdn 0.04013f
C1212 a_93348_57760# neuron_4__VKup 0.04013f
C1213 w[25] w[3] 0.14074f
C1214 a_62978_59374# DAC_5__Isum_i 0.15476f
C1215 DAC_1__Isum_i spike[3] 0.06832f
C1216 DAC_1__Isum_e a_16558_110912# 2.10366f
C1217 DAC_5__Isum_e a_62528_53070# 7.72842f
C1218 a_90542_14492# a_91170_14492# 1.47502f
C1219 a_26214_125050# DAC_7__Vb 0.18591f
C1220 s[4] w[5] 0.06098f
C1221 VDD w[5] 0.38087f
C1222 w[25] w[1] 0.13813f
C1223 w[24] a_16310_110912# 0.01848f
C1224 a_22014_50454# a_34614_50454# 0.11882f
C1225 w[8] w[16] 0.23965f
C1226 a_89914_81648# VMEM_3 0.1368f
C1227 pulse[1] w[17] 0.23597f
C1228 pulse[1] s[3] 0.14182f
C1229 a_26214_50454# a_17058_50296# 0.06004f
C1230 w[23] a_17058_94688# 1.50762f
C1231 a_17058_80500# a_16310_80708# 0.10497f
C1232 a_17058_13344# pulse[0] 0.37995f
C1233 a_34614_110862# DAC_7__Vb 0.093f
C1234 s[6] w[29] 0.1385f
C1235 a_26214_13502# DAC_7__Vb 0.18591f
C1236 VDD a_89534_81298# 6.11065f
C1237 w[11] w[26] 0.1488f
C1238 VDD w[24] 0.1576f
C1239 w[4] w[5] 7.1498f
C1240 w[24] s[4] 0.15f
C1241 neuron_4__VK spike[1] 0.15762f
C1242 w[28] w[31] 0.08777f
C1243 VDD a_16310_94896# 0.54717f
C1244 a_90542_51444# VMEM_2 0.25888f
C1245 s[5] w[2] 0.05348f
C1246 a_90542_32968# a_89914_32968# 1.82301f
C1247 s[5] w[3] 0.10366f
C1248 a_93348_118168# a_93976_118168# 0.53841f
C1249 DAC_1__Isum_e DAC_1__Isum_i 7.67246f
C1250 a_93348_118168# a_90162_111852# 0.37248f
C1251 w[23] w[16] 0.14073f
C1252 s[7] w[0] 0.47023f
C1253 a_88272_87964# a_89914_81648# 0.09468f
C1254 a_16558_32028# a_16310_32028# 1.6884f
C1255 spike[1] DAC_7__Vb 0.52619f
C1256 w[11] pulse[0] 0.35877f
C1257 VDD a_16310_125100# 0.54717f
C1258 spike[1] DPI_4__VT 0.5516f
C1259 s[5] w[1] 0.35296f
C1260 a_16310_13552# w[2] 0.18228f
C1261 a_34614_31978# DAC_6__Isum_e 6.81042f
C1262 a_17058_50296# a_19914_50454# 0.11443f
C1263 w[9] w[5] 0.61351f
C1264 a_16310_13552# w[3] 0.364f
C1265 VMEM_0 a_93976_20808# 0.93986f
C1266 w[11] w[8] 6.93488f
C1267 w[20] w[16] 0.11273f
C1268 a_19914_64642# DAC_5__Isum_i 0.01896f
C1269 a_16310_32028# w[7] 0.364f
C1270 a_22014_50454# a_16310_50504# 15.0391f
C1271 w[11] a_16310_50504# 0.364f
C1272 a_87734_32968# a_89534_32618# 0.9311f
C1273 w[27] a_17058_110704# 1.50762f
C1274 a_16310_13552# w[1] 0.10002f
C1275 neuron_4__VKdn neuron_4__VIp 70.156f
C1276 s[7] w[31] 7.91396f
C1277 VMEM_0 neuron_4__VK 0.20559f
C1278 a_89534_14142# neuron_4__VKup 0.15239f
C1279 w[28] w[5] 0.87036f
C1280 VDD VMEM_2 6.49584f
C1281 a_16310_32028# w[6] 0.18228f
C1282 a_16310_64692# DAC_5__Isum_e 0.07931f
C1283 w[25] w[16] 0.13176f
C1284 w[9] w[24] 8.22468f
C1285 w[13] w[26] 0.19176f
C1286 VDD a_93976_20808# 2.94927f
C1287 VMEM_2 DPI_4__Vthr 2.71399f
C1288 a_26214_125050# a_17058_124892# 0.06004f
C1289 a_90162_111852# a_88272_118168# 4.40172f
C1290 s[2] w[0] 0.21447f
C1291 neuron_4__VKdn a_90542_111852# 0.04013f
C1292 DAC_1__Isum_e a_17058_110704# 14.2174f
C1293 a_34614_94846# DAC_3__Isum_e 6.81042f
C1294 a_26214_13502# w[1] 0.08445f
C1295 VDD neuron_4__VK 7.99473f
C1296 VMEM_0 DPI_4__VT 0.30011f
C1297 s[5] a_17058_94688# 3.46922f
C1298 s[1] s[6] 0.19998f
C1299 neuron_4__VK DPI_4__Vthr 0.34342f
C1300 neuron_4__VNA a_4687_155494# 0.15709f
C1301 w[14] w[10] 0.25757f
C1302 w[11] w[23] 0.13606f
C1303 a_90162_111852# neuron_4__VIp 0.02258f
C1304 neuron_4__VK a_89534_111502# 0.01248f
C1305 VDD DAC_7__Vb 27.2416f
C1306 spike[1] a_89914_32968# 0.04786f
C1307 s[4] DAC_7__Vb 6.63538f
C1308 DAC_3__Isum_i a_22014_94846# 12.8867f
C1309 DPI_4__Vthr DAC_7__Vb 15.0991f
C1310 VDD DPI_4__VT 0.14878p
C1311 a_62528_113478# spike[2] 0.17023f
C1312 a_19914_31978# DAC_7__Vb 0.74342f
C1313 s[2] w[31] 3.22188f
C1314 DPI_4__Vthr DPI_4__VT 39.1705f
C1315 s[7] w[5] 0.30545f
C1316 w[11] w[20] 0.13916f
C1317 a_90162_111852# a_90542_111852# 0.67211f
C1318 w[28] a_16310_125100# 0.01848f
C1319 DPI_4__VT a_89534_111502# 0.7679f
C1320 a_67078_125606# DAC_1__Isum_i 6.16686f
C1321 a_16558_125100# a_17058_124892# 0.11824f
C1322 s[5] w[16] 2.58113f
C1323 DAC_7__Vb w[4] 7.61812f
C1324 w[15] w[16] 0.88676f
C1325 a_87734_111852# neuron_4__Vamp_bias 0.05117f
C1326 a_26214_94846# DAC_3__Isum_e 2.06134f
C1327 a_16310_64692# a_34614_64642# 1.31469f
C1328 neuron_4__Vlk Iref 2.05665f
C1329 w[11] w[25] 0.1488f
C1330 s[7] w[24] 0.0616f
C1331 a_16558_80708# DAC_3__Isum_i 1.32914f
C1332 s[6] a_16558_110912# 0.04246f
C1333 a_93348_20808# a_93976_20808# 0.53841f
C1334 DAC_3__Isum_e a_17058_94688# 14.2174f
C1335 neuron_4__Vlk neuron_4__VKup 14.5159f
C1336 w[13] w[23] 0.20051f
C1337 VDD a_34614_94846# 0.19093f
C1338 s[2] w[5] 2.16995f
C1339 w[9] DAC_7__Vb 1.55064f
C1340 spike[1] a_17058_94688# 0.37995f
C1341 w[29] s[3] 0.09601f
C1342 s[4] w[2] 0.04131f
C1343 VDD w[2] 0.08809f
C1344 w[8] a_34614_50454# 0.04246f
C1345 w[24] spike[2] 0.08662f
C1346 s[4] w[3] 0.08338f
C1347 VDD w[3] 0.19721f
C1348 a_16310_13552# a_17058_13344# 0.10497f
C1349 a_16310_50504# a_34614_50454# 1.31469f
C1350 VDD a_89914_32968# 0.14568f
C1351 a_62528_34594# VDD 11.5929f
C1352 w[30] w[31] 32.9121f
C1353 VMEM_4 spike[4] 2.75441f
C1354 a_62528_34594# DPI_4__Vthr 1.25274f
C1355 w[13] w[20] 8.2286f
C1356 s[4] w[1] 0.06885f
C1357 VDD w[1] 0.08575f
C1358 w[24] s[2] 0.27872f
C1359 w[8] w[26] 0.12327f
C1360 neuron_4__Vamp_bias a_89534_81298# 0.09962f
C1361 w[28] DAC_7__Vb 6.95216f
C1362 w[31] spike[3] 0.07426f
C1363 w[11] s[5] 0.05355f
C1364 w[2] w[4] 1.00026f
C1365 w[0] w[7] 0.56865f
C1366 VDD a_17058_124892# 8.84723f
C1367 w[3] w[4] 0.46689f
C1368 w[0] s[0] 1.47628f
C1369 DAC_1__Isum_i s[6] 0.01848f
C1370 spike[1] w[16] 0.06128f
C1371 w[13] w[25] 0.19176f
C1372 a_26214_13502# a_17058_13344# 0.06004f
C1373 a_89914_81648# a_87734_81648# 0.02914f
C1374 neuron_4__VNA VT 1.58714f
C1375 w[0] w[6] 0.82316f
C1376 VMEM_2 a_62528_53070# 4.23737f
C1377 w[1] w[4] 0.5394f
C1378 a_89914_51444# a_90162_51444# 1.31172f
C1379 VDD a_26214_94846# 0.26038f
C1380 w[19] w[5] 0.12297f
C1381 a_87734_32968# a_88272_39284# 2.33814f
C1382 a_88272_20808# neuron_4__VKup 3.23931f
C1383 w[30] w[5] 1.63676f
C1384 w[9] w[2] 1.97715f
C1385 w[31] w[7] 0.13006f
C1386 VMEM_2 spike[2] 2.78018f
C1387 w[9] w[3] 0.14972f
C1388 VT VMEM_3 1.70036f
C1389 VDD a_17058_94688# 8.90886f
C1390 s[7] DAC_7__Vb 6.70773f
C1391 a_16310_50504# w[8] 0.01848f
C1392 neuron_4__VNA VMEM_3 4.27759f
C1393 a_16310_13552# a_34614_13502# 1.31469f
C1394 a_88272_118168# a_89914_111852# 0.09468f
C1395 w[31] w[6] 3.42869f
C1396 a_62528_53070# DPI_4__VT 1.39792f
C1397 w[9] w[1] 0.49376f
C1398 neuron_4__VK spike[2] 13.3995f
C1399 a_17058_110704# s[6] 3.46922f
C1400 VDD a_89914_81648# 0.14568f
C1401 w[20] w[26] 17.3804f
C1402 s[1] s[3] 0.34587f
C1403 w[13] s[5] 0.06299f
C1404 VMEM_2 neuron_4__Vamp_bias 2.00815f
C1405 a_62528_113478# DAC_1__Isum_e 7.70074f
C1406 pulse[1] w[14] 1.38079f
C1407 w[13] w[15] 25.6638f
C1408 w[12] pulse[1] 0.73448f
C1409 VDD a_91170_111852# 0.17724f
C1410 a_89534_81298# spike[3] 0.14351f
C1411 DAC_3__Isum_i a_16310_80708# 1.77847f
C1412 a_89914_111852# neuron_4__VIp 0.04013f
C1413 spike[2] DAC_7__Vb 0.48242f
C1414 neuron_4__VNA a_90162_14492# 0.40576f
C1415 w[28] w[1] 0.14293f
C1416 spike[0] VMEM_2 0.02182f
C1417 a_90162_14492# VT 0.07044f
C1418 a_26214_13502# a_34614_13502# 7.01128f
C1419 neuron_4__VK neuron_4__Vamp_bias 5.08579f
C1420 VDD w[16] 0.19195f
C1421 DPI_4__VT spike[2] 0.31375f
C1422 VMEM_2 a_93976_57760# 0.93986f
C1423 w[25] w[26] 21.9939f
C1424 spike[0] a_93976_20808# 0.28806f
C1425 a_17058_64484# a_26214_64642# 0.06004f
C1426 w[16] s[4] 1.40036f
C1427 a_26214_31978# DAC_6__Isum_e 2.06134f
C1428 w[27] w[5] 0.1352f
C1429 w[30] a_16310_125100# 0.18228f
C1430 w[23] w[8] 0.11175f
C1431 a_88272_87964# VT 0.0157f
C1432 a_26214_125050# a_19914_125050# 0.27118f
C1433 w[7] w[5] 0.96516f
C1434 s[2] DAC_7__Vb 10.8191f
C1435 neuron_4__VNA a_88272_87964# 0.33746f
C1436 s[0] w[5] 0.09601f
C1437 neuron_4__Vamp_bias DAC_7__Vb 31.3744f
C1438 spike[0] neuron_4__VK 0.19138f
C1439 a_89914_111852# a_90542_111852# 1.82301f
C1440 a_90162_32968# VT 0.07035f
C1441 neuron_4__Vamp_bias DPI_4__VT 0.27069f
C1442 a_16310_125100# spike[3] 0.04246f
C1443 a_88272_118168# a_87734_111852# 2.33814f
C1444 neuron_4__Vlk neuron_4__VKdn 59.5819f
C1445 a_90162_32968# neuron_4__VNA 0.40552f
C1446 w[6] w[5] 7.77711f
C1447 w[16] w[4] 0.25718f
C1448 s[7] w[2] 0.03426f
C1449 a_90542_14492# a_89914_14492# 1.82301f
C1450 VDD a_17058_13344# 8.90537f
C1451 w[27] w[24] 0.08777f
C1452 w[20] w[8] 0.2156f
C1453 a_22014_94846# a_16310_94896# 15.0391f
C1454 spike[0] DAC_7__Vb 0.66784f
C1455 DAC_5__Isum_e a_16558_50504# 2.10366f
C1456 s[7] w[3] 0.06269f
C1457 w[24] w[7] 0.08987f
C1458 a_16558_64692# s[3] 0.04246f
C1459 spike[0] DPI_4__VT 2.4455f
C1460 VMEM_1 DAC_6__Isum_e 0.0248f
C1461 a_17058_64484# s[3] 3.46922f
C1462 a_26214_50454# DAC_5__Isum_i 10.8659f
C1463 a_88272_87964# VMEM_3 1.71072f
C1464 s[7] w[1] 3.64256f
C1465 a_89534_51094# a_90162_51444# 14.8965f
C1466 w[25] w[8] 0.13217f
C1467 w[24] w[6] 0.13506f
C1468 s[5] w[26] 0.14157f
C1469 a_34614_110862# a_19914_110862# 0.16484f
C1470 s[7] a_17058_124892# 3.46922f
C1471 w[13] spike[1] 0.14714f
C1472 w[15] w[26] 0.12288f
C1473 w[19] DAC_7__Vb 1.66355f
C1474 w[11] VDD 2.38095f
C1475 VDD a_22014_50454# 0.42217f
C1476 a_90542_14492# a_88272_20808# 0.01339f
C1477 w[11] s[4] 0.52839f
C1478 neuron_4__VK spike[3] 0.16365f
C1479 w[20] w[23] 0.37342f
C1480 DAC_1__Isum_e a_16310_125100# 0.07931f
C1481 s[2] w[2] 0.34892f
C1482 w[30] DAC_7__Vb 1.3063f
C1483 a_62528_113478# a_67078_125606# 0.15017f
C1484 s[2] w[3] 0.56415f
C1485 w[28] w[16] 0.14051f
C1486 a_26214_110862# DAC_1__Isum_i 10.8659f
C1487 a_19914_50454# DAC_5__Isum_i 0.01896f
C1488 w[11] w[4] 0.26345f
C1489 a_93976_87964# neuron_4__VNA 0.04168f
C1490 s[2] w[1] 0.89514f
C1491 DAC_7__Vb spike[3] 20.2795f
C1492 DPI_4__VT spike[3] 2.79904f
C1493 VDD a_34614_13502# 0.30771f
C1494 a_19914_80658# a_26214_80658# 0.27118f
C1495 a_16310_13552# pulse[0] 0.04246f
C1496 VMEM_1 a_89534_32618# 3.23701f
C1497 s[5] w[8] 1.0216f
C1498 w[8] w[15] 1.04684f
C1499 a_89534_81298# a_90162_81648# 14.8965f
C1500 s[6] w[0] 0.05055f
C1501 a_89534_51094# neuron_4__VKup 0.1418f
C1502 w[20] w[25] 17.493f
C1503 a_22014_94846# DAC_7__Vb 0.37182f
C1504 VDD a_4687_155494# 37.217f
C1505 DPI_4__Vthr a_4687_155494# 25.5884f
C1506 w[22] w[5] 0.14143f
C1507 w[27] DAC_7__Vb 1.52574f
C1508 a_93976_87964# VMEM_3 0.93986f
C1509 VDD a_19914_125050# 0.75723f
C1510 DAC_7__Vb w[7] 2.4716f
C1511 w[13] VDD 0.32965f
C1512 w[11] w[9] 0.60805f
C1513 spike[1] w[26] 13.2327f
C1514 w[13] s[4] 4.96724f
C1515 s[7] w[16] 0.07641f
C1516 DAC_7__Vb s[0] 6.32731f
C1517 neuron_4__VK a_91170_14492# 0.04013f
C1518 w[19] w[3] 0.1087f
C1519 pulse[1] w[10] 0.19821f
C1520 a_26214_110862# a_17058_110704# 0.06004f
C1521 a_16310_110912# a_19914_110862# 17.2602f
C1522 DAC_1__Isum_e DAC_7__Vb 1.19018f
C1523 DAC_7__Vb w[6] 1.36593f
C1524 w[19] w[1] 0.52804f
C1525 s[6] w[31] 0.1558f
C1526 s[5] w[23] 0.41522f
C1527 w[23] w[15] 0.132f
C1528 w[28] w[11] 0.14993f
C1529 a_34614_31978# a_22014_31978# 0.11882f
C1530 w[30] w[1] 0.13409f
C1531 w[22] a_16310_94896# 0.18228f
C1532 spike[1] VT 0.13048f
C1533 a_22014_13502# a_19914_13502# 0.57119f
C1534 VDD a_19914_110862# 0.75723f
C1535 neuron_4__VNA spike[1] 0.0662f
C1536 w[12] w[29] 0.45575f
C1537 a_16558_13552# DAC_7__Isum_e 2.10366f
C1538 a_90162_32968# a_90542_32968# 0.67211f
C1539 VMEM_2 neuron_4__VIp 0.23607f
C1540 a_62528_16118# VMEM_0 4.23813f
C1541 w[20] s[5] 1.2406f
C1542 Iref bias_0__VT_inh 0.10346f
C1543 w[20] w[15] 2.34965f
C1544 a_88272_57760# a_90162_51444# 4.40172f
C1545 w[21] w[5] 0.13046f
C1546 a_34614_94846# a_22014_94846# 0.11882f
C1547 w[16] s[2] 1.81966f
C1548 a_16310_110912# w[26] 0.18228f
C1549 VT a_87734_81648# 0.26497f
C1550 a_17058_124892# spike[3] 0.37995f
C1551 VDD a_34614_50454# 0.19093f
C1552 a_88272_118168# DPI_4__VT 0.11609f
C1553 DAC_5__Isum_e a_26214_64642# 2.06134f
C1554 DAC_3__Isum_e VMEM_3 0.0248f
C1555 w[25] s[5] 0.38478f
C1556 neuron_4__VK neuron_4__VIp 47.8563f
C1557 bias_0__VT_inh neuron_4__VKup 0.4273f
C1558 VDD a_62528_16118# 11.6146f
C1559 w[25] w[15] 0.12299f
C1560 w[27] w[3] 1.42948f
C1561 w[2] w[7] 0.09608f
C1562 a_62528_16118# DPI_4__Vthr 1.25274f
C1563 w[3] w[7] 0.17019f
C1564 w[18] w[5] 0.11995f
C1565 w[2] s[0] 0.63299f
C1566 s[6] w[5] 0.05264f
C1567 spike[0] w[16] 0.08662f
C1568 w[11] s[7] 0.29188f
C1569 VDD w[26] 0.15988f
C1570 w[3] s[0] 0.9894f
C1571 neuron_4__VIp DAC_7__Vb 0.23515f
C1572 w[27] w[1] 0.13132f
C1573 s[4] w[26] 0.1325f
C1574 a_91170_51444# a_89914_51444# 0.26264f
C1575 w[2] w[6] 0.32451f
C1576 w[1] w[7] 0.86444f
C1577 DPI_4__VT neuron_4__VIp 8.04045f
C1578 s[2] a_17058_13344# 0.01005f
C1579 w[21] a_16310_94896# 0.10002f
C1580 VMEM_0 VT 1.93165f
C1581 w[1] s[0] 1.57373f
C1582 w[3] w[6] 0.28548f
C1583 w[13] w[28] 0.20926f
C1584 a_87734_81648# VMEM_3 0.27205f
C1585 VMEM_2 a_93348_57760# 0.12888f
C1586 w[24] s[6] 1.40814f
C1587 w[23] spike[1] 0.2086f
C1588 w[1] w[6] 1.29582f
C1589 a_26214_94846# a_22014_94846# 0.29412f
C1590 VDD pulse[0] 0.0889f
C1591 VDD VT 0.90162f
C1592 DAC_5__Isum_e a_17058_50296# 14.2174f
C1593 w[19] w[16] 0.66196f
C1594 VDD neuron_4__VNA 36.3738f
C1595 neuron_4__VNA DPI_4__Vthr 0.53964f
C1596 DAC_1__Isum_e a_17058_124892# 14.2174f
C1597 a_88272_57760# neuron_4__VKup 3.23931f
C1598 a_67078_125606# DAC_7__Vb 0.2583f
C1599 a_89914_81648# spike[3] 0.04786f
C1600 a_22014_125050# a_34614_125050# 0.11882f
C1601 w[22] DAC_7__Vb 1.37823f
C1602 VT a_89534_111502# 0.51489f
C1603 w[20] spike[1] 0.20651f
C1604 w[11] s[2] 3.97121f
C1605 DPI_4__VT a_67078_125606# 1.70518f
C1606 neuron_4__VNA a_89534_111502# 0.17882f
C1607 a_90162_32968# spike[1] 9.68412f
C1608 s[5] w[15] 7.36008f
C1609 a_26214_64642# a_34614_64642# 7.01128f
C1610 w[30] w[16] 0.13176f
C1611 w[8] s[4] 0.05423f
C1612 VDD w[8] 0.34194f
C1613 a_17058_94688# a_22014_94846# 0.05882f
C1614 DAC_1__Isum_i a_22014_110862# 12.8867f
C1615 s[1] w[14] 0.30411f
C1616 VDD a_16310_50504# 0.54717f
C1617 s[1] w[12] 0.18191f
C1618 a_90542_81648# a_89914_81648# 1.82301f
C1619 a_88272_87964# a_87734_81648# 2.33814f
C1620 w[25] spike[1] 0.12852f
C1621 w[13] s[7] 0.07267f
C1622 VMEM_1 a_88272_39284# 1.71072f
C1623 w[9] w[26] 0.13126f
C1624 w[11] spike[0] 0.13553f
C1625 VDD VMEM_3 5.15407f
C1626 DPI_4__Vthr VMEM_3 3.05378f
C1627 neuron_4__VIp a_89914_32968# 0.04013f
C1628 w[8] w[4] 0.32288f
C1629 w[0] s[3] 0.01993f
C1630 VMEM_0 a_90162_14492# 0.29575f
C1631 a_34614_31978# a_16310_32028# 1.31469f
C1632 a_93348_39284# a_90162_32968# 0.37248f
C1633 w[23] s[4] 0.15f
C1634 VDD w[23] 0.42095f
C1635 w[27] w[16] 0.13176f
C1636 w[9] pulse[0] 0.07356f
C1637 w[21] DAC_7__Vb 4.07706f
C1638 VDD a_90162_14492# 3.95804f
C1639 w[11] w[19] 0.14577f
C1640 a_17058_110704# a_22014_110862# 0.05882f
C1641 neuron_4__Vamp_bias a_4687_155494# 0.85875f
C1642 spike[1] a_90542_32968# 1.35619f
C1643 a_16310_13552# a_26214_13502# 1.78781f
C1644 w[9] w[8] 7.21115f
C1645 VDD a_88272_87964# 10.7282f
C1646 w[25] a_16310_110912# 0.10002f
C1647 w[31] s[3] 0.16033f
C1648 w[22] w[3] 0.24838f
C1649 w[11] w[30] 0.15868f
C1650 w[18] DAC_7__Vb 1.58911f
C1651 w[9] a_16310_50504# 0.10002f
C1652 s[6] DAC_7__Vb 6.98569f
C1653 s[5] spike[1] 1.94838f
C1654 w[20] s[4] 4.60453f
C1655 VDD w[20] 0.38875f
C1656 VDD a_90162_32968# 3.95783f
C1657 VMEM_1 a_91170_32968# 3.31883f
C1658 spike[1] w[15] 0.13553f
C1659 w[22] w[1] 0.12355f
C1660 a_62528_83274# a_67078_95402# 0.15017f
C1661 neuron_4__VKdn bias_0__VT_inh 0.20895f
C1662 a_17058_13344# w[7] 0.01419f
C1663 neuron_4__VK a_89534_14142# 0.02793f
C1664 w[13] spike[0] 0.06052f
C1665 neuron_4__VKdn spike[4] 0.10816f
C1666 a_17058_13344# s[0] 3.46922f
C1667 VDD w[25] 0.15754f
C1668 w[25] s[4] 0.14125f
C1669 w[28] w[8] 0.12558f
C1670 a_26214_50454# a_19914_50454# 0.27118f
C1671 s[7] w[26] 0.0616f
C1672 w[20] w[4] 0.35383f
C1673 VMEM_1 neuron_4__VKup 0.14837f
C1674 a_22014_80658# VDD 0.42217f
C1675 a_17058_64484# a_19914_64642# 0.11443f
C1676 a_89914_81648# neuron_4__VIp 0.04013f
C1677 a_67078_65198# a_62978_59374# 9.93393f
C1678 w[9] w[23] 0.12425f
C1679 w[11] w[27] 0.14093f
C1680 w[13] a_16310_64692# 0.10002f
C1681 w[17] w[5] 2.93414f
C1682 a_89914_81648# a_90162_81648# 1.31172f
C1683 a_16558_64692# DAC_5__Isum_i 1.32914f
C1684 a_34614_80658# a_26214_80658# 7.01128f
C1685 w[11] w[7] 1.38154f
C1686 a_19914_80658# a_34614_80658# 0.16484f
C1687 w[13] w[19] 0.20524f
C1688 w[5] s[3] 0.02178f
C1689 a_17058_64484# DAC_5__Isum_i 0.05814f
C1690 spike[2] w[26] 0.08662f
C1691 w[21] w[3] 0.11524f
C1692 spike[4] a_93976_118168# 0.28806f
C1693 w[11] s[0] 0.72669f
C1694 a_90162_111852# spike[4] 9.68412f
C1695 a_93348_20808# a_90162_14492# 0.37248f
C1696 w[13] w[30] 0.20602f
C1697 w[9] w[20] 0.1216f
C1698 w[21] w[1] 0.10783f
C1699 w[11] w[6] 0.1364f
C1700 a_91170_111852# a_90542_111852# 1.47502f
C1701 s[6] w[2] 0.0414f
C1702 VDD a_90542_32968# 0.15438f
C1703 VDD a_22014_64642# 0.42217f
C1704 s[2] w[26] 0.26991f
C1705 s[7] w[8] 1.28435f
C1706 s[6] w[3] 0.06991f
C1707 w[18] w[3] 0.123f
C1708 w[24] s[3] 0.08448f
C1709 a_26214_31978# a_22014_31978# 0.29412f
C1710 VDD s[5] 2.51204f
C1711 VDD a_93976_87964# 2.94927f
C1712 s[5] s[4] 1.6701f
C1713 w[15] s[4] 0.19789f
C1714 VDD w[15] 0.4671f
C1715 spike[2] VT 0.1724f
C1716 w[9] w[25] 8.21813f
C1717 s[6] w[1] 0.06045f
C1718 w[18] w[1] 0.21955f
C1719 neuron_4__VNA spike[2] 0.07507f
C1720 w[28] w[20] 0.1215f
C1721 s[1] w[10] 0.52403f
C1722 VMEM_2 neuron_4__Vlk 0.27624f
C1723 a_17058_80500# a_26214_80658# 0.06004f
C1724 a_26214_94846# w[21] 0.08445f
C1725 a_16310_110912# a_34614_110862# 1.31469f
C1726 VDD a_16310_13552# 2.32564f
C1727 a_19914_80658# a_17058_80500# 0.11443f
C1728 a_89534_32618# a_88272_39284# 0.68101f
C1729 s[2] pulse[0] 0.02302f
C1730 w[16] w[22] 0.14088f
C1731 a_26214_125050# VDD 0.26038f
C1732 s[5] w[4] 0.1781f
C1733 neuron_4__Vamp_bias VT 20.9839f
C1734 neuron_4__VNA neuron_4__Vamp_bias 1.36561f
C1735 neuron_4__VK neuron_4__Vlk 20.2004f
C1736 w[15] w[4] 0.10594f
C1737 a_93976_39284# VMEM_1 0.93986f
C1738 w[13] w[27] 0.20051f
C1739 s[7] w[23] 0.0616f
C1740 w[13] w[7] 3.35548f
C1741 w[8] s[2] 5.16177f
C1742 VDD a_34614_110862# 0.19093f
C1743 a_93348_39284# spike[1] 1.98323f
C1744 spike[0] VT 0.13929f
C1745 spike[2] VMEM_3 0.21453f
C1746 VDD a_26214_13502# 11.1263f
C1747 neuron_4__Vlk DAC_7__Vb 31.8808f
C1748 neuron_4__VNA a_93976_57760# 0.04168f
C1749 spike[0] neuron_4__VNA 0.06368f
C1750 VMEM_4 neuron_4__VKup 0.08489f
C1751 neuron_4__Vlk DPI_4__VT 0.24036f
C1752 spike[0] w[8] 0.15659f
C1753 a_26214_64642# DAC_7__Vb 0.18591f
C1754 s[7] w[20] 0.06099f
C1755 w[16] a_16310_80708# 0.01848f
C1756 a_67078_65198# DAC_5__Isum_i 6.12944f
C1757 w[9] s[5] 0.0585f
C1758 neuron_4__Vamp_bias VMEM_3 1.39008f
C1759 w[27] a_19914_110862# 0.56837f
C1760 spike[0] a_16310_50504# 0.04246f
C1761 VDD DAC_3__Isum_e 20.9233f
C1762 DAC_3__Isum_e DPI_4__Vthr 2.8953f
C1763 VDD a_16558_125100# 0.21115f
C1764 spike[1] s[4] 0.24562f
C1765 VDD spike[1] 7.6119f
C1766 DPI_4__Vthr spike[1] 0.095f
C1767 w[21] w[16] 0.12073f
C1768 s[7] w[25] 0.0616f
C1769 w[23] s[2] 0.27956f
C1770 w[28] s[5] 0.15487f
C1771 w[28] w[15] 0.14038f
C1772 a_26214_110862# DAC_7__Vb 0.18591f
C1773 w[17] DAC_7__Vb 6.53486f
C1774 pulse[1] w[29] 2.73637f
C1775 w[11] w[22] 0.13606f
C1776 VMEM_1 neuron_4__VKdn 0.24376f
C1777 w[19] w[8] 8.84234f
C1778 DAC_7__Vb s[3] 6.6298f
C1779 neuron_4__Vamp_bias a_90162_14492# 0.06057f
C1780 VDD a_87734_81648# 0.22723f
C1781 a_93348_87964# VMEM_3 0.12888f
C1782 VDD a_90542_51444# 0.15438f
C1783 w[18] w[16] 0.64568f
C1784 a_89534_32618# neuron_4__VKup 0.14162f
C1785 w[16] s[6] 0.07831f
C1786 neuron_4__VK a_88272_20808# 0.04423f
C1787 a_4687_155494# neuron_4__VIp 0.35566f
C1788 spike[0] w[23] 13.0548f
C1789 neuron_4__VNA spike[3] 0.07696f
C1790 a_17058_50296# DAC_7__Vb 0.01092f
C1791 VT spike[3] 0.15063f
C1792 w[25] spike[2] 0.08662f
C1793 a_88272_87964# neuron_4__Vamp_bias 0.03762f
C1794 w[27] w[26] 18.5141f
C1795 w[30] w[8] 0.14307f
C1796 w[20] s[2] 0.25839f
C1797 spike[0] a_90162_14492# 9.68412f
C1798 w[7] w[26] 0.107f
C1799 a_93348_39284# VDD 2.79898f
C1800 a_90162_32968# neuron_4__Vamp_bias 0.06057f
C1801 VDD VMEM_0 4.44277f
C1802 a_26214_31978# a_16310_32028# 1.78781f
C1803 w[25] s[2] 0.2876f
C1804 VDD a_16310_110912# 0.54717f
C1805 VMEM_0 DPI_4__Vthr 0.06828f
C1806 w[6] w[26] 0.138f
C1807 spike[0] w[20] 0.13752f
C1808 VMEM_2 a_89914_51444# 0.1368f
C1809 s[7] s[5] 0.99904f
C1810 VMEM_3 spike[3] 2.78018f
C1811 s[7] w[15] 0.07685f
C1812 pulse[0] s[0] 1.60436f
C1813 w[11] w[21] 0.14499f
C1814 VDD s[4] 1.97221f
C1815 a_89914_111852# spike[4] 0.04786f
C1816 VDD DPI_4__Vthr 0.12965p
C1817 w[13] w[22] 0.19176f
C1818 w[27] w[8] 0.10555f
C1819 w[3] VSS 15.2389f
C1820 w[2] VSS 6.85336f
C1821 w[1] VSS 7.62883f
C1822 w[0] VSS 5.0036f
C1823 pulse[0] VSS 6.37818f
C1824 s[0] VSS 21.5576f
C1825 w[7] VSS 16.3779f
C1826 w[6] VSS 10.1253f
C1827 w[5] VSS 9.08577f
C1828 w[4] VSS 6.53681f
C1829 pulse[1] VSS 8.00844f
C1830 s[1] VSS 22.9392f
C1831 w[11] VSS 22.7945f
C1832 w[10] VSS 8.47374f
C1833 w[9] VSS 7.31696f
C1834 w[8] VSS 9.50543f
C1835 s[2] VSS 31.3906f
C1836 w[15] VSS 18.7329f
C1837 w[14] VSS 9.01251f
C1838 w[13] VSS 9.12484f
C1839 w[12] VSS 8.54134f
C1840 s[3] VSS 28.4477f
C1841 w[19] VSS 18.888f
C1842 w[18] VSS 8.98404f
C1843 w[17] VSS 8.97333f
C1844 w[16] VSS 19.914f
C1845 spike[0] VSS 57.0293f
C1846 s[4] VSS 27.7416f
C1847 w[23] VSS 19.0585f
C1848 w[22] VSS 10.0909f
C1849 w[21] VSS 16.4699f
C1850 w[20] VSS 10.5874f
C1851 spike[1] VSS 58.0401f
C1852 s[5] VSS 32.2325f
C1853 VT VSS 23.7918f
C1854 w[27] VSS 17.9439f
C1855 w[26] VSS 10.5667f
C1856 w[25] VSS 17.7392f
C1857 w[24] VSS 20.862f
C1858 spike[2] VSS 62.203f
C1859 spike[4] VSS 32.8035f
C1860 s[6] VSS 29.1235f
C1861 w[31] VSS 22.6736f
C1862 w[30] VSS 12.437f
C1863 w[29] VSS 11.147f
C1864 w[28] VSS 11.9426f
C1865 spike[3] VSS 55.1713f
C1866 s[7] VSS 31.5353f
C1867 Iref VSS 0.13218p
C1868 VDD VSS 4.48069p
C1869 a_91170_14492# VSS 4.53886f $ **FLOATING
C1870 a_90542_14492# VSS 3.65994f $ **FLOATING
C1871 a_89914_14492# VSS 5.91238f $ **FLOATING
C1872 a_87734_14492# VSS 5.03265f $ **FLOATING
C1873 a_62528_16118# VSS 9.9446f $ **FLOATING
C1874 a_34614_13502# VSS 5.10168f $ **FLOATING
C1875 a_26214_13502# VSS 9.33535f $ **FLOATING
C1876 a_22014_13502# VSS 16.5225f $ **FLOATING
C1877 a_19914_13502# VSS 43.9107f $ **FLOATING
C1878 a_16558_13552# VSS 2.88389f $ **FLOATING
C1879 a_16310_13552# VSS 9.72397f $ **FLOATING
C1880 a_93976_20808# VSS 0.1558f $ **FLOATING
C1881 VMEM_0 VSS 27.1819f $ **FLOATING
C1882 a_93348_20808# VSS 0.36469f $ **FLOATING
C1883 a_90162_14492# VSS 4.59089f $ **FLOATING
C1884 a_89534_14142# VSS 7.31948f $ **FLOATING
C1885 a_88272_20808# VSS 4.46601f $ **FLOATING
C1886 a_17058_13344# VSS 9.84118f $ **FLOATING
C1887 a_91170_32968# VSS 4.53886f $ **FLOATING
C1888 a_90542_32968# VSS 3.65994f $ **FLOATING
C1889 a_89914_32968# VSS 5.91238f $ **FLOATING
C1890 a_87734_32968# VSS 5.03265f $ **FLOATING
C1891 a_62528_34594# VSS 9.96068f $ **FLOATING
C1892 a_34614_31978# VSS 5.10168f $ **FLOATING
C1893 a_26214_31978# VSS 9.33535f $ **FLOATING
C1894 a_22014_31978# VSS 16.5225f $ **FLOATING
C1895 a_19914_31978# VSS 43.9107f $ **FLOATING
C1896 a_16558_32028# VSS 2.88389f $ **FLOATING
C1897 a_16310_32028# VSS 9.72397f $ **FLOATING
C1898 a_93976_39284# VSS 0.1558f $ **FLOATING
C1899 VMEM_1 VSS 25.8967f $ **FLOATING
C1900 a_93348_39284# VSS 0.36469f $ **FLOATING
C1901 a_90162_32968# VSS 4.6117f $ **FLOATING
C1902 a_89534_32618# VSS 7.34925f $ **FLOATING
C1903 a_88272_39284# VSS 4.48872f $ **FLOATING
C1904 a_17058_31820# VSS 9.82687f $ **FLOATING
C1905 a_91170_51444# VSS 4.53886f $ **FLOATING
C1906 a_90542_51444# VSS 3.65994f $ **FLOATING
C1907 a_89914_51444# VSS 5.91238f $ **FLOATING
C1908 a_87734_51444# VSS 5.03265f $ **FLOATING
C1909 a_62528_53070# VSS 9.81856f $ **FLOATING
C1910 a_34614_50454# VSS 5.10168f $ **FLOATING
C1911 a_26214_50454# VSS 9.33535f $ **FLOATING
C1912 a_22014_50454# VSS 16.5225f $ **FLOATING
C1913 a_19914_50454# VSS 43.9107f $ **FLOATING
C1914 a_16558_50504# VSS 2.88389f $ **FLOATING
C1915 a_16310_50504# VSS 9.72397f $ **FLOATING
C1916 a_93976_57760# VSS 0.1558f $ **FLOATING
C1917 a_93348_57760# VSS 0.36469f $ **FLOATING
C1918 a_90162_51444# VSS 4.58399f $ **FLOATING
C1919 a_89534_51094# VSS 7.32779f $ **FLOATING
C1920 a_88272_57760# VSS 4.47347f $ **FLOATING
C1921 VMEM_2 VSS 33.5651f $ **FLOATING
C1922 a_17058_50296# VSS 9.82629f $ **FLOATING
C1923 a_62978_59374# VSS 16.6941f $ **FLOATING
C1924 a_67078_65198# VSS 13.1702f $ **FLOATING
C1925 a_34614_64642# VSS 5.10168f $ **FLOATING
C1926 a_26214_64642# VSS 9.33535f $ **FLOATING
C1927 a_22014_64642# VSS 16.5225f $ **FLOATING
C1928 a_19914_64642# VSS 43.9107f $ **FLOATING
C1929 a_16558_64692# VSS 2.88389f $ **FLOATING
C1930 a_16310_64692# VSS 9.72397f $ **FLOATING
C1931 a_17058_64484# VSS 9.81068f $ **FLOATING
C1932 a_91170_81648# VSS 4.53886f $ **FLOATING
C1933 a_90542_81648# VSS 3.65994f $ **FLOATING
C1934 a_89914_81648# VSS 5.91238f $ **FLOATING
C1935 a_87734_81648# VSS 5.03265f $ **FLOATING
C1936 a_62528_83274# VSS 10.2696f $ **FLOATING
C1937 a_34614_80658# VSS 5.10168f $ **FLOATING
C1938 a_26214_80658# VSS 9.33535f $ **FLOATING
C1939 a_22014_80658# VSS 16.5225f $ **FLOATING
C1940 a_19914_80658# VSS 43.9107f $ **FLOATING
C1941 a_16558_80708# VSS 2.88389f $ **FLOATING
C1942 a_16310_80708# VSS 9.72397f $ **FLOATING
C1943 a_93976_87964# VSS 0.1558f $ **FLOATING
C1944 a_93348_87964# VSS 0.36469f $ **FLOATING
C1945 a_90162_81648# VSS 4.59032f $ **FLOATING
C1946 a_89534_81298# VSS 7.32187f $ **FLOATING
C1947 a_88272_87964# VSS 4.45951f $ **FLOATING
C1948 VMEM_3 VSS 35.0683f $ **FLOATING
C1949 a_17058_80500# VSS 9.82641f $ **FLOATING
C1950 a_62978_89578# VSS 16.6889f $ **FLOATING
C1951 a_67078_95402# VSS 13.1153f $ **FLOATING
C1952 a_34614_94846# VSS 5.10168f $ **FLOATING
C1953 a_26214_94846# VSS 9.33535f $ **FLOATING
C1954 a_22014_94846# VSS 16.5225f $ **FLOATING
C1955 a_19914_94846# VSS 43.9107f $ **FLOATING
C1956 a_16558_94896# VSS 2.88389f $ **FLOATING
C1957 a_16310_94896# VSS 9.72397f $ **FLOATING
C1958 a_17058_94688# VSS 9.83244f $ **FLOATING
C1959 a_91170_111852# VSS 4.53886f $ **FLOATING
C1960 a_90542_111852# VSS 3.65994f $ **FLOATING
C1961 a_89914_111852# VSS 5.91238f $ **FLOATING
C1962 a_87734_111852# VSS 5.03265f $ **FLOATING
C1963 a_62528_113478# VSS 10.1567f $ **FLOATING
C1964 a_34614_110862# VSS 5.10168f $ **FLOATING
C1965 a_26214_110862# VSS 9.33535f $ **FLOATING
C1966 a_22014_110862# VSS 16.5225f $ **FLOATING
C1967 a_19914_110862# VSS 43.9107f $ **FLOATING
C1968 a_16558_110912# VSS 2.88389f $ **FLOATING
C1969 a_16310_110912# VSS 9.72397f $ **FLOATING
C1970 a_93976_118168# VSS 0.1558f $ **FLOATING
C1971 a_93348_118168# VSS 0.36469f $ **FLOATING
C1972 a_90162_111852# VSS 4.5174f $ **FLOATING
C1973 a_89534_111502# VSS 7.06891f $ **FLOATING
C1974 a_88272_118168# VSS 4.43928f $ **FLOATING
C1975 VMEM_4 VSS 35.645f $ **FLOATING
C1976 a_17058_110704# VSS 9.86847f $ **FLOATING
C1977 a_62978_119782# VSS 16.6244f $ **FLOATING
C1978 a_67078_125606# VSS 12.8962f $ **FLOATING
C1979 a_34614_125050# VSS 5.10168f $ **FLOATING
C1980 a_26214_125050# VSS 9.33535f $ **FLOATING
C1981 a_22014_125050# VSS 16.5225f $ **FLOATING
C1982 a_19914_125050# VSS 43.9107f $ **FLOATING
C1983 a_16558_125100# VSS 2.88389f $ **FLOATING
C1984 a_16310_125100# VSS 9.72397f $ **FLOATING
C1985 a_17058_124892# VSS 9.86051f $ **FLOATING
C1986 bias_0__VT_inh VSS 41.403f $ **FLOATING
C1987 neuron_4__Vlk VSS 68.688f $ **FLOATING
C1988 neuron_4__VNA VSS 39.0149f $ **FLOATING
C1989 neuron_4__VKup VSS 53.6299f $ **FLOATING
C1990 DPI_4__VT VSS 0.11223p $ **FLOATING
C1991 DPI_4__Vthr VSS 0.12332p $ **FLOATING
C1992 neuron_4__VIp VSS 42.6212f $ **FLOATING
C1993 neuron_4__Vamp_bias VSS 68.85279f $ **FLOATING
C1994 neuron_4__VK VSS 0.10097p $ **FLOATING
C1995 DAC_7__Vb VSS 0.71446p $ **FLOATING
C1996 neuron_4__VKdn VSS 48.1415f $ **FLOATING
C1997 a_4687_155494# VSS 13.5947f $ **FLOATING
C1998 DAC_7__Isum_e VSS 17.2603f $ **FLOATING
C1999 DAC_6__Isum_e VSS 17.7405f $ **FLOATING
C2000 DAC_5__Isum_e VSS 21.5617f $ **FLOATING
C2001 DAC_5__Isum_i VSS 29.1939f $ **FLOATING
C2002 DAC_3__Isum_e VSS 22.802f $ **FLOATING
C2003 DAC_3__Isum_i VSS 29.1301f $ **FLOATING
C2004 DAC_1__Isum_e VSS 23.2855f $ **FLOATING
C2005 DAC_1__Isum_i VSS 30.1867f $ **FLOATING
.ends
