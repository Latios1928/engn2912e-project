* NGSPICE file created from SNN_signed_flat__ext - technology: gf180mcuD

.subckt SNN_signed_flat w[31] w[30] w[29] w[28] w[27] w[26] w[25] w[24] w[23] w[22]  w[21] w[20] w[19] w[18] w[17] w[16] w[15] w[14] w[13] w[12] w[11] w[10] w[9] w[8]  w[7] w[6] w[5] w[4] w[3] w[2] w[1] w[0] s[7] s[6] s[5] s[4] s[3] s[2] s[1] s[0]  pulse[1] pulse[0] VDD VSS VT spike[4] spike[3] spike[2] spike[1] spike[0] Iref
X23 bias_0__VT_inh bias_0__VT_inh VDD VDD pfet_03v3 ad=0.2464p pd=1.44u as=0.2464p ps=1.44u w=0.88u l=1.12u
X24 a_16310_94896# w[22] a_22014_94846# VSS nfet_03v3 ad=0.14p pd=1.06u as=0.3p ps=2.2u w=0.5u l=0.64u
X32 VDD s[1] a_16558_32028# VSS nfet_03v3 ad=0.3p pd=2.2u as=0.3p ps=2.2u w=0.5u l=0.64u
X35 VDD neuron_4__VKup neuron_4__VKup VDD pfet_03v3 ad=0.6p pd=3.2u as=0.6p ps=3.2u w=1u l=8u
X39 a_16310_94896# w[23] a_19914_94846# VSS nfet_03v3 ad=0.14p pd=1.06u as=0.14p ps=1.06u w=0.5u l=0.64u
X55 a_19914_50454# DAC_7__Vb VSS VSS nfet_03v3 ad=0.6p pd=3.2u as=0.6p ps=3.2u w=1u l=8u
X64 VDD neuron_4__VKup a_93348_57760# VDD pfet_03v3 ad=0.6p pd=3.2u as=0.6p ps=3.2u w=1u l=1u
X66 VDD a_88272_87964# a_88272_87964# VDD pfet_03v3 ad=0.3p pd=2.2u as=0.3p ps=2.2u w=0.5u l=8u
X76 a_19914_80658# DAC_7__Vb VSS VSS nfet_03v3 ad=0.6p pd=3.2u as=0.6p ps=3.2u w=1u l=8u
X81 a_93976_57760# a_90162_51444# VMEM_2 VDD pfet_03v3 ad=0.3p pd=2.2u as=0.3p ps=2.2u w=0.5u l=0.64u
X125 a_19914_110862# w[27] a_16310_110912# VSS nfet_03v3 ad=0.14p pd=1.06u as=0.14p ps=1.06u w=0.5u l=0.64u
X128 a_22014_31978# DAC_7__Vb VSS VSS nfet_03v3 ad=0.6p pd=3.2u as=0.6p ps=3.2u w=1u l=8u
X133 VDD a_88272_57760# a_89534_51094# VDD pfet_03v3 ad=0.3p pd=2.2u as=0.3p ps=2.2u w=0.5u l=8u
X136 VMEM_3 neuron_4__Vlk VSS VSS nfet_03v3 ad=0.6p pd=3.2u as=0.6p ps=3.2u w=1u l=1u
X137 a_16310_94896# w[20] a_34614_94846# VSS nfet_03v3 ad=0.3p pd=2.2u as=0.3p ps=2.2u w=0.5u l=0.64u
X138 a_19914_125050# DAC_7__Vb VSS VSS nfet_03v3 ad=0.6p pd=3.2u as=0.6p ps=3.2u w=1u l=8u
X139 a_22014_31978# w[6] a_16310_32028# VSS nfet_03v3 ad=0.14p pd=1.06u as=0.14p ps=1.06u w=0.5u l=0.64u
X151 a_16310_125100# w[31] a_19914_125050# VSS nfet_03v3 ad=0.14p pd=1.06u as=0.14p ps=1.06u w=0.5u l=0.64u
X153 VDD DPI_4__VT a_62528_16118# VDD pfet_03v3 ad=2.4p pd=9.2u as=2.4p ps=9.2u w=4u l=5.12u
X156 VDD DPI_4__VT DPI_4__VT VDD pfet_03v3 ad=1.12p pd=4.56u as=1.12p ps=4.56u w=4u l=5.12u
X164 a_22014_64642# DAC_7__Vb VSS VSS nfet_03v3 ad=0.6p pd=3.2u as=0.6p ps=3.2u w=1u l=8u
X169 a_22014_80658# DAC_7__Vb VSS VSS nfet_03v3 ad=0.6p pd=3.2u as=0.6p ps=3.2u w=1u l=8u
X174 VDD neuron_4__VNA a_93976_87964# VDD pfet_03v3 ad=0.6p pd=3.2u as=0.6p ps=3.2u w=1u l=1u
X175 DPI_4__VT DPI_4__VT VDD VDD pfet_03v3 ad=1.12p pd=4.56u as=1.12p ps=4.56u w=4u l=5.12u
X179 a_88272_39284# VMEM_1 a_87734_32968# VSS nfet_03v3 ad=2.4p pd=9.2u as=2.4p ps=9.2u w=4u l=2u
X212 VDD bias_0__VT_inh bias_0__VT_inh VDD pfet_03v3 ad=0.2464p pd=1.44u as=0.2464p ps=1.44u w=0.88u l=1.12u
X216 DPI_4__Vthr DPI_4__Vthr VDD VDD pfet_03v3 ad=1.12p pd=4.56u as=1.12p ps=4.56u w=4u l=5.12u
X218 a_16310_110912# w[25] a_26214_110862# VSS nfet_03v3 ad=0.14p pd=1.06u as=0.3p ps=2.2u w=0.5u l=0.64u
X224 a_19914_64642# DAC_7__Vb VSS VSS nfet_03v3 ad=0.6p pd=3.2u as=0.6p ps=3.2u w=1u l=8u
X225 DPI_4__VT DPI_4__VT VDD VDD pfet_03v3 ad=1.12p pd=4.56u as=1.12p ps=4.56u w=4u l=5.12u
X230 DPI_4__VT DPI_4__VT VDD VDD pfet_03v3 ad=1.12p pd=4.56u as=1.12p ps=4.56u w=4u l=5.12u
X239 a_22014_31978# w[6] a_16310_32028# VSS nfet_03v3 ad=0.3p pd=2.2u as=0.14p ps=1.06u w=0.5u l=0.64u
X240 a_19914_94846# DAC_7__Vb VSS VSS nfet_03v3 ad=0.6p pd=3.2u as=0.6p ps=3.2u w=1u l=8u
X253 a_19914_110862# DAC_7__Vb VSS VSS nfet_03v3 ad=0.6p pd=3.2u as=0.6p ps=3.2u w=1u l=8u
X259 a_19914_31978# w[7] a_16310_32028# VSS nfet_03v3 ad=0.14p pd=1.06u as=0.14p ps=1.06u w=0.5u l=0.64u
X267 DAC_1__Isum_i s[6] a_16558_110912# VSS nfet_03v3 ad=0.3p pd=2.2u as=0.3p ps=2.2u w=0.5u l=0.64u
X268 a_34614_31978# DAC_7__Vb VSS VSS nfet_03v3 ad=0.6p pd=3.2u as=0.6p ps=3.2u w=1u l=8u
X270 a_91170_32968# neuron_4__VK VSS VSS nfet_03v3 ad=0.6p pd=3.2u as=0.6p ps=3.2u w=1u l=1u
X272 DPI_4__Vthr DPI_4__Vthr VDD VDD pfet_03v3 ad=1.12p pd=4.56u as=1.12p ps=4.56u w=4u l=5.12u
X285 DPI_4__VT DPI_4__VT VDD VDD pfet_03v3 ad=1.12p pd=4.56u as=1.12p ps=4.56u w=4u l=5.12u
X288 VMEM_1 VSS cap_mim_2f0_m4m5_noshield c_width=22.18u c_length=22.18u
X289 a_19914_94846# w[23] a_16310_94896# VSS nfet_03v3 ad=0.14p pd=1.06u as=0.14p ps=1.06u w=0.5u l=0.64u
X291 a_19914_13502# DAC_7__Vb VSS VSS nfet_03v3 ad=0.6p pd=3.2u as=0.6p ps=3.2u w=1u l=8u
X299 VDD a_62528_53070# VMEM_2 VDD pfet_03v3 ad=2.4p pd=9.2u as=2.4p ps=9.2u w=4u l=5.12u
X305 a_26214_125050# DAC_7__Vb VSS VSS nfet_03v3 ad=0.6p pd=3.2u as=0.6p ps=3.2u w=1u l=8u
X306 a_22014_94846# DAC_7__Vb VSS VSS nfet_03v3 ad=0.6p pd=3.2u as=0.6p ps=3.2u w=1u l=8u
X318 DAC_1__Isum_e a_17058_124892# a_16558_125100# VSS nfet_03v3 ad=0.3p pd=2.2u as=0.3p ps=2.2u w=0.5u l=0.64u
X319 neuron_4__VKdn neuron_4__VKdn VSS VSS nfet_03v3 ad=0.28p pd=1.56u as=0.28p ps=1.56u w=1u l=1u
X324 VDD s[1] a_17058_31820# VDD pfet_03v3 ad=0.3p pd=2.2u as=0.3p ps=2.2u w=0.5u l=0.32u
X341 a_19914_110862# w[27] a_16310_110912# VSS nfet_03v3 ad=0.3p pd=2.2u as=0.14p ps=1.06u w=0.5u l=0.64u
X342 a_62528_53070# a_62528_53070# DAC_5__Isum_e DAC_5__Isum_e nfet_03v3 ad=2.4p pd=9.2u as=2.4p ps=9.2u w=4u l=5.12u
X350 DAC_3__Isum_e a_17058_80500# a_16558_80708# VSS nfet_03v3 ad=0.3p pd=2.2u as=0.3p ps=2.2u w=0.5u l=0.64u
X351 VDD a_4687_155814# a_4687_155814# VDD pfet_03v3 ad=6p pd=21.2u as=6p ps=21.2u w=10u l=8u
X355 VSS neuron_4__VKdn neuron_4__VKdn VSS nfet_03v3 ad=0.6p pd=3.2u as=0.28p ps=1.56u w=1u l=1u
X359 a_19914_31978# w[7] a_16310_32028# VSS nfet_03v3 ad=0.3p pd=2.2u as=0.14p ps=1.06u w=0.5u l=0.64u
X374 a_17058_80500# s[4] VSS VSS nfet_03v3 ad=0.3p pd=2.2u as=0.3p ps=2.2u w=0.5u l=0.64u
X378 VSS neuron_4__Vlk neuron_4__Vlk VSS nfet_03v3 ad=0.6p pd=3.2u as=0.28p ps=1.56u w=1u l=1u
X380 a_93348_118168# a_90162_111852# spike[4] VDD pfet_03v3 ad=0.3p pd=2.2u as=0.3p ps=2.2u w=0.5u l=0.64u
X381 a_89534_32618# VT a_87734_32968# VSS nfet_03v3 ad=2.4p pd=9.2u as=2.4p ps=9.2u w=4u l=2u
X382 DAC_5__Isum_e a_17058_64484# a_16558_64692# VSS nfet_03v3 ad=0.3p pd=2.2u as=0.3p ps=2.2u w=0.5u l=0.64u
X393 VDD s[0] a_16558_13552# VSS nfet_03v3 ad=0.3p pd=2.2u as=0.3p ps=2.2u w=0.5u l=0.64u
X398 a_17058_64484# s[3] VSS VSS nfet_03v3 ad=0.3p pd=2.2u as=0.3p ps=2.2u w=0.5u l=0.64u
X418 a_19914_125050# w[31] a_16310_125100# VSS nfet_03v3 ad=0.14p pd=1.06u as=0.14p ps=1.06u w=0.5u l=0.64u
X419 VDD DPI_4__VT DPI_4__VT VDD pfet_03v3 ad=1.12p pd=4.56u as=1.12p ps=4.56u w=4u l=5.12u
X424 a_19914_50454# DAC_7__Vb VSS VSS nfet_03v3 ad=0.6p pd=3.2u as=0.6p ps=3.2u w=1u l=8u
X443 a_19914_80658# DAC_7__Vb VSS VSS nfet_03v3 ad=0.6p pd=3.2u as=0.6p ps=3.2u w=1u l=8u
X448 VDD a_62528_16118# cap_mim_2f0_m4m5_noshield c_width=22.18u c_length=22.18u
X462 a_22014_13502# w[2] a_16310_13552# VSS nfet_03v3 ad=0.14p pd=1.06u as=0.14p ps=1.06u w=0.5u l=0.64u
X465 VDD DPI_4__Vthr DPI_4__Vthr VDD pfet_03v3 ad=1.12p pd=4.56u as=1.12p ps=4.56u w=4u l=5.12u
X471 a_26214_80658# w[17] a_16310_80708# VSS nfet_03v3 ad=0.3p pd=2.2u as=0.14p ps=1.06u w=0.5u l=0.64u
X485 a_90162_32968# a_89534_32618# a_89914_32968# VSS nfet_03v3 ad=0.3p pd=2.2u as=0.3p ps=2.2u w=0.5u l=0.64u
X490 DAC_5__Isum_i s[2] a_16558_50504# VSS nfet_03v3 ad=0.3p pd=2.2u as=0.3p ps=2.2u w=0.5u l=0.64u
X494 VMEM_3 spike[3] a_91170_81648# VSS nfet_03v3 ad=0.3p pd=2.2u as=0.3p ps=2.2u w=0.5u l=11.36u
X497 a_26214_50454# DAC_7__Vb VSS VSS nfet_03v3 ad=0.6p pd=3.2u as=0.6p ps=3.2u w=1u l=8u
X508 a_26214_64642# w[13] a_16310_64692# VSS nfet_03v3 ad=0.3p pd=2.2u as=0.14p ps=1.06u w=0.5u l=0.64u
X510 a_22014_80658# DAC_7__Vb VSS VSS nfet_03v3 ad=0.6p pd=3.2u as=0.6p ps=3.2u w=1u l=8u
X513 a_16310_125100# w[29] a_26214_125050# VSS nfet_03v3 ad=0.14p pd=1.06u as=0.3p ps=2.2u w=0.5u l=0.64u
X526 VMEM_2 VSS cap_mim_2f0_m4m5_noshield c_width=22.18u c_length=22.18u
X533 VDD a_62528_113478# cap_mim_2f0_m4m5_noshield c_width=22.18u c_length=22.18u
X534 VDD neuron_4__VKup a_93348_118168# VDD pfet_03v3 ad=0.6p pd=3.2u as=0.6p ps=3.2u w=1u l=1u
X542 a_19914_94846# w[23] a_16310_94896# VSS nfet_03v3 ad=0.14p pd=1.06u as=0.14p ps=1.06u w=0.5u l=0.64u
X547 VDD DPI_4__VT DPI_4__VT VDD pfet_03v3 ad=2.4p pd=9.2u as=1.12p ps=4.56u w=4u l=5.12u
X548 a_19914_31978# DAC_7__Vb VSS VSS nfet_03v3 ad=0.6p pd=3.2u as=0.6p ps=3.2u w=1u l=8u
X551 a_19914_125050# DAC_7__Vb VSS VSS nfet_03v3 ad=0.6p pd=3.2u as=0.6p ps=3.2u w=1u l=8u
X560 a_90542_81648# neuron_4__VKdn VSS VSS nfet_03v3 ad=0.6p pd=3.2u as=0.6p ps=3.2u w=1u l=1u
X564 DAC_1__Isum_i s[7] a_16558_125100# VSS nfet_03v3 ad=0.3p pd=2.2u as=0.3p ps=2.2u w=0.5u l=0.64u
X569 VDD a_89534_81298# a_90162_81648# VDD pfet_03v3 ad=0.3p pd=2.2u as=0.3p ps=2.2u w=0.5u l=0.64u
X570 a_22014_13502# w[2] a_16310_13552# VSS nfet_03v3 ad=0.3p pd=2.2u as=0.14p ps=1.06u w=0.5u l=0.64u
X575 bias_0__VT_inh bias_0__VT_inh VDD VDD pfet_03v3 ad=0.2464p pd=1.44u as=0.2464p ps=1.44u w=0.88u l=1.12u
X576 a_22014_50454# w[10] a_16310_50504# VSS nfet_03v3 ad=0.14p pd=1.06u as=0.14p ps=1.06u w=0.5u l=0.64u
X577 VMEM_2 a_62978_59374# VSS VSS nfet_03v3 ad=1.44p pd=6u as=1.44p ps=6u w=2.4u l=8u
X580 a_19914_64642# DAC_7__Vb VSS VSS nfet_03v3 ad=0.6p pd=3.2u as=0.6p ps=3.2u w=1u l=8u
X583 VDD a_4687_155814# neuron_4__Vlk VDD pfet_03v3 ad=0.504p pd=2.88u as=0.504p ps=2.88u w=0.84u l=16u
X588 a_19914_13502# w[3] a_16310_13552# VSS nfet_03v3 ad=0.14p pd=1.06u as=0.14p ps=1.06u w=0.5u l=0.64u
X596 a_19914_94846# DAC_7__Vb VSS VSS nfet_03v3 ad=0.6p pd=3.2u as=0.6p ps=3.2u w=1u l=8u
X604 DPI_4__Vthr DPI_4__Vthr VDD VDD pfet_03v3 ad=1.12p pd=4.56u as=1.12p ps=4.56u w=4u l=5.12u
X607 neuron_4__VKup Iref VSS VSS nfet_03v3 ad=3.606p pd=13.22u as=3.606p ps=13.22u w=6.01u l=8u
X639 a_62978_59374# a_62978_59374# VSS VSS nfet_03v3 ad=1.2p pd=5.2u as=1.2p ps=5.2u w=2u l=8u
X640 a_26214_64642# DAC_7__Vb VSS VSS nfet_03v3 ad=0.6p pd=3.2u as=0.6p ps=3.2u w=1u l=8u
X641 a_19914_125050# w[31] a_16310_125100# VSS nfet_03v3 ad=0.3p pd=2.2u as=0.14p ps=1.06u w=0.5u l=0.64u
X653 a_19914_13502# DAC_7__Vb VSS VSS nfet_03v3 ad=0.6p pd=3.2u as=0.6p ps=3.2u w=1u l=8u
X655 a_88272_20808# VMEM_0 a_87734_14492# VSS nfet_03v3 ad=2.4p pd=9.2u as=2.4p ps=9.2u w=4u l=2u
X659 a_22014_94846# DAC_7__Vb VSS VSS nfet_03v3 ad=0.6p pd=3.2u as=0.6p ps=3.2u w=1u l=8u
X663 DPI_4__Vthr DPI_4__Vthr VDD VDD pfet_03v3 ad=1.12p pd=4.56u as=1.12p ps=4.56u w=4u l=5.12u
X669 VDD bias_0__VT_inh bias_0__VT_inh VDD pfet_03v3 ad=0.2464p pd=1.44u as=0.2464p ps=1.44u w=0.88u l=1.12u
X672 a_22014_50454# w[10] a_16310_50504# VSS nfet_03v3 ad=0.3p pd=2.2u as=0.14p ps=1.06u w=0.5u l=0.64u
X676 DPI_4__VT DPI_4__VT VDD VDD pfet_03v3 ad=1.12p pd=4.56u as=1.12p ps=4.56u w=4u l=5.12u
X685 a_19914_13502# w[3] a_16310_13552# VSS nfet_03v3 ad=0.3p pd=2.2u as=0.14p ps=1.06u w=0.5u l=0.64u
X689 a_19914_50454# w[11] a_16310_50504# VSS nfet_03v3 ad=0.14p pd=1.06u as=0.14p ps=1.06u w=0.5u l=0.64u
X697 a_4687_155814# Iref VSS VSS nfet_03v3 ad=6p pd=21.2u as=6p ps=21.2u w=10u l=8u
X711 a_89914_111852# neuron_4__VIp VSS VSS nfet_03v3 ad=0.6p pd=3.2u as=0.6p ps=3.2u w=1u l=1u
X713 VDD neuron_4__VKup a_93348_20808# VDD pfet_03v3 ad=0.6p pd=3.2u as=0.6p ps=3.2u w=1u l=1u
X715 a_16310_32028# w[6] a_22014_31978# VSS nfet_03v3 ad=0.14p pd=1.06u as=0.14p ps=1.06u w=0.5u l=0.64u
X717 a_26214_13502# DAC_7__Vb VSS VSS nfet_03v3 ad=0.6p pd=3.2u as=0.6p ps=3.2u w=1u l=8u
X727 a_22014_110862# DAC_7__Vb VSS VSS nfet_03v3 ad=0.6p pd=3.2u as=0.6p ps=3.2u w=1u l=8u
X728 a_22014_50454# DAC_7__Vb VSS VSS nfet_03v3 ad=0.6p pd=3.2u as=0.6p ps=3.2u w=1u l=8u
X734 a_16558_32028# pulse[1] a_16310_32028# VSS nfet_03v3 ad=0.3p pd=2.2u as=0.3p ps=2.2u w=0.5u l=0.64u
X739 a_16310_32028# w[7] a_19914_31978# VSS nfet_03v3 ad=0.14p pd=1.06u as=0.14p ps=1.06u w=0.5u l=0.64u
X740 DPI_4__VT DPI_4__VT VDD VDD pfet_03v3 ad=1.12p pd=4.56u as=2.4p ps=9.2u w=4u l=5.12u
X741 VDD bias_0__VT_inh bias_0__VT_inh VDD pfet_03v3 ad=0.528p pd=2.96u as=0.2464p ps=1.44u w=0.88u l=1.12u
X745 a_88272_118168# VMEM_4 a_87734_111852# VSS nfet_03v3 ad=2.4p pd=9.2u as=2.4p ps=9.2u w=4u l=2u
X754 VDD DPI_4__Vthr DAC_3__Isum_i DAC_3__Isum_i nfet_03v3 ad=2.4p pd=9.2u as=2.4p ps=9.2u w=4u l=5.12u
X763 a_67118_143686# neuron_4__VK VSS VSS nfet_03v3 ad=0.3p pd=2.2u as=0.3p ps=2.2u w=0.5u l=45.45u
X766 a_91170_14492# neuron_4__VK VSS VSS nfet_03v3 ad=0.6p pd=3.2u as=0.6p ps=3.2u w=1u l=1u
X790 a_19914_13502# DAC_7__Vb VSS VSS nfet_03v3 ad=0.6p pd=3.2u as=0.6p ps=3.2u w=1u l=8u
X795 a_19914_110862# DAC_7__Vb VSS VSS nfet_03v3 ad=0.6p pd=3.2u as=0.6p ps=3.2u w=1u l=8u
X802 a_19914_50454# w[11] a_16310_50504# VSS nfet_03v3 ad=0.3p pd=2.2u as=0.14p ps=1.06u w=0.5u l=0.64u
X804 a_16310_94896# w[21] a_26214_94846# VSS nfet_03v3 ad=0.14p pd=1.06u as=0.3p ps=2.2u w=0.5u l=0.64u
X821 DPI_4__VT DPI_4__VT VDD VDD pfet_03v3 ad=1.12p pd=4.56u as=1.12p ps=4.56u w=4u l=5.12u
X842 a_89914_51444# neuron_4__VIp VSS VSS nfet_03v3 ad=0.6p pd=3.2u as=0.6p ps=3.2u w=1u l=1u
X843 a_16310_32028# w[7] a_19914_31978# VSS nfet_03v3 ad=0.14p pd=1.06u as=0.14p ps=1.06u w=0.5u l=0.64u
X857 VDD a_62528_53070# cap_mim_2f0_m4m5_noshield c_width=22.18u c_length=22.18u
X858 a_87734_111852# neuron_4__Vamp_bias VSS VSS nfet_03v3 ad=0.3p pd=2.2u as=0.3p ps=2.2u w=0.5u l=0.64u
X872 VDD bias_0__VT_inh bias_0__VT_inh VDD pfet_03v3 ad=0.2464p pd=1.44u as=0.2464p ps=1.44u w=0.88u l=1.12u
X876 a_34614_50454# DAC_7__Vb VSS VSS nfet_03v3 ad=0.6p pd=3.2u as=0.6p ps=3.2u w=1u l=8u
X885 VDD DPI_4__Vthr DPI_4__Vthr VDD pfet_03v3 ad=1.12p pd=4.56u as=1.12p ps=4.56u w=4u l=5.12u
X887 a_89534_14142# VT a_87734_14492# VSS nfet_03v3 ad=2.4p pd=9.2u as=2.4p ps=9.2u w=4u l=2u
X888 a_22014_64642# DAC_7__Vb VSS VSS nfet_03v3 ad=0.6p pd=3.2u as=0.6p ps=3.2u w=1u l=8u
X889 a_22014_80658# DAC_7__Vb VSS VSS nfet_03v3 ad=0.6p pd=3.2u as=0.6p ps=3.2u w=1u l=8u
X890 a_67078_125606# a_67078_125606# DAC_1__Isum_i DAC_1__Isum_i nfet_03v3 ad=2.4p pd=9.2u as=2.4p ps=9.2u w=4u l=5.12u
X909 a_16310_32028# w[7] a_19914_31978# VSS nfet_03v3 ad=0.14p pd=1.06u as=0.3p ps=2.2u w=0.5u l=0.64u
X910 neuron_4__Vlk neuron_4__Vlk VSS VSS nfet_03v3 ad=0.28p pd=1.56u as=0.28p ps=1.56u w=1u l=1u
X912 a_16310_110912# w[26] a_22014_110862# VSS nfet_03v3 ad=0.14p pd=1.06u as=0.3p ps=2.2u w=0.5u l=0.64u
X933 DPI_4__Vthr DPI_4__Vthr VDD VDD pfet_03v3 ad=1.12p pd=4.56u as=1.12p ps=4.56u w=4u l=5.12u
X936 a_19914_31978# DAC_7__Vb VSS VSS nfet_03v3 ad=0.6p pd=3.2u as=0.6p ps=3.2u w=1u l=8u
X937 DPI_4__VT DPI_4__VT VDD VDD pfet_03v3 ad=1.12p pd=4.56u as=1.12p ps=4.56u w=4u l=5.12u
X946 VDD s[2] a_17058_50296# VDD pfet_03v3 ad=0.3p pd=2.2u as=0.3p ps=2.2u w=0.5u l=0.32u
X948 VDD s[6] a_17058_110704# VDD pfet_03v3 ad=0.3p pd=2.2u as=0.3p ps=2.2u w=0.5u l=0.32u
X965 a_19914_80658# DAC_7__Vb VSS VSS nfet_03v3 ad=0.6p pd=3.2u as=0.6p ps=3.2u w=1u l=8u
X972 a_62978_119782# a_62978_119782# VSS VSS nfet_03v3 ad=1.2p pd=5.2u as=1.2p ps=5.2u w=2u l=8u
X973 VDD neuron_4__VKup a_93348_87964# VDD pfet_03v3 ad=0.6p pd=3.2u as=0.6p ps=3.2u w=1u l=1u
X982 a_22014_110862# w[26] a_16310_110912# VSS nfet_03v3 ad=0.14p pd=1.06u as=0.14p ps=1.06u w=0.5u l=0.64u
X988 a_93976_87964# a_90162_81648# VMEM_3 VDD pfet_03v3 ad=0.3p pd=2.2u as=0.3p ps=2.2u w=0.5u l=0.64u
X1002 a_16310_32028# w[6] a_22014_31978# VSS nfet_03v3 ad=0.14p pd=1.06u as=0.3p ps=2.2u w=0.5u l=0.64u
X1004 DPI_4__Vthr DPI_4__Vthr VDD VDD pfet_03v3 ad=1.12p pd=4.56u as=1.12p ps=4.56u w=4u l=5.12u
X1007 DPI_4__VT DPI_4__VT VDD VDD pfet_03v3 ad=1.12p pd=4.56u as=1.12p ps=4.56u w=4u l=5.12u
X1011 a_26214_31978# DAC_7__Vb VSS VSS nfet_03v3 ad=0.6p pd=3.2u as=0.6p ps=3.2u w=1u l=8u
X1016 a_90162_14492# a_89534_14142# a_89914_14492# VSS nfet_03v3 ad=0.3p pd=2.2u as=0.3p ps=2.2u w=0.5u l=0.64u
X1018 a_93348_39284# a_90162_32968# spike[1] VDD pfet_03v3 ad=0.3p pd=2.2u as=0.3p ps=2.2u w=0.5u l=0.64u
X1021 a_16310_32028# w[7] a_19914_31978# VSS nfet_03v3 ad=0.14p pd=1.06u as=0.14p ps=1.06u w=0.5u l=0.64u
X1028 VDD a_88272_87964# a_89534_81298# VDD pfet_03v3 ad=0.3p pd=2.2u as=0.3p ps=2.2u w=0.5u l=8u
X1037 a_34614_64642# DAC_7__Vb VSS VSS nfet_03v3 ad=0.6p pd=3.2u as=0.6p ps=3.2u w=1u l=8u
X1049 a_22014_94846# DAC_7__Vb VSS VSS nfet_03v3 ad=0.6p pd=3.2u as=0.6p ps=3.2u w=1u l=8u
X1058 a_22014_125050# DAC_7__Vb VSS VSS nfet_03v3 ad=0.6p pd=3.2u as=0.6p ps=3.2u w=1u l=8u
X1061 DPI_4__Vthr DPI_4__Vthr VDD VDD pfet_03v3 ad=1.12p pd=4.56u as=2.4p ps=9.2u w=4u l=5.12u
X1066 a_22014_110862# DAC_7__Vb VSS VSS nfet_03v3 ad=0.6p pd=3.2u as=0.6p ps=3.2u w=1u l=8u
X1073 a_19914_31978# DAC_7__Vb VSS VSS nfet_03v3 ad=0.6p pd=3.2u as=0.6p ps=3.2u w=1u l=8u
X1085 VMEM_1 neuron_4__Vlk VSS VSS nfet_03v3 ad=0.6p pd=3.2u as=0.6p ps=3.2u w=1u l=1u
X1086 a_16310_13552# w[2] a_22014_13502# VSS nfet_03v3 ad=0.14p pd=1.06u as=0.14p ps=1.06u w=0.5u l=0.64u
X1105 a_16558_13552# pulse[0] a_16310_13552# VSS nfet_03v3 ad=0.3p pd=2.2u as=0.3p ps=2.2u w=0.5u l=0.64u
X1106 a_16310_32028# w[4] a_34614_31978# VSS nfet_03v3 ad=0.3p pd=2.2u as=0.3p ps=2.2u w=0.5u l=0.64u
X1114 VMEM_4 a_62978_119782# VSS VSS nfet_03v3 ad=1.44p pd=6u as=1.44p ps=6u w=2.4u l=8u
X1116 a_16310_13552# w[3] a_19914_13502# VSS nfet_03v3 ad=0.14p pd=1.06u as=0.14p ps=1.06u w=0.5u l=0.64u
X1120 VDD a_88272_118168# a_89534_111502# VDD pfet_03v3 ad=0.3p pd=2.2u as=0.3p ps=2.2u w=0.5u l=8u
X1134 a_19914_94846# DAC_7__Vb VSS VSS nfet_03v3 ad=0.6p pd=3.2u as=0.6p ps=3.2u w=1u l=8u
X1143 DPI_4__VT Iref VSS VSS nfet_03v3 ad=0.702p pd=3.54u as=0.702p ps=3.54u w=1.17u l=32u
X1144 a_19914_125050# DAC_7__Vb VSS VSS nfet_03v3 ad=0.6p pd=3.2u as=0.6p ps=3.2u w=1u l=8u
X1145 a_90162_51444# a_89534_51094# a_89914_51444# VSS nfet_03v3 ad=0.3p pd=2.2u as=0.3p ps=2.2u w=0.5u l=0.64u
X1146 DPI_4__Vthr DPI_4__Vthr VDD VDD pfet_03v3 ad=1.12p pd=4.56u as=1.12p ps=4.56u w=4u l=5.12u
X1170 a_19914_110862# w[27] a_16310_110912# VSS nfet_03v3 ad=0.14p pd=1.06u as=0.14p ps=1.06u w=0.5u l=0.64u
X1180 VDD a_88272_118168# a_88272_118168# VDD pfet_03v3 ad=0.3p pd=2.2u as=0.3p ps=2.2u w=0.5u l=8u
X1183 a_19914_13502# DAC_7__Vb VSS VSS nfet_03v3 ad=0.6p pd=3.2u as=0.6p ps=3.2u w=1u l=8u
X1189 a_19914_50454# DAC_7__Vb VSS VSS nfet_03v3 ad=0.6p pd=3.2u as=0.6p ps=3.2u w=1u l=8u
X1194 a_16310_50504# w[10] a_22014_50454# VSS nfet_03v3 ad=0.14p pd=1.06u as=0.14p ps=1.06u w=0.5u l=0.64u
X1195 a_62528_16118# a_62528_16118# DAC_7__Isum_e DAC_7__Isum_e nfet_03v3 ad=2.4p pd=9.2u as=2.4p ps=9.2u w=4u l=5.12u
X1201 VDD a_62528_83274# VMEM_3 VDD pfet_03v3 ad=2.4p pd=9.2u as=2.4p ps=9.2u w=4u l=5.12u
X1205 a_16310_13552# w[3] a_19914_13502# VSS nfet_03v3 ad=0.14p pd=1.06u as=0.14p ps=1.06u w=0.5u l=0.64u
X1206 a_16558_50504# spike[0] a_16310_50504# VSS nfet_03v3 ad=0.3p pd=2.2u as=0.3p ps=2.2u w=0.5u l=0.64u
X1214 a_22014_110862# w[26] a_16310_110912# VSS nfet_03v3 ad=0.3p pd=2.2u as=0.14p ps=1.06u w=0.5u l=0.64u
X1217 a_16310_50504# w[11] a_19914_50454# VSS nfet_03v3 ad=0.14p pd=1.06u as=0.14p ps=1.06u w=0.5u l=0.64u
X1219 VDD DPI_4__VT DPI_4__VT VDD pfet_03v3 ad=1.12p pd=4.56u as=1.12p ps=4.56u w=4u l=5.12u
X1228 spike[1] VSS cap_mim_2f0_m4m5_noshield c_width=10u c_length=10u
X1231 a_87734_32968# neuron_4__Vamp_bias VSS VSS nfet_03v3 ad=0.3p pd=2.2u as=0.3p ps=2.2u w=0.5u l=0.64u
X1233 a_16310_125100# w[30] a_22014_125050# VSS nfet_03v3 ad=0.14p pd=1.06u as=0.3p ps=2.2u w=0.5u l=0.64u
X1240 a_19914_110862# DAC_7__Vb VSS VSS nfet_03v3 ad=0.6p pd=3.2u as=0.6p ps=3.2u w=1u l=8u
X1242 a_90542_111852# neuron_4__VKdn VSS VSS nfet_03v3 ad=0.6p pd=3.2u as=0.6p ps=3.2u w=1u l=1u
X1247 a_62528_83274# a_62528_83274# DAC_3__Isum_e DAC_3__Isum_e nfet_03v3 ad=2.4p pd=9.2u as=2.4p ps=9.2u w=4u l=5.12u
X1256 a_19914_31978# w[7] a_16310_32028# VSS nfet_03v3 ad=0.14p pd=1.06u as=0.14p ps=1.06u w=0.5u l=0.64u
X1260 VDD DPI_4__VT a_67078_125606# VDD pfet_03v3 ad=2.4p pd=9.2u as=2.4p ps=9.2u w=4u l=5.12u
X1262 neuron_4__VKdn neuron_4__VKdn VSS VSS nfet_03v3 ad=0.28p pd=1.56u as=0.6p ps=3.2u w=1u l=1u
X1267 spike[0] VSS cap_mim_2f0_m4m5_noshield c_width=10u c_length=10u
X1270 a_16310_13552# w[3] a_19914_13502# VSS nfet_03v3 ad=0.14p pd=1.06u as=0.3p ps=2.2u w=0.5u l=0.64u
X1277 VDD DPI_4__VT DPI_4__VT VDD pfet_03v3 ad=1.12p pd=4.56u as=1.12p ps=4.56u w=4u l=5.12u
X1281 DAC_3__Isum_e a_17058_94688# a_16558_94896# VSS nfet_03v3 ad=0.3p pd=2.2u as=0.3p ps=2.2u w=0.5u l=0.64u
X1287 a_22014_125050# w[30] a_16310_125100# VSS nfet_03v3 ad=0.14p pd=1.06u as=0.14p ps=1.06u w=0.5u l=0.64u
X1298 a_17058_94688# s[5] VSS VSS nfet_03v3 ad=0.3p pd=2.2u as=0.3p ps=2.2u w=0.5u l=0.64u
X1308 a_16310_50504# w[11] a_19914_50454# VSS nfet_03v3 ad=0.14p pd=1.06u as=0.14p ps=1.06u w=0.5u l=0.64u
X1312 VMEM_4 spike[4] a_91170_111852# VSS nfet_03v3 ad=0.3p pd=2.2u as=0.3p ps=2.2u w=0.5u l=11.36u
X1323 VDD bias_0__VT_inh bias_0__VT_inh VDD pfet_03v3 ad=0.2464p pd=1.44u as=0.2464p ps=1.44u w=0.88u l=1.12u
X1327 a_19914_64642# DAC_7__Vb VSS VSS nfet_03v3 ad=0.6p pd=3.2u as=0.6p ps=3.2u w=1u l=8u
X1328 VDD DPI_4__VT DPI_4__VT VDD pfet_03v3 ad=1.12p pd=4.56u as=1.12p ps=4.56u w=4u l=5.12u
X1335 a_19914_80658# DAC_7__Vb VSS VSS nfet_03v3 ad=0.6p pd=3.2u as=0.6p ps=3.2u w=1u l=8u
X1339 a_16310_13552# w[2] a_22014_13502# VSS nfet_03v3 ad=0.14p pd=1.06u as=0.3p ps=2.2u w=0.5u l=0.64u
X1342 a_93348_20808# a_90162_14492# spike[0] VDD pfet_03v3 ad=0.3p pd=2.2u as=0.3p ps=2.2u w=0.5u l=0.64u
X1347 DPI_4__VT DPI_4__VT VDD VDD pfet_03v3 ad=1.12p pd=4.56u as=1.12p ps=4.56u w=4u l=5.12u
X1360 a_16310_13552# w[3] a_19914_13502# VSS nfet_03v3 ad=0.14p pd=1.06u as=0.14p ps=1.06u w=0.5u l=0.64u
X1368 a_16310_50504# w[11] a_19914_50454# VSS nfet_03v3 ad=0.14p pd=1.06u as=0.3p ps=2.2u w=0.5u l=0.64u
X1374 a_22014_125050# DAC_7__Vb VSS VSS nfet_03v3 ad=0.6p pd=3.2u as=0.6p ps=3.2u w=1u l=8u
X1377 VDD DPI_4__VT a_62528_34594# VDD pfet_03v3 ad=2.4p pd=9.2u as=2.4p ps=9.2u w=4u l=5.12u
X1397 DAC_3__Isum_i s[4] a_16558_80708# VSS nfet_03v3 ad=0.3p pd=2.2u as=0.3p ps=2.2u w=0.5u l=0.64u
X1401 a_26214_80658# DAC_7__Vb VSS VSS nfet_03v3 ad=0.6p pd=3.2u as=0.6p ps=3.2u w=1u l=8u
X1409 DPI_4__VT DPI_4__VT VDD VDD pfet_03v3 ad=1.12p pd=4.56u as=1.12p ps=4.56u w=4u l=5.12u
X1414 a_26214_94846# w[21] a_16310_94896# VSS nfet_03v3 ad=0.3p pd=2.2u as=0.14p ps=1.06u w=0.5u l=0.64u
X1430 DAC_5__Isum_i s[3] a_16558_64692# VSS nfet_03v3 ad=0.3p pd=2.2u as=0.3p ps=2.2u w=0.5u l=0.64u
X1434 a_16310_13552# w[0] a_34614_13502# VSS nfet_03v3 ad=0.3p pd=2.2u as=0.3p ps=2.2u w=0.5u l=0.64u
X1442 a_16310_110912# w[27] a_19914_110862# VSS nfet_03v3 ad=0.14p pd=1.06u as=0.14p ps=1.06u w=0.5u l=0.64u
X1443 a_19914_31978# DAC_7__Vb VSS VSS nfet_03v3 ad=0.6p pd=3.2u as=0.6p ps=3.2u w=1u l=8u
X1452 a_16310_50504# w[10] a_22014_50454# VSS nfet_03v3 ad=0.14p pd=1.06u as=0.3p ps=2.2u w=0.5u l=0.64u
X1455 a_62528_113478# a_62528_113478# DAC_1__Isum_e DAC_1__Isum_e nfet_03v3 ad=2.4p pd=9.2u as=2.4p ps=9.2u w=4u l=5.12u
X1463 DPI_4__Vthr DPI_4__Vthr VDD VDD pfet_03v3 ad=1.12p pd=4.56u as=1.12p ps=4.56u w=4u l=5.12u
X1468 a_93348_57760# a_90162_51444# spike[2] VDD pfet_03v3 ad=0.3p pd=2.2u as=0.3p ps=2.2u w=0.5u l=0.64u
X1470 a_19914_125050# w[31] a_16310_125100# VSS nfet_03v3 ad=0.14p pd=1.06u as=0.14p ps=1.06u w=0.5u l=0.64u
X1471 a_16310_50504# w[11] a_19914_50454# VSS nfet_03v3 ad=0.14p pd=1.06u as=0.14p ps=1.06u w=0.5u l=0.64u
X1481 a_17058_110704# s[6] VSS VSS nfet_03v3 ad=0.3p pd=2.2u as=0.3p ps=2.2u w=0.5u l=0.64u
X1482 a_22014_80658# w[18] a_16310_80708# VSS nfet_03v3 ad=0.14p pd=1.06u as=0.14p ps=1.06u w=0.5u l=0.64u
X1483 VDD a_62528_113478# VMEM_4 VDD pfet_03v3 ad=2.4p pd=9.2u as=2.4p ps=9.2u w=4u l=5.12u
X1484 VMEM_3 a_62978_89578# VSS VSS nfet_03v3 ad=1.44p pd=6u as=1.44p ps=6u w=2.4u l=8u
X1490 a_19914_94846# DAC_7__Vb VSS VSS nfet_03v3 ad=0.6p pd=3.2u as=0.6p ps=3.2u w=1u l=8u
X1492 a_89534_111502# VT a_87734_111852# VSS nfet_03v3 ad=2.4p pd=9.2u as=2.4p ps=9.2u w=4u l=2u
X1501 a_22014_110862# DAC_7__Vb VSS VSS nfet_03v3 ad=0.6p pd=3.2u as=0.6p ps=3.2u w=1u l=8u
X1509 a_19914_31978# w[7] a_16310_32028# VSS nfet_03v3 ad=0.14p pd=1.06u as=0.14p ps=1.06u w=0.5u l=0.64u
X1511 a_22014_64642# w[14] a_16310_64692# VSS nfet_03v3 ad=0.14p pd=1.06u as=0.14p ps=1.06u w=0.5u l=0.64u
X1512 a_22014_125050# w[30] a_16310_125100# VSS nfet_03v3 ad=0.3p pd=2.2u as=0.14p ps=1.06u w=0.5u l=0.64u
X1514 a_90542_32968# neuron_4__VKdn VSS VSS nfet_03v3 ad=0.6p pd=3.2u as=0.6p ps=3.2u w=1u l=1u
X1540 a_19914_13502# DAC_7__Vb VSS VSS nfet_03v3 ad=0.6p pd=3.2u as=0.6p ps=3.2u w=1u l=8u
X1547 a_16310_50504# w[8] a_34614_50454# VSS nfet_03v3 ad=0.3p pd=2.2u as=0.3p ps=2.2u w=0.5u l=0.64u
X1548 spike[1] a_90162_32968# a_90542_32968# VSS nfet_03v3 ad=0.3p pd=2.2u as=0.3p ps=2.2u w=0.5u l=0.64u
X1553 a_19914_125050# DAC_7__Vb VSS VSS nfet_03v3 ad=0.6p pd=3.2u as=0.6p ps=3.2u w=1u l=8u
X1555 a_26214_94846# DAC_7__Vb VSS VSS nfet_03v3 ad=0.6p pd=3.2u as=0.6p ps=3.2u w=1u l=8u
X1556 a_62978_89578# a_62978_89578# VSS VSS nfet_03v3 ad=1.2p pd=5.2u as=1.2p ps=5.2u w=2u l=8u
X1558 a_19914_50454# DAC_7__Vb VSS VSS nfet_03v3 ad=0.6p pd=3.2u as=0.6p ps=3.2u w=1u l=8u
X1559 a_88272_57760# VMEM_2 a_87734_51444# VSS nfet_03v3 ad=2.4p pd=9.2u as=2.4p ps=9.2u w=4u l=2u
X1591 a_22014_80658# w[18] a_16310_80708# VSS nfet_03v3 ad=0.3p pd=2.2u as=0.14p ps=1.06u w=0.5u l=0.64u
X1595 VMEM_0 neuron_4__Vlk VSS VSS nfet_03v3 ad=0.6p pd=3.2u as=0.6p ps=3.2u w=1u l=1u
X1596 VDD DPI_4__Vthr DAC_6__Isum_e DAC_6__Isum_e nfet_03v3 ad=2.4p pd=9.2u as=2.4p ps=9.2u w=4u l=5.12u
X1604 a_19914_13502# w[3] a_16310_13552# VSS nfet_03v3 ad=0.14p pd=1.06u as=0.14p ps=1.06u w=0.5u l=0.64u
X1613 a_19914_80658# w[19] a_16310_80708# VSS nfet_03v3 ad=0.14p pd=1.06u as=0.14p ps=1.06u w=0.5u l=0.64u
X1614 DPI_4__VT DPI_4__VT VDD VDD pfet_03v3 ad=1.12p pd=4.56u as=1.12p ps=4.56u w=4u l=5.12u
X1619 a_91170_111852# neuron_4__VK VSS VSS nfet_03v3 ad=0.6p pd=3.2u as=0.6p ps=3.2u w=1u l=1u
X1623 a_22014_13502# DAC_7__Vb VSS VSS nfet_03v3 ad=0.6p pd=3.2u as=0.6p ps=3.2u w=1u l=8u
X1627 a_22014_64642# w[14] a_16310_64692# VSS nfet_03v3 ad=0.3p pd=2.2u as=0.14p ps=1.06u w=0.5u l=0.64u
X1630 a_26214_50454# DAC_7__Vb VSS VSS nfet_03v3 ad=0.6p pd=3.2u as=0.6p ps=3.2u w=1u l=8u
X1631 VDD DPI_4__VT DPI_4__VT VDD pfet_03v3 ad=1.12p pd=4.56u as=1.12p ps=4.56u w=4u l=5.12u
X1646 a_22014_80658# DAC_7__Vb VSS VSS nfet_03v3 ad=0.6p pd=3.2u as=0.6p ps=3.2u w=1u l=8u
X1649 a_19914_64642# w[15] a_16310_64692# VSS nfet_03v3 ad=0.14p pd=1.06u as=0.14p ps=1.06u w=0.5u l=0.64u
X1673 a_91170_51444# neuron_4__VK VSS VSS nfet_03v3 ad=0.6p pd=3.2u as=0.6p ps=3.2u w=1u l=1u
X1676 a_16310_110912# w[27] a_19914_110862# VSS nfet_03v3 ad=0.14p pd=1.06u as=0.14p ps=1.06u w=0.5u l=0.64u
X1682 VDD DPI_4__Vthr DPI_4__Vthr VDD pfet_03v3 ad=1.12p pd=4.56u as=1.12p ps=4.56u w=4u l=5.12u
X1687 VDD DPI_4__VT DPI_4__VT VDD pfet_03v3 ad=1.12p pd=4.56u as=1.12p ps=4.56u w=4u l=5.12u
X1691 a_19914_50454# DAC_7__Vb VSS VSS nfet_03v3 ad=0.6p pd=3.2u as=0.6p ps=3.2u w=1u l=8u
X1698 VDD a_62528_16118# VMEM_0 VDD pfet_03v3 ad=2.4p pd=9.2u as=2.4p ps=9.2u w=4u l=5.12u
X1715 VDD bias_0__VT_inh bias_0__VT_inh VDD pfet_03v3 ad=0.2464p pd=1.44u as=0.2464p ps=1.44u w=0.88u l=1.12u
X1721 a_19914_80658# w[19] a_16310_80708# VSS nfet_03v3 ad=0.3p pd=2.2u as=0.14p ps=1.06u w=0.5u l=0.64u
X1724 a_19914_50454# w[11] a_16310_50504# VSS nfet_03v3 ad=0.14p pd=1.06u as=0.14p ps=1.06u w=0.5u l=0.64u
X1725 a_19914_64642# DAC_7__Vb VSS VSS nfet_03v3 ad=0.6p pd=3.2u as=0.6p ps=3.2u w=1u l=8u
X1747 DPI_4__VT DPI_4__VT VDD VDD pfet_03v3 ad=1.12p pd=4.56u as=1.12p ps=4.56u w=4u l=5.12u
X1757 a_87734_14492# neuron_4__Vamp_bias VSS VSS nfet_03v3 ad=0.3p pd=2.2u as=0.3p ps=2.2u w=0.5u l=0.64u
X1760 a_19914_64642# w[15] a_16310_64692# VSS nfet_03v3 ad=0.3p pd=2.2u as=0.14p ps=1.06u w=0.5u l=0.64u
X1761 VDD DPI_4__VT DPI_4__VT VDD pfet_03v3 ad=1.12p pd=4.56u as=1.12p ps=4.56u w=4u l=5.12u
X1766 a_89914_81648# neuron_4__VIp VSS VSS nfet_03v3 ad=0.6p pd=3.2u as=0.6p ps=3.2u w=1u l=1u
X1772 a_16310_125100# w[31] a_19914_125050# VSS nfet_03v3 ad=0.14p pd=1.06u as=0.14p ps=1.06u w=0.5u l=0.64u
X1774 a_26214_110862# w[25] a_16310_110912# VSS nfet_03v3 ad=0.3p pd=2.2u as=0.14p ps=1.06u w=0.5u l=0.64u
X1780 neuron_4__Vlk neuron_4__Vlk VSS VSS nfet_03v3 ad=0.28p pd=1.56u as=0.6p ps=3.2u w=1u l=1u
X1788 a_26214_64642# DAC_7__Vb VSS VSS nfet_03v3 ad=0.6p pd=3.2u as=0.6p ps=3.2u w=1u l=8u
X1793 a_16310_32028# w[5] a_26214_31978# VSS nfet_03v3 ad=0.14p pd=1.06u as=0.3p ps=2.2u w=0.5u l=0.64u
X1794 a_67078_65198# a_67078_65198# DAC_5__Isum_i DAC_5__Isum_i nfet_03v3 ad=2.4p pd=9.2u as=2.4p ps=9.2u w=4u l=5.12u
X1800 a_34614_80658# DAC_7__Vb VSS VSS nfet_03v3 ad=0.6p pd=3.2u as=0.6p ps=3.2u w=1u l=8u
X1804 a_89534_51094# VT a_87734_51444# VSS nfet_03v3 ad=2.4p pd=9.2u as=2.4p ps=9.2u w=4u l=2u
X1809 VDD a_67078_125606# a_62978_119782# VDD pfet_03v3 ad=2.4p pd=9.2u as=2.4p ps=9.2u w=4u l=5.12u
X1812 a_22014_94846# DAC_7__Vb VSS VSS nfet_03v3 ad=0.6p pd=3.2u as=0.6p ps=3.2u w=1u l=8u
X1824 a_17058_124892# s[7] VSS VSS nfet_03v3 ad=0.3p pd=2.2u as=0.3p ps=2.2u w=0.5u l=0.64u
X1833 a_19914_31978# DAC_7__Vb VSS VSS nfet_03v3 ad=0.6p pd=3.2u as=0.6p ps=3.2u w=1u l=8u
X1835 a_22014_125050# DAC_7__Vb VSS VSS nfet_03v3 ad=0.6p pd=3.2u as=0.6p ps=3.2u w=1u l=8u
X1836 a_16310_110912# w[24] a_34614_110862# VSS nfet_03v3 ad=0.3p pd=2.2u as=0.3p ps=2.2u w=0.5u l=0.64u
X1838 a_34614_110862# DAC_7__Vb VSS VSS nfet_03v3 ad=0.6p pd=3.2u as=0.6p ps=3.2u w=1u l=8u
X1860 DAC_7__Vb DAC_7__Vb VSS VSS nfet_03v3 ad=0.6p pd=3.2u as=0.6p ps=3.2u w=1u l=8u
X1867 DPI_4__Vthr DPI_4__Vthr VDD VDD pfet_03v3 ad=1.12p pd=4.56u as=1.12p ps=4.56u w=4u l=5.12u
X1868 a_19914_64642# DAC_7__Vb VSS VSS nfet_03v3 ad=0.6p pd=3.2u as=0.6p ps=3.2u w=1u l=8u
X1876 VDD s[4] a_17058_80500# VDD pfet_03v3 ad=0.3p pd=2.2u as=0.3p ps=2.2u w=0.5u l=0.32u
X1877 a_87734_51444# neuron_4__Vamp_bias VSS VSS nfet_03v3 ad=0.3p pd=2.2u as=0.3p ps=2.2u w=0.5u l=0.64u
X1885 neuron_4__Vlk neuron_4__Vlk VSS VSS nfet_03v3 ad=0.28p pd=1.56u as=0.28p ps=1.56u w=1u l=1u
X1890 VDD a_67078_65198# a_62978_59374# VDD pfet_03v3 ad=2.4p pd=9.2u as=2.4p ps=9.2u w=4u l=5.12u
X1894 a_19914_13502# w[3] a_16310_13552# VSS nfet_03v3 ad=0.14p pd=1.06u as=0.14p ps=1.06u w=0.5u l=0.64u
X1912 VDD DPI_4__VT DPI_4__VT VDD pfet_03v3 ad=1.12p pd=4.56u as=1.12p ps=4.56u w=4u l=5.12u
X1921 a_22014_31978# DAC_7__Vb VSS VSS nfet_03v3 ad=0.6p pd=3.2u as=0.6p ps=3.2u w=1u l=8u
X1924 VDD bias_0__VT_inh bias_0__VT_inh VDD pfet_03v3 ad=0.2464p pd=1.44u as=0.2464p ps=1.44u w=0.88u l=1.12u
X1932 DPI_4__VT DPI_4__VT VDD VDD pfet_03v3 ad=1.12p pd=4.56u as=1.12p ps=4.56u w=4u l=5.12u
X1933 DPI_4__Vthr DPI_4__Vthr VDD VDD pfet_03v3 ad=1.12p pd=4.56u as=1.12p ps=4.56u w=4u l=5.12u
X1949 a_19914_13502# DAC_7__Vb VSS VSS nfet_03v3 ad=0.6p pd=3.2u as=0.6p ps=3.2u w=1u l=8u
X1962 a_34614_94846# DAC_7__Vb VSS VSS nfet_03v3 ad=0.6p pd=3.2u as=0.6p ps=3.2u w=1u l=8u
X1979 VDD s[5] a_17058_94688# VDD pfet_03v3 ad=0.3p pd=2.2u as=0.3p ps=2.2u w=0.5u l=0.32u
X1990 DPI_4__VT DPI_4__VT VDD VDD pfet_03v3 ad=1.12p pd=4.56u as=1.12p ps=4.56u w=4u l=5.12u
X1991 bias_0__VT_inh bias_0__VT_inh VDD VDD pfet_03v3 ad=0.2464p pd=1.44u as=0.2464p ps=1.44u w=0.88u l=1.12u
X1999 VDD a_88272_39284# a_88272_39284# VDD pfet_03v3 ad=0.3p pd=2.2u as=0.3p ps=2.2u w=0.5u l=8u
X2000 Iref Iref VSS VSS nfet_03v3 ad=6p pd=21.2u as=6p ps=21.2u w=10u l=8u
X2006 a_19914_50454# w[11] a_16310_50504# VSS nfet_03v3 ad=0.14p pd=1.06u as=0.14p ps=1.06u w=0.5u l=0.64u
X2013 a_22014_13502# DAC_7__Vb VSS VSS nfet_03v3 ad=0.6p pd=3.2u as=0.6p ps=3.2u w=1u l=8u
X2015 a_16310_125100# w[31] a_19914_125050# VSS nfet_03v3 ad=0.14p pd=1.06u as=0.14p ps=1.06u w=0.5u l=0.64u
X2019 a_19914_110862# DAC_7__Vb VSS VSS nfet_03v3 ad=0.6p pd=3.2u as=0.6p ps=3.2u w=1u l=8u
X2022 bias_0__VT_inh bias_0__VT_inh VDD VDD pfet_03v3 ad=0.2464p pd=1.44u as=0.2464p ps=1.44u w=0.88u l=1.12u
X2030 VDD DPI_4__VT a_62528_53070# VDD pfet_03v3 ad=2.4p pd=9.2u as=2.4p ps=9.2u w=4u l=5.12u
X2031 VDD DPI_4__VT DPI_4__VT VDD pfet_03v3 ad=1.12p pd=4.56u as=1.12p ps=4.56u w=4u l=5.12u
X2044 a_90162_81648# a_89534_81298# a_89914_81648# VSS nfet_03v3 ad=0.3p pd=2.2u as=0.3p ps=2.2u w=0.5u l=0.64u
X2054 a_90542_14492# neuron_4__VKdn VSS VSS nfet_03v3 ad=0.6p pd=3.2u as=0.6p ps=3.2u w=1u l=1u
X2059 VDD DPI_4__VT DPI_4__VT VDD pfet_03v3 ad=1.12p pd=4.56u as=1.12p ps=4.56u w=4u l=5.12u
X2070 VDD DPI_4__Vthr DAC_5__Isum_e DAC_5__Isum_e nfet_03v3 ad=2.4p pd=9.2u as=2.4p ps=9.2u w=4u l=5.12u
X2073 VDD neuron_4__VNA a_93976_39284# VDD pfet_03v3 ad=0.6p pd=3.2u as=0.6p ps=3.2u w=1u l=1u
X2077 VDD DPI_4__Vthr DPI_4__Vthr VDD pfet_03v3 ad=1.12p pd=4.56u as=1.12p ps=4.56u w=4u l=5.12u
X2084 bias_0__VT_inh bias_0__VT_inh VDD VDD pfet_03v3 ad=0.2464p pd=1.44u as=0.2464p ps=1.44u w=0.88u l=1.12u
X2086 spike[0] a_90162_14492# a_90542_14492# VSS nfet_03v3 ad=0.3p pd=2.2u as=0.3p ps=2.2u w=0.5u l=0.64u
X2088 a_19914_50454# DAC_7__Vb VSS VSS nfet_03v3 ad=0.6p pd=3.2u as=0.6p ps=3.2u w=1u l=8u
X2097 a_26214_125050# w[29] a_16310_125100# VSS nfet_03v3 ad=0.3p pd=2.2u as=0.14p ps=1.06u w=0.5u l=0.64u
X2100 a_19914_80658# DAC_7__Vb VSS VSS nfet_03v3 ad=0.6p pd=3.2u as=0.6p ps=3.2u w=1u l=8u
X2104 a_16310_80708# w[18] a_22014_80658# VSS nfet_03v3 ad=0.14p pd=1.06u as=0.14p ps=1.06u w=0.5u l=0.64u
X2106 spike[3] VSS cap_mim_2f0_m4m5_noshield c_width=10u c_length=10u
X2112 VDD DPI_4__VT a_67078_65198# VDD pfet_03v3 ad=2.4p pd=9.2u as=2.4p ps=9.2u w=4u l=5.12u
X2113 VDD DPI_4__VT DPI_4__VT VDD pfet_03v3 ad=1.12p pd=4.56u as=1.12p ps=4.56u w=4u l=5.12u
X2114 a_16558_80708# spike[0] a_16310_80708# VSS nfet_03v3 ad=0.3p pd=2.2u as=0.3p ps=2.2u w=0.5u l=0.64u
X2127 a_16310_80708# w[19] a_19914_80658# VSS nfet_03v3 ad=0.14p pd=1.06u as=0.14p ps=1.06u w=0.5u l=0.64u
X2130 VDD DPI_4__Vthr DPI_4__Vthr VDD pfet_03v3 ad=1.12p pd=4.56u as=1.12p ps=4.56u w=4u l=5.12u
X2135 a_16310_64692# w[14] a_22014_64642# VSS nfet_03v3 ad=0.14p pd=1.06u as=0.14p ps=1.06u w=0.5u l=0.64u
X2143 a_16310_13552# w[1] a_26214_13502# VSS nfet_03v3 ad=0.14p pd=1.06u as=0.3p ps=2.2u w=0.5u l=0.64u
X2147 a_16310_125100# w[28] a_34614_125050# VSS nfet_03v3 ad=0.3p pd=2.2u as=0.3p ps=2.2u w=0.5u l=0.64u
X2148 a_34614_125050# DAC_7__Vb VSS VSS nfet_03v3 ad=0.6p pd=3.2u as=0.6p ps=3.2u w=1u l=8u
X2149 a_16558_64692# spike[1] a_16310_64692# VSS nfet_03v3 ad=0.3p pd=2.2u as=0.3p ps=2.2u w=0.5u l=0.64u
X2154 a_16310_64692# w[15] a_19914_64642# VSS nfet_03v3 ad=0.14p pd=1.06u as=0.14p ps=1.06u w=0.5u l=0.64u
X2182 spike[2] a_90162_51444# a_90542_51444# VSS nfet_03v3 ad=0.3p pd=2.2u as=0.3p ps=2.2u w=0.5u l=0.64u
X2185 VDD DPI_4__Vthr DPI_4__Vthr VDD pfet_03v3 ad=1.12p pd=4.56u as=1.12p ps=4.56u w=4u l=5.12u
X2189 VDD neuron_4__VNA neuron_4__VNA VDD pfet_03v3 ad=0.3p pd=2.2u as=0.3p ps=2.2u w=0.5u l=45.45u
X2195 VDD a_4687_155814# DAC_7__Vb VDD pfet_03v3 ad=0.864p pd=4.08u as=0.864p ps=4.08u w=1.44u l=8u
X2204 a_19914_31978# DAC_7__Vb VSS VSS nfet_03v3 ad=0.6p pd=3.2u as=0.6p ps=3.2u w=1u l=8u
X2209 DPI_4__Vthr DPI_4__Vthr VDD VDD pfet_03v3 ad=1.12p pd=4.56u as=1.12p ps=4.56u w=4u l=5.12u
X2222 a_16310_80708# w[19] a_19914_80658# VSS nfet_03v3 ad=0.14p pd=1.06u as=0.14p ps=1.06u w=0.5u l=0.64u
X2227 a_19914_64642# DAC_7__Vb VSS VSS nfet_03v3 ad=0.6p pd=3.2u as=0.6p ps=3.2u w=1u l=8u
X2232 VDD a_4687_155814# neuron_4__VIp VDD pfet_03v3 ad=1.404p pd=5.88u as=1.404p ps=5.88u w=2.34u l=8u
X2236 a_19914_94846# DAC_7__Vb VSS VSS nfet_03v3 ad=0.6p pd=3.2u as=0.6p ps=3.2u w=1u l=8u
X2238 a_16310_50504# w[9] a_26214_50454# VSS nfet_03v3 ad=0.14p pd=1.06u as=0.3p ps=2.2u w=0.5u l=0.64u
X2239 neuron_4__Vamp_bias neuron_4__Vamp_bias VSS VSS nfet_03v3 ad=0.3p pd=2.2u as=0.3p ps=2.2u w=0.5u l=0.64u
X2242 VMEM_1 spike[1] a_91170_32968# VSS nfet_03v3 ad=0.3p pd=2.2u as=0.3p ps=2.2u w=0.5u l=11.36u
X2244 a_16310_64692# w[15] a_19914_64642# VSS nfet_03v3 ad=0.14p pd=1.06u as=0.14p ps=1.06u w=0.5u l=0.64u
X2248 DAC_6__Isum_e a_17058_31820# a_16558_32028# VSS nfet_03v3 ad=0.3p pd=2.2u as=0.3p ps=2.2u w=0.5u l=0.64u
X2253 a_26214_110862# DAC_7__Vb VSS VSS nfet_03v3 ad=0.6p pd=3.2u as=0.6p ps=3.2u w=1u l=8u
X2256 VDD a_62528_34594# cap_mim_2f0_m4m5_noshield c_width=22.18u c_length=22.18u
X2257 a_22014_31978# DAC_7__Vb VSS VSS nfet_03v3 ad=0.6p pd=3.2u as=0.6p ps=3.2u w=1u l=8u
X2273 a_17058_31820# s[1] VSS VSS nfet_03v3 ad=0.3p pd=2.2u as=0.3p ps=2.2u w=0.5u l=0.64u
X2279 a_16310_80708# w[19] a_19914_80658# VSS nfet_03v3 ad=0.14p pd=1.06u as=0.3p ps=2.2u w=0.5u l=0.64u
X2288 VDD a_4687_155814# neuron_4__Vamp_bias VDD pfet_03v3 ad=5.484p pd=19.48u as=5.484p ps=19.48u w=9.14u l=8u
X2303 a_19914_125050# DAC_7__Vb VSS VSS nfet_03v3 ad=0.6p pd=3.2u as=0.6p ps=3.2u w=1u l=8u
X2304 VDD a_88272_20808# a_88272_20808# VDD pfet_03v3 ad=0.3p pd=2.2u as=0.3p ps=2.2u w=0.5u l=8u
X2305 spike[2] VSS cap_mim_2f0_m4m5_noshield c_width=10u c_length=10u
X2307 a_16310_64692# w[15] a_19914_64642# VSS nfet_03v3 ad=0.14p pd=1.06u as=0.3p ps=2.2u w=0.5u l=0.64u
X2312 DPI_4__VT DPI_4__VT VDD VDD pfet_03v3 ad=1.12p pd=4.56u as=1.12p ps=4.56u w=4u l=5.12u
X2322 a_19914_110862# DAC_7__Vb VSS VSS nfet_03v3 ad=0.6p pd=3.2u as=0.6p ps=3.2u w=1u l=8u
X2344 DAC_3__Isum_i s[5] a_16558_94896# VSS nfet_03v3 ad=0.3p pd=2.2u as=0.3p ps=2.2u w=0.5u l=0.64u
X2363 a_16310_80708# w[18] a_22014_80658# VSS nfet_03v3 ad=0.14p pd=1.06u as=0.3p ps=2.2u w=0.5u l=0.64u
X2366 VDD a_89534_111502# a_90162_111852# VDD pfet_03v3 ad=0.3p pd=2.2u as=0.3p ps=2.2u w=0.5u l=0.64u
X2367 VDD DPI_4__VT DPI_4__VT VDD pfet_03v3 ad=1.12p pd=4.56u as=1.12p ps=4.56u w=4u l=5.12u
X2370 DPI_4__Vthr Iref VSS VSS nfet_03v3 ad=0.546p pd=3.02u as=0.546p ps=3.02u w=0.91u l=32u
X2372 a_22014_13502# DAC_7__Vb VSS VSS nfet_03v3 ad=0.6p pd=3.2u as=0.6p ps=3.2u w=1u l=8u
X2373 VDD a_67078_65198# cap_mim_2f0_m4m5_noshield c_width=22.18u c_length=22.18u
X2379 a_93348_87964# a_90162_81648# spike[3] VDD pfet_03v3 ad=0.3p pd=2.2u as=0.3p ps=2.2u w=0.5u l=0.64u
X2389 a_16310_80708# w[19] a_19914_80658# VSS nfet_03v3 ad=0.14p pd=1.06u as=0.14p ps=1.06u w=0.5u l=0.64u
X2393 a_26214_31978# w[5] a_16310_32028# VSS nfet_03v3 ad=0.3p pd=2.2u as=0.14p ps=1.06u w=0.5u l=0.64u
X2397 a_16310_64692# w[14] a_22014_64642# VSS nfet_03v3 ad=0.14p pd=1.06u as=0.3p ps=2.2u w=0.5u l=0.64u
X2410 VDD DPI_4__Vthr DPI_4__Vthr VDD pfet_03v3 ad=1.12p pd=4.56u as=1.12p ps=4.56u w=4u l=5.12u
X2416 VDD DPI_4__Vthr DPI_4__Vthr VDD pfet_03v3 ad=1.12p pd=4.56u as=1.12p ps=4.56u w=4u l=5.12u
X2420 a_16310_64692# w[15] a_19914_64642# VSS nfet_03v3 ad=0.14p pd=1.06u as=0.14p ps=1.06u w=0.5u l=0.64u
X2428 VDD DPI_4__VT DPI_4__VT VDD pfet_03v3 ad=1.12p pd=4.56u as=1.12p ps=4.56u w=4u l=5.12u
X2429 VSS neuron_4__VKdn neuron_4__VKdn VSS nfet_03v3 ad=0.28p pd=1.56u as=0.28p ps=1.56u w=1u l=1u
X2431 a_22014_94846# w[22] a_16310_94896# VSS nfet_03v3 ad=0.14p pd=1.06u as=0.14p ps=1.06u w=0.5u l=0.64u
X2442 VDD DPI_4__Vthr DAC_1__Isum_e DAC_1__Isum_e nfet_03v3 ad=2.4p pd=9.2u as=2.4p ps=9.2u w=4u l=5.12u
X2445 a_19914_110862# DAC_7__Vb VSS VSS nfet_03v3 ad=0.6p pd=3.2u as=0.6p ps=3.2u w=1u l=8u
X2446 a_19914_13502# DAC_7__Vb VSS VSS nfet_03v3 ad=0.6p pd=3.2u as=0.6p ps=3.2u w=1u l=8u
X2447 VDD a_88272_57760# a_88272_57760# VDD pfet_03v3 ad=0.3p pd=2.2u as=0.3p ps=2.2u w=0.5u l=8u
X2457 a_19914_50454# DAC_7__Vb VSS VSS nfet_03v3 ad=0.6p pd=3.2u as=0.6p ps=3.2u w=1u l=8u
X2471 VDD DPI_4__VT a_62528_113478# VDD pfet_03v3 ad=2.4p pd=9.2u as=2.4p ps=9.2u w=4u l=5.12u
X2472 a_16310_80708# w[16] a_34614_80658# VSS nfet_03v3 ad=0.3p pd=2.2u as=0.3p ps=2.2u w=0.5u l=0.64u
X2478 a_19914_80658# DAC_7__Vb VSS VSS nfet_03v3 ad=0.6p pd=3.2u as=0.6p ps=3.2u w=1u l=8u
X2481 a_88272_87964# VMEM_3 a_87734_81648# VSS nfet_03v3 ad=2.4p pd=9.2u as=2.4p ps=9.2u w=4u l=2u
X2489 VDD DPI_4__Vthr DPI_4__Vthr VDD pfet_03v3 ad=1.12p pd=4.56u as=1.12p ps=4.56u w=4u l=5.12u
X2498 neuron_4__Vlk neuron_4__Vlk VSS VSS nfet_03v3 ad=0.28p pd=1.56u as=0.28p ps=1.56u w=1u l=1u
X2500 VDD a_89534_32618# a_90162_32968# VDD pfet_03v3 ad=0.3p pd=2.2u as=0.3p ps=2.2u w=0.5u l=0.64u
X2510 VMEM_2 neuron_4__Vlk VSS VSS nfet_03v3 ad=0.6p pd=3.2u as=0.6p ps=3.2u w=1u l=1u
X2514 a_16310_64692# w[12] a_34614_64642# VSS nfet_03v3 ad=0.3p pd=2.2u as=0.3p ps=2.2u w=0.5u l=0.64u
X2520 a_22014_110862# DAC_7__Vb VSS VSS nfet_03v3 ad=0.6p pd=3.2u as=0.6p ps=3.2u w=1u l=8u
X2521 VMEM_4 neuron_4__Vlk VSS VSS nfet_03v3 ad=0.6p pd=3.2u as=0.6p ps=3.2u w=1u l=1u
X2537 a_22014_50454# DAC_7__Vb VSS VSS nfet_03v3 ad=0.6p pd=3.2u as=0.6p ps=3.2u w=1u l=8u
X2539 VDD neuron_4__VNA a_93976_57760# VDD pfet_03v3 ad=0.6p pd=3.2u as=0.6p ps=3.2u w=1u l=1u
X2553 a_22014_94846# w[22] a_16310_94896# VSS nfet_03v3 ad=0.3p pd=2.2u as=0.14p ps=1.06u w=0.5u l=0.64u
X2557 a_26214_80658# DAC_7__Vb VSS VSS nfet_03v3 ad=0.6p pd=3.2u as=0.6p ps=3.2u w=1u l=8u
X2560 VDD DPI_4__Vthr DPI_4__Vthr VDD pfet_03v3 ad=1.12p pd=4.56u as=1.12p ps=4.56u w=4u l=5.12u
X2567 VDD bias_0__VT_inh bias_0__VT_inh VDD pfet_03v3 ad=0.2464p pd=1.44u as=0.2464p ps=1.44u w=0.88u l=1.12u
X2568 a_16310_110912# w[26] a_22014_110862# VSS nfet_03v3 ad=0.14p pd=1.06u as=0.14p ps=1.06u w=0.5u l=0.64u
X2572 a_19914_94846# w[23] a_16310_94896# VSS nfet_03v3 ad=0.14p pd=1.06u as=0.14p ps=1.06u w=0.5u l=0.64u
X2585 VSS neuron_4__Vlk neuron_4__Vlk VSS nfet_03v3 ad=0.28p pd=1.56u as=0.28p ps=1.56u w=1u l=1u
X2594 a_91170_81648# neuron_4__VK VSS VSS nfet_03v3 ad=0.6p pd=3.2u as=0.6p ps=3.2u w=1u l=1u
X2596 a_26214_125050# DAC_7__Vb VSS VSS nfet_03v3 ad=0.6p pd=3.2u as=0.6p ps=3.2u w=1u l=8u
X2616 a_19914_64642# DAC_7__Vb VSS VSS nfet_03v3 ad=0.6p pd=3.2u as=0.6p ps=3.2u w=1u l=8u
X2617 VDD DPI_4__Vthr DPI_4__Vthr VDD pfet_03v3 ad=1.12p pd=4.56u as=1.12p ps=4.56u w=4u l=5.12u
X2619 a_19914_80658# DAC_7__Vb VSS VSS nfet_03v3 ad=0.6p pd=3.2u as=0.6p ps=3.2u w=1u l=8u
X2623 DAC_7__Isum_e a_17058_13344# a_16558_13552# VSS nfet_03v3 ad=0.3p pd=2.2u as=0.3p ps=2.2u w=0.5u l=0.64u
X2635 a_19914_94846# DAC_7__Vb VSS VSS nfet_03v3 ad=0.6p pd=3.2u as=0.6p ps=3.2u w=1u l=8u
X2636 a_19914_80658# w[19] a_16310_80708# VSS nfet_03v3 ad=0.14p pd=1.06u as=0.14p ps=1.06u w=0.5u l=0.64u
X2642 a_17058_13344# s[0] VSS VSS nfet_03v3 ad=0.3p pd=2.2u as=0.3p ps=2.2u w=0.5u l=0.64u
X2644 VMEM_0 VSS cap_mim_2f0_m4m5_noshield c_width=22.18u c_length=22.18u
X2662 a_19914_125050# DAC_7__Vb VSS VSS nfet_03v3 ad=0.6p pd=3.2u as=0.6p ps=3.2u w=1u l=8u
X2663 a_22014_31978# DAC_7__Vb VSS VSS nfet_03v3 ad=0.6p pd=3.2u as=0.6p ps=3.2u w=1u l=8u
X2666 bias_0__VT_inh bias_0__VT_inh VDD VDD pfet_03v3 ad=0.2464p pd=1.44u as=0.2464p ps=1.44u w=0.88u l=1.12u
X2674 a_19914_94846# w[23] a_16310_94896# VSS nfet_03v3 ad=0.3p pd=2.2u as=0.14p ps=1.06u w=0.5u l=0.64u
X2679 a_19914_64642# w[15] a_16310_64692# VSS nfet_03v3 ad=0.14p pd=1.06u as=0.14p ps=1.06u w=0.5u l=0.64u
X2686 VDD s[3] a_17058_64484# VDD pfet_03v3 ad=0.3p pd=2.2u as=0.3p ps=2.2u w=0.5u l=0.32u
X2695 a_22014_64642# DAC_7__Vb VSS VSS nfet_03v3 ad=0.6p pd=3.2u as=0.6p ps=3.2u w=1u l=8u
X2702 a_90162_111852# a_89534_111502# a_89914_111852# VSS nfet_03v3 ad=0.3p pd=2.2u as=0.3p ps=2.2u w=0.5u l=0.64u
X2704 a_26214_94846# DAC_7__Vb VSS VSS nfet_03v3 ad=0.6p pd=3.2u as=0.6p ps=3.2u w=1u l=8u
X2707 a_67078_95402# a_67078_95402# DAC_3__Isum_i DAC_3__Isum_i nfet_03v3 ad=2.4p pd=9.2u as=2.4p ps=9.2u w=4u l=5.12u
X2709 DPI_4__Vthr DPI_4__Vthr VDD VDD pfet_03v3 ad=1.12p pd=4.56u as=1.12p ps=4.56u w=4u l=5.12u
X2713 a_89534_81298# VT a_87734_81648# VSS nfet_03v3 ad=2.4p pd=9.2u as=2.4p ps=9.2u w=4u l=2u
X2720 a_19914_31978# DAC_7__Vb VSS VSS nfet_03v3 ad=0.6p pd=3.2u as=0.6p ps=3.2u w=1u l=8u
X2726 a_89914_32968# neuron_4__VIp VSS VSS nfet_03v3 ad=0.6p pd=3.2u as=0.6p ps=3.2u w=1u l=1u
X2729 DAC_5__Isum_e a_17058_50296# a_16558_50504# VSS nfet_03v3 ad=0.3p pd=2.2u as=0.3p ps=2.2u w=0.5u l=0.64u
X2734 a_16558_110912# spike[2] a_16310_110912# VSS nfet_03v3 ad=0.3p pd=2.2u as=0.3p ps=2.2u w=0.5u l=0.64u
X2740 a_17058_50296# s[2] VSS VSS nfet_03v3 ad=0.3p pd=2.2u as=0.3p ps=2.2u w=0.5u l=0.64u
X2742 a_26214_13502# w[1] a_16310_13552# VSS nfet_03v3 ad=0.3p pd=2.2u as=0.14p ps=1.06u w=0.5u l=0.64u
X2751 DPI_4__Vthr DPI_4__Vthr VDD VDD pfet_03v3 ad=1.12p pd=4.56u as=1.12p ps=4.56u w=4u l=5.12u
X2752 a_19914_125050# DAC_7__Vb VSS VSS nfet_03v3 ad=0.6p pd=3.2u as=0.6p ps=3.2u w=1u l=8u
X2754 a_19914_94846# DAC_7__Vb VSS VSS nfet_03v3 ad=0.6p pd=3.2u as=0.6p ps=3.2u w=1u l=8u
X2767 a_87734_81648# neuron_4__Vamp_bias VSS VSS nfet_03v3 ad=0.3p pd=2.2u as=0.3p ps=2.2u w=0.5u l=0.64u
X2769 VMEM_0 spike[0] a_91170_14492# VSS nfet_03v3 ad=0.3p pd=2.2u as=0.3p ps=2.2u w=0.5u l=11.36u
X2771 a_19914_110862# DAC_7__Vb VSS VSS nfet_03v3 ad=0.6p pd=3.2u as=0.6p ps=3.2u w=1u l=8u
X2779 neuron_4__VNA Iref VSS VSS nfet_03v3 ad=3.456p pd=12.72u as=3.456p ps=12.72u w=5.76u l=8u
X2796 a_19914_110862# w[27] a_16310_110912# VSS nfet_03v3 ad=0.14p pd=1.06u as=0.14p ps=1.06u w=0.5u l=0.64u
X2804 neuron_4__VK neuron_4__VK a_67118_143686# VSS nfet_03v3 ad=0.3p pd=2.2u as=0.3p ps=2.2u w=0.5u l=45.45u
X2813 a_93976_118168# a_90162_111852# VMEM_4 VDD pfet_03v3 ad=0.3p pd=2.2u as=0.3p ps=2.2u w=0.5u l=0.64u
X2821 VMEM_3 VSS cap_mim_2f0_m4m5_noshield c_width=22.18u c_length=22.18u
X2824 DPI_4__Vthr DPI_4__Vthr VDD VDD pfet_03v3 ad=1.12p pd=4.56u as=1.12p ps=4.56u w=4u l=5.12u
X2826 a_19914_13502# DAC_7__Vb VSS VSS nfet_03v3 ad=0.6p pd=3.2u as=0.6p ps=3.2u w=1u l=8u
X2833 a_22014_125050# DAC_7__Vb VSS VSS nfet_03v3 ad=0.6p pd=3.2u as=0.6p ps=3.2u w=1u l=8u
X2836 a_19914_50454# DAC_7__Vb VSS VSS nfet_03v3 ad=0.6p pd=3.2u as=0.6p ps=3.2u w=1u l=8u
X2837 VDD a_89534_14142# a_90162_14492# VDD pfet_03v3 ad=0.3p pd=2.2u as=0.3p ps=2.2u w=0.5u l=0.64u
X2847 bias_0__VT_inh bias_0__VT_inh VDD VDD pfet_03v3 ad=0.2464p pd=1.44u as=0.2464p ps=1.44u w=0.88u l=1.12u
X2857 bias_0__VT_inh Iref VSS VSS nfet_03v3 ad=0.378p pd=2.46u as=0.378p ps=2.46u w=0.63u l=32u
X2864 a_26214_50454# w[9] a_16310_50504# VSS nfet_03v3 ad=0.3p pd=2.2u as=0.14p ps=1.06u w=0.5u l=0.64u
X2869 VDD s[7] a_17058_124892# VDD pfet_03v3 ad=0.3p pd=2.2u as=0.3p ps=2.2u w=0.5u l=0.32u
X2877 a_16310_125100# w[30] a_22014_125050# VSS nfet_03v3 ad=0.14p pd=1.06u as=0.14p ps=1.06u w=0.5u l=0.64u
X2882 a_16310_110912# w[27] a_19914_110862# VSS nfet_03v3 ad=0.14p pd=1.06u as=0.3p ps=2.2u w=0.5u l=0.64u
X2885 VMEM_2 spike[2] a_91170_51444# VSS nfet_03v3 ad=0.3p pd=2.2u as=0.3p ps=2.2u w=0.5u l=11.36u
X2889 VDD neuron_4__VKup a_93348_39284# VDD pfet_03v3 ad=0.6p pd=3.2u as=0.6p ps=3.2u w=1u l=1u
X2891 a_26214_13502# DAC_7__Vb VSS VSS nfet_03v3 ad=0.6p pd=3.2u as=0.6p ps=3.2u w=1u l=8u
X2898 a_19914_80658# w[19] a_16310_80708# VSS nfet_03v3 ad=0.14p pd=1.06u as=0.14p ps=1.06u w=0.5u l=0.64u
X2899 a_22014_50454# DAC_7__Vb VSS VSS nfet_03v3 ad=0.6p pd=3.2u as=0.6p ps=3.2u w=1u l=8u
X2903 VDD DPI_4__Vthr DPI_4__Vthr VDD pfet_03v3 ad=1.12p pd=4.56u as=1.12p ps=4.56u w=4u l=5.12u
X2905 a_93976_39284# a_90162_32968# VMEM_1 VDD pfet_03v3 ad=0.3p pd=2.2u as=0.3p ps=2.2u w=0.5u l=0.64u
X2914 VDD DPI_4__Vthr DAC_7__Isum_e DAC_7__Isum_e nfet_03v3 ad=2.4p pd=9.2u as=2.4p ps=9.2u w=4u l=5.12u
X2923 VDD DPI_4__VT a_62528_83274# VDD pfet_03v3 ad=2.4p pd=9.2u as=2.4p ps=9.2u w=4u l=5.12u
X2930 a_19914_64642# w[15] a_16310_64692# VSS nfet_03v3 ad=0.14p pd=1.06u as=0.14p ps=1.06u w=0.5u l=0.64u
X2934 VDD a_88272_39284# a_89534_32618# VDD pfet_03v3 ad=0.3p pd=2.2u as=0.3p ps=2.2u w=0.5u l=8u
X2937 VDD neuron_4__VNA a_93976_118168# VDD pfet_03v3 ad=0.6p pd=3.2u as=0.6p ps=3.2u w=1u l=1u
X2942 spike[4] a_90162_111852# a_90542_111852# VSS nfet_03v3 ad=0.3p pd=2.2u as=0.3p ps=2.2u w=0.5u l=0.64u
X2944 a_90542_51444# neuron_4__VKdn VSS VSS nfet_03v3 ad=0.6p pd=3.2u as=0.6p ps=3.2u w=1u l=1u
X2950 VDD a_62528_34594# VMEM_1 VDD pfet_03v3 ad=2.4p pd=9.2u as=2.4p ps=9.2u w=4u l=5.12u
X2957 VDD a_89534_51094# a_90162_51444# VDD pfet_03v3 ad=0.3p pd=2.2u as=0.3p ps=2.2u w=0.5u l=0.64u
X2959 VDD DPI_4__Vthr DPI_4__Vthr VDD pfet_03v3 ad=1.12p pd=4.56u as=1.12p ps=4.56u w=4u l=5.12u
X2966 VDD DPI_4__Vthr DAC_3__Isum_e DAC_3__Isum_e nfet_03v3 ad=2.4p pd=9.2u as=2.4p ps=9.2u w=4u l=5.12u
X2968 VDD a_67078_95402# a_62978_89578# VDD pfet_03v3 ad=2.4p pd=9.2u as=2.4p ps=9.2u w=4u l=5.12u
X2977 VMEM_4 VSS cap_mim_2f0_m4m5_noshield c_width=22.18u c_length=22.18u
X2978 a_19914_64642# DAC_7__Vb VSS VSS nfet_03v3 ad=0.6p pd=3.2u as=0.6p ps=3.2u w=1u l=8u
X2981 a_19914_80658# DAC_7__Vb VSS VSS nfet_03v3 ad=0.6p pd=3.2u as=0.6p ps=3.2u w=1u l=8u
X3019 VSS neuron_4__Vlk neuron_4__Vlk VSS nfet_03v3 ad=0.28p pd=1.56u as=0.28p ps=1.56u w=1u l=1u
X3022 VDD a_4687_155814# neuron_4__VK VDD pfet_03v3 ad=6.27p pd=22.1u as=6.27p ps=22.1u w=10.45u l=8u
X3029 a_16310_94896# w[22] a_22014_94846# VSS nfet_03v3 ad=0.14p pd=1.06u as=0.14p ps=1.06u w=0.5u l=0.64u
X3035 a_16558_125100# spike[3] a_16310_125100# VSS nfet_03v3 ad=0.3p pd=2.2u as=0.3p ps=2.2u w=0.5u l=0.64u
X3036 a_22014_64642# DAC_7__Vb VSS VSS nfet_03v3 ad=0.6p pd=3.2u as=0.6p ps=3.2u w=1u l=8u
X3045 a_16558_94896# spike[1] a_16310_94896# VSS nfet_03v3 ad=0.3p pd=2.2u as=0.3p ps=2.2u w=0.5u l=0.64u
X3051 VDD a_4687_155814# neuron_4__VKdn VDD pfet_03v3 ad=7.764p pd=27.08u as=7.764p ps=27.08u w=12.94u l=8u
X3059 a_16310_94896# w[23] a_19914_94846# VSS nfet_03v3 ad=0.14p pd=1.06u as=0.14p ps=1.06u w=0.5u l=0.64u
X3061 VDD a_67078_125606# cap_mim_2f0_m4m5_noshield c_width=22.18u c_length=22.18u
X3079 a_19914_125050# DAC_7__Vb VSS VSS nfet_03v3 ad=0.6p pd=3.2u as=0.6p ps=3.2u w=1u l=8u
X3081 a_19914_110862# DAC_7__Vb VSS VSS nfet_03v3 ad=0.6p pd=3.2u as=0.6p ps=3.2u w=1u l=8u
X3088 a_19914_31978# DAC_7__Vb VSS VSS nfet_03v3 ad=0.6p pd=3.2u as=0.6p ps=3.2u w=1u l=8u
X3090 spike[3] a_90162_81648# a_90542_81648# VSS nfet_03v3 ad=0.3p pd=2.2u as=0.3p ps=2.2u w=0.5u l=0.64u
X3093 a_16310_110912# w[27] a_19914_110862# VSS nfet_03v3 ad=0.14p pd=1.06u as=0.14p ps=1.06u w=0.5u l=0.64u
X3097 a_19914_125050# w[31] a_16310_125100# VSS nfet_03v3 ad=0.14p pd=1.06u as=0.14p ps=1.06u w=0.5u l=0.64u
X3100 neuron_4__VIp neuron_4__VIp VSS VSS nfet_03v3 ad=0.6p pd=3.2u as=0.6p ps=3.2u w=1u l=1u
X3105 VDD a_67078_95402# cap_mim_2f0_m4m5_noshield c_width=22.18u c_length=22.18u
X3106 a_22014_13502# DAC_7__Vb VSS VSS nfet_03v3 ad=0.6p pd=3.2u as=0.6p ps=3.2u w=1u l=8u
X3114 a_19914_94846# DAC_7__Vb VSS VSS nfet_03v3 ad=0.6p pd=3.2u as=0.6p ps=3.2u w=1u l=8u
X3115 VDD DPI_4__Vthr DAC_5__Isum_i DAC_5__Isum_i nfet_03v3 ad=2.4p pd=9.2u as=2.4p ps=9.2u w=4u l=5.12u
X3121 spike[4] VSS cap_mim_2f0_m4m5_noshield c_width=10u c_length=10u
X3124 VDD a_62528_83274# cap_mim_2f0_m4m5_noshield c_width=22.18u c_length=22.18u
X3127 VDD s[0] a_17058_13344# VDD pfet_03v3 ad=0.3p pd=2.2u as=0.3p ps=2.2u w=0.5u l=0.32u
X3139 a_16310_80708# w[17] a_26214_80658# VSS nfet_03v3 ad=0.14p pd=1.06u as=0.3p ps=2.2u w=0.5u l=0.64u
X3140 a_26214_31978# DAC_7__Vb VSS VSS nfet_03v3 ad=0.6p pd=3.2u as=0.6p ps=3.2u w=1u l=8u
X3143 a_62528_34594# a_62528_34594# DAC_6__Isum_e DAC_6__Isum_e nfet_03v3 ad=2.4p pd=9.2u as=2.4p ps=9.2u w=4u l=5.12u
X3147 a_16310_94896# w[23] a_19914_94846# VSS nfet_03v3 ad=0.14p pd=1.06u as=0.14p ps=1.06u w=0.5u l=0.64u
X3168 a_16310_125100# w[31] a_19914_125050# VSS nfet_03v3 ad=0.14p pd=1.06u as=0.3p ps=2.2u w=0.5u l=0.64u
X3171 a_16310_64692# w[13] a_26214_64642# VSS nfet_03v3 ad=0.14p pd=1.06u as=0.3p ps=2.2u w=0.5u l=0.64u
X3172 VDD neuron_4__VNA a_93976_20808# VDD pfet_03v3 ad=0.6p pd=3.2u as=0.6p ps=3.2u w=1u l=1u
X3177 VSS neuron_4__Vlk neuron_4__Vlk VSS nfet_03v3 ad=0.28p pd=1.56u as=0.28p ps=1.56u w=1u l=1u
X3183 VDD DPI_4__VT a_67078_95402# VDD pfet_03v3 ad=2.4p pd=9.2u as=2.4p ps=9.2u w=4u l=5.12u
X3186 VDD DPI_4__Vthr DPI_4__Vthr VDD pfet_03v3 ad=2.4p pd=9.2u as=1.12p ps=4.56u w=4u l=5.12u
X3199 VDD DPI_4__Vthr DPI_4__Vthr VDD pfet_03v3 ad=1.12p pd=4.56u as=1.12p ps=4.56u w=4u l=5.12u
X3200 bias_0__VT_inh bias_0__VT_inh VDD VDD pfet_03v3 ad=0.2464p pd=1.44u as=0.528p ps=2.96u w=0.88u l=1.12u
X3213 a_16310_94896# w[23] a_19914_94846# VSS nfet_03v3 ad=0.14p pd=1.06u as=0.3p ps=2.2u w=0.5u l=0.64u
X3220 DPI_4__Vthr DPI_4__Vthr VDD VDD pfet_03v3 ad=1.12p pd=4.56u as=1.12p ps=4.56u w=4u l=5.12u
X3227 a_89914_14492# neuron_4__VIp VSS VSS nfet_03v3 ad=0.6p pd=3.2u as=0.6p ps=3.2u w=1u l=1u
X3229 a_93976_20808# a_90162_14492# VMEM_0 VDD pfet_03v3 ad=0.3p pd=2.2u as=0.3p ps=2.2u w=0.5u l=0.64u
X3250 a_26214_110862# DAC_7__Vb VSS VSS nfet_03v3 ad=0.6p pd=3.2u as=0.6p ps=3.2u w=1u l=8u
X3251 a_34614_13502# DAC_7__Vb VSS VSS nfet_03v3 ad=0.6p pd=3.2u as=0.6p ps=3.2u w=1u l=8u
X3257 a_22014_50454# DAC_7__Vb VSS VSS nfet_03v3 ad=0.6p pd=3.2u as=0.6p ps=3.2u w=1u l=8u
X3259 VDD DPI_4__Vthr DAC_1__Isum_i DAC_1__Isum_i nfet_03v3 ad=2.4p pd=9.2u as=2.4p ps=9.2u w=4u l=5.12u
X3260 VDD a_88272_20808# a_89534_14142# VDD pfet_03v3 ad=0.3p pd=2.2u as=0.3p ps=2.2u w=0.5u l=8u
X3264 DAC_1__Isum_e a_17058_110704# a_16558_110912# VSS nfet_03v3 ad=0.3p pd=2.2u as=0.3p ps=2.2u w=0.5u l=0.64u
X3266 VDD DPI_4__Vthr DPI_4__Vthr VDD pfet_03v3 ad=1.12p pd=4.56u as=1.12p ps=4.56u w=4u l=5.12u
X3271 VDD DPI_4__VT DPI_4__VT VDD pfet_03v3 ad=1.12p pd=4.56u as=1.12p ps=4.56u w=4u l=5.12u
C0 w[23] w[16] 0.14073f
C1 a_26214_125050# a_19914_125050# 0.27118f
C2 VDD w[20] 0.38875f
C3 a_16310_13552# w[3] 0.364f
C4 w[19] w[1] 0.52804f
C5 a_34614_94846# w[20] 0.04246f
C6 w[23] w[11] 0.13606f
C7 VT VMEM_1 4.14207f
C8 a_93976_20808# a_90162_14492# 0.04621f
C9 w[31] spike[3] 0.07426f
C10 w[31] w[13] 0.22079f
C11 spike[0] a_62528_53070# 0.12569f
C12 VDD pulse[1] 1.09432f
C13 DAC_7__Vb a_22014_50454# 0.37182f
C14 DPI_4__VT VDD 0.14879p
C15 a_89534_14142# neuron_4__Vamp_bias 0.07771f
C16 neuron_4__VNA neuron_4__VKup 72.7259f
C17 w[24] w[8] 0.11022f
C18 w[29] VDD 0.17437f
C19 neuron_4__VIp VMEM_4 0.25899f
C20 s[7] w[28] 1.41835f
C21 w[21] w[1] 0.10783f
C22 a_34614_125050# DAC_1__Isum_i 0.11679f
C23 w[17] VDD 1.98621f
C24 VDD w[10] 0.28806f
C25 VDD DAC_3__Isum_e 20.9233f
C26 a_34614_94846# DAC_3__Isum_e 6.81042f
C27 neuron_4__Vlk Iref 2.05631f
C28 spike[3] VMEM_4 0.42158f
C29 a_90542_81648# neuron_4__VKdn 0.04013f
C30 a_62978_119782# spike[3] 0.09204f
C31 spike[2] a_89534_51094# 0.14351f
C32 DAC_7__Vb w[8] 7.37243f
C33 spike[1] DAC_5__Isum_e 2.04271f
C34 a_19914_125050# a_16310_125100# 17.2602f
C35 a_19914_94846# a_22014_94846# 0.57119f
C36 s[6] w[26] 0.43307f
C37 a_16310_80708# a_19914_80658# 17.2602f
C38 s[2] w[8] 5.16177f
C39 spike[0] a_89914_14492# 0.04786f
C40 neuron_4__VKup a_88272_20808# 3.23931f
C41 a_90542_32968# a_89914_32968# 1.82301f
C42 a_88272_57760# a_89534_51094# 0.68101f
C43 w[14] VDD 0.33487f
C44 w[30] a_16310_125100# 0.18228f
C45 a_87734_32968# neuron_4__Vamp_bias 0.05117f
C46 a_34614_64642# VDD 0.19093f
C47 s[3] s[0] 0.27569f
C48 neuron_4__Vlk neuron_4__Vamp_bias 4.68277f
C49 w[3] w[1] 0.83336f
C50 a_90542_81648# VDD 0.15438f
C51 neuron_4__VNA a_89534_111502# 0.17882f
C52 VDD a_17058_80500# 8.84723f
C53 w[24] s[3] 0.08448f
C54 s[4] w[20] 4.60453f
C55 w[13] w[19] 0.20524f
C56 w[3] w[2] 7.18298f
C57 DPI_4__Vthr a_62528_53070# 1.69204f
C58 DAC_5__Isum_i a_16310_64692# 1.77847f
C59 a_16558_125100# DAC_1__Isum_i 1.32914f
C60 VDD a_26214_110862# 0.26038f
C61 VDD DAC_1__Isum_i 18.3562f
C62 w[3] w[0] 0.33143f
C63 a_91170_32968# neuron_4__VK 0.04013f
C64 s[4] pulse[1] 0.12622f
C65 neuron_4__VK neuron_4__VKup 8.78974f
C66 a_89914_111852# a_87734_111852# 0.02914f
C67 spike[1] a_16558_64692# 0.01869f
C68 a_91170_81648# a_89914_81648# 0.26264f
C69 s[4] w[29] 0.15f
C70 w[21] w[13] 0.18395f
C71 DAC_7__Vb s[3] 6.6298f
C72 VT VMEM_4 1.63653f
C73 s[4] w[10] 0.05345f
C74 w[17] s[4] 0.50877f
C75 spike[1] a_89534_32618# 0.14351f
C76 DPI_4__Vthr VMEM_3 3.05378f
C77 s[2] s[3] 0.71596f
C78 DAC_7__Vb Iref 0.54829f
C79 a_90542_81648# a_88272_87964# 0.01339f
C80 a_26214_80658# DAC_3__Isum_i 10.8659f
C81 w[18] w[9] 0.11981f
C82 a_34614_125050# w[28] 0.04246f
C83 spike[1] w[19] 0.08275f
C84 a_87734_111852# VMEM_4 0.27205f
C85 a_26214_31978# w[5] 0.08445f
C86 spike[0] w[20] 0.13752f
C87 VT a_89534_32618# 0.51489f
C88 a_88272_118168# spike[4] 0.52077f
C89 a_67078_65198# DPI_4__Vthr 2.11209f
C90 w[14] s[4] 0.0789f
C91 w[21] spike[1] 0.2726f
C92 spike[0] DPI_4__VT 2.4455f
C93 w[20] w[27] 0.13155f
C94 DAC_7__Vb neuron_4__Vamp_bias 31.4769f
C95 DAC_1__Isum_e spike[3] 0.25849f
C96 neuron_4__VK a_89534_111502# 0.01248f
C97 w[31] w[15] 0.1464f
C98 a_93976_118168# a_90162_111852# 0.04621f
C99 a_87734_32968# VMEM_1 0.27205f
C100 s[4] a_17058_80500# 3.46922f
C101 spike[0] w[10] 0.14404f
C102 neuron_4__Vlk VMEM_1 0.29877f
C103 a_89534_81298# a_90162_81648# 14.8965f
C104 a_89534_51094# VDD 6.10092f
C105 w[17] spike[0] 0.22965f
C106 w[27] pulse[1] 0.14437f
C107 DAC_1__Isum_e a_16558_110912# 2.10366f
C108 a_16310_110912# a_26214_110862# 1.78781f
C109 DAC_3__Isum_i a_26214_94846# 10.8659f
C110 a_16310_110912# DAC_1__Isum_i 1.77847f
C111 s[5] a_16558_94896# 0.04246f
C112 neuron_4__VIp a_88272_118168# 0.01472f
C113 w[20] w[6] 0.13182f
C114 w[27] w[10] 9.5467f
C115 s[6] w[22] 0.04984f
C116 w[9] a_16310_50504# 0.10002f
C117 w[20] w[7] 2.49058f
C118 DAC_7__Vb a_19914_50454# 0.74342f
C119 a_17058_124892# w[31] 1.50762f
C120 w[9] s[7] 0.04615f
C121 w[6] pulse[1] 0.28684f
C122 VDD w[28] 0.17444f
C123 DAC_7__Vb a_19914_31978# 0.74342f
C124 w[20] w[5] 0.13044f
C125 w[29] w[6] 1.55346f
C126 w[7] pulse[1] 4.0591f
C127 s[0] s[1] 0.65954f
C128 w[14] spike[0] 0.06204f
C129 w[17] w[6] 0.13469f
C130 w[29] w[7] 0.12131f
C131 w[6] w[10] 0.11345f
C132 neuron_4__VIp a_89914_51444# 0.04013f
C133 w[5] pulse[1] 4.1238f
C134 a_22014_94846# w[22] 0.25032f
C135 w[17] w[7] 0.25906f
C136 w[7] w[10] 0.17938f
C137 w[30] w[8] 0.14307f
C138 w[29] w[5] 2.48789f
C139 a_19914_64642# a_17058_64484# 0.11443f
C140 a_34614_125050# a_26214_125050# 7.01128f
C141 spike[0] a_17058_80500# 0.37995f
C142 a_67078_95402# DAC_3__Isum_i 6.12556f
C143 VMEM_0 neuron_4__VKdn 0.18457f
C144 w[5] w[10] 0.21447f
C145 w[17] w[5] 2.93414f
C146 w[13] a_16310_64692# 0.10002f
C147 DPI_4__Vthr DPI_4__VT 39.2204f
C148 w[16] a_34614_80658# 0.04246f
C149 w[19] w[15] 0.20164f
C150 a_87734_14492# neuron_4__Vamp_bias 0.05117f
C151 DAC_7__Vb s[1] 6.94494f
C152 w[18] w[8] 8.85615f
C153 s[6] s[5] 1.4624f
C154 neuron_4__VNA bias_0__VT_inh 0.41113f
C155 DPI_4__Vthr DAC_3__Isum_e 2.8953f
C156 w[14] w[6] 0.1257f
C157 s[2] s[1] 1.95246f
C158 w[21] w[15] 0.28914f
C159 VMEM_1 a_93348_39284# 0.12888f
C160 w[14] w[7] 0.26982f
C161 w[9] w[4] 0.09323f
C162 VDD a_16558_80708# 0.21115f
C163 neuron_4__VKup a_89534_111502# 0.14581f
C164 VDD a_93976_87964# 2.94927f
C165 a_90162_81648# VDD 3.97006f
C166 w[23] w[20] 0.37342f
C167 a_17058_124892# a_22014_125050# 0.05882f
C168 w[20] w[16] 0.11273f
C169 DAC_7__Isum_e a_16310_13552# 0.07931f
C170 w[14] w[5] 0.2566f
C171 a_22014_64642# a_19914_64642# 0.57119f
C172 VMEM_0 VDD 4.44277f
C173 a_90542_14492# neuron_4__VKdn 0.04013f
C174 a_26214_64642# DAC_5__Isum_i 10.8659f
C175 DAC_3__Isum_i VDD 15.2407f
C176 a_22014_50454# a_16310_50504# 15.0391f
C177 a_34614_125050# a_16310_125100# 1.31469f
C178 neuron_4__Vlk VMEM_4 0.51029f
C179 w[23] pulse[1] 0.12687f
C180 spike[1] a_16310_64692# 0.04246f
C181 w[20] w[11] 0.13916f
C182 a_34614_94846# DAC_3__Isum_i 0.11679f
C183 w[26] s[5] 0.14157f
C184 pulse[1] w[16] 0.19476f
C185 a_26214_13502# DAC_7__Vb 0.18591f
C186 s[4] w[28] 0.15f
C187 w[30] s[3] 0.09957f
C188 w[29] w[16] 0.14051f
C189 a_26214_125050# VDD 0.26038f
C190 w[23] w[10] 8.21839f
C191 pulse[1] w[11] 0.38533f
C192 a_88272_118168# a_87734_111852# 2.33814f
C193 w[17] w[16] 7.05645f
C194 a_91170_32968# a_90542_32968# 1.47502f
C195 a_16310_50504# w[8] 0.01848f
C196 a_87734_32968# a_89534_32618# 0.9311f
C197 neuron_4__VIp a_89914_32968# 0.04013f
C198 w[29] w[11] 0.15868f
C199 w[10] w[11] 7.97218f
C200 a_34614_64642# a_17058_64484# 0.75055f
C201 w[17] w[11] 0.1757f
C202 w[18] s[3] 0.08459f
C203 s[7] w[8] 1.28435f
C204 a_90162_81648# a_88272_87964# 4.40172f
C205 w[18] a_16310_80708# 0.18228f
C206 VMEM_2 a_62978_59374# 0.20517f
C207 DPI_4__Vthr DAC_1__Isum_i 2.8953f
C208 a_90542_14492# VDD 0.15438f
C209 a_4687_155814# Iref 13.2228f
C210 w[25] w[3] 0.14074f
C211 neuron_4__VK bias_0__VT_inh 0.15085f
C212 VDD a_93348_20808# 2.79898f
C213 DAC_7__Vb w[31] 1.37791f
C214 a_16558_125100# a_16310_125100# 1.6884f
C215 a_67078_65198# a_62528_53070# 0.15017f
C216 VDD a_16310_125100# 0.54717f
C217 DAC_7__Vb a_34614_31978# 0.093f
C218 a_67118_143686# VDD 0.32513f
C219 a_90162_111852# a_93348_118168# 0.37248f
C220 s[2] w[31] 3.22188f
C221 w[19] a_19914_80658# 0.56837f
C222 w[12] s[3] 27.0014f
C223 VMEM_1 a_62528_34594# 4.24606f
C224 s[4] a_16558_80708# 0.04246f
C225 w[14] w[11] 0.20944f
C226 a_17058_124892# DAC_1__Isum_e 14.2174f
C227 w[14] a_22014_64642# 0.25032f
C228 a_34614_64642# a_22014_64642# 0.11882f
C229 s[4] DAC_3__Isum_i 0.01848f
C230 neuron_4__VIp neuron_4__VNA 5.32349f
C231 w[21] a_16310_94896# 0.10002f
C232 w[28] w[27] 17.8398f
C233 a_4687_155814# neuron_4__Vamp_bias 0.87269f
C234 spike[1] a_89914_32968# 0.04786f
C235 a_16310_13552# pulse[0] 0.04246f
C236 VMEM_4 a_67078_125606# 6.41445f
C237 a_62978_119782# a_67078_125606# 9.93393f
C238 a_16558_32028# a_16310_32028# 1.6884f
C239 a_16558_13552# DAC_7__Isum_e 2.10366f
C240 a_62528_113478# VMEM_4 4.23596f
C241 w[8] w[4] 0.32288f
C242 s[6] w[1] 0.06045f
C243 s[7] s[3] 0.13488f
C244 w[9] VDD 0.28285f
C245 a_93976_118168# VDD 2.94927f
C246 neuron_4__VNA spike[3] 0.07696f
C247 VT a_90162_51444# 0.07035f
C248 neuron_4__Vamp_bias VMEM_2 2.00815f
C249 w[28] w[6] 3.56342f
C250 s[6] w[2] 0.0414f
C251 a_16310_64692# w[15] 0.364f
C252 w[28] w[7] 0.09825f
C253 s[6] w[0] 0.05055f
C254 neuron_4__VK a_91170_14492# 0.04013f
C255 a_90162_111852# neuron_4__Vamp_bias 0.06057f
C256 DAC_7__Vb a_22014_125050# 0.37182f
C257 w[28] w[5] 0.87036f
C258 spike[0] a_16558_80708# 0.01869f
C259 DAC_7__Vb w[19] 1.66355f
C260 a_87734_81648# neuron_4__Vamp_bias 0.05117f
C261 a_26214_80658# a_16310_80708# 1.78781f
C262 a_16558_32028# s[1] 0.04246f
C263 neuron_4__VK spike[4] 0.08809f
C264 spike[0] VMEM_0 2.78018f
C265 w[26] w[1] 0.13813f
C266 s[2] w[19] 0.23419f
C267 a_26214_64642# w[13] 0.08445f
C268 neuron_4__VKup bias_0__VT_inh 0.4273f
C269 w[22] s[5] 0.40861f
C270 w[21] DAC_7__Vb 4.07706f
C271 a_17058_13344# a_26214_13502# 0.06004f
C272 spike[1] neuron_4__VNA 0.0662f
C273 a_62528_53070# DPI_4__VT 1.39792f
C274 s[2] w[21] 0.74477f
C275 s[3] w[4] 0.01984f
C276 neuron_4__VIp neuron_4__VK 48.0461f
C277 w[1] pulse[0] 0.08662f
C278 VT neuron_4__VNA 1.58714f
C279 spike[1] a_16558_94896# 0.01869f
C280 a_19914_50454# a_16310_50504# 17.2602f
C281 w[2] pulse[0] 0.10229f
C282 w[3] s[0] 0.9894f
C283 spike[0] a_90542_14492# 1.35619f
C284 VMEM_3 DPI_4__VT 0.60257f
C285 neuron_4__VK spike[3] 0.16365f
C286 s[6] w[13] 0.0664f
C287 a_90162_32968# neuron_4__Vamp_bias 0.06057f
C288 w[9] s[4] 0.05345f
C289 VDD a_22014_50454# 0.42217f
C290 a_22014_110862# w[26] 0.25032f
C291 s[6] spike[3] 0.25978f
C292 w[24] w[3] 0.1234f
C293 a_16558_13552# pulse[0] 0.01869f
C294 w[0] pulse[0] 0.56155f
C295 spike[0] a_93348_20808# 1.98323f
C296 w[28] w[16] 0.14051f
C297 s[6] a_16558_110912# 0.04246f
C298 VMEM_3 DAC_3__Isum_e 0.0248f
C299 w[12] s[1] 0.18191f
C300 a_17058_50296# a_22014_50454# 0.05882f
C301 a_93976_39284# VMEM_1 0.93986f
C302 w[28] w[11] 0.14993f
C303 w[31] a_19914_125050# 0.56837f
C304 spike[2] neuron_4__Vamp_bias 0.67858f
C305 VT a_87734_51444# 0.26497f
C306 DPI_4__Vthr VMEM_0 0.06828f
C307 DAC_1__Isum_e DAC_7__Vb 1.19018f
C308 a_67078_65198# DPI_4__VT 1.9254f
C309 DAC_7__Vb w[3] 1.44243f
C310 VDD w[8] 0.34194f
C311 DPI_4__Vthr DAC_3__Isum_i 2.8953f
C312 VT a_88272_20808# 0.01016f
C313 s[2] w[3] 0.56415f
C314 w[26] w[13] 0.19176f
C315 a_88272_57760# neuron_4__Vamp_bias 0.04161f
C316 DAC_1__Isum_e a_62528_113478# 7.70074f
C317 s[7] s[1] 0.19273f
C318 spike[1] neuron_4__VK 0.15762f
C319 w[31] w[30] 32.9121f
C320 a_89534_81298# neuron_4__Vamp_bias 0.09962f
C321 spike[0] w[9] 0.1426f
C322 a_26214_50454# w[9] 0.08445f
C323 a_90542_81648# VMEM_3 0.25888f
C324 a_87734_81648# a_89914_81648# 0.02914f
C325 a_34614_110862# DAC_1__Isum_e 6.81042f
C326 neuron_4__VKdn Iref 0.30659f
C327 a_16310_32028# w[4] 0.01848f
C328 VT neuron_4__VK 3.45873f
C329 DAC_5__Isum_e VMEM_2 0.0248f
C330 VDD a_62978_59374# 4.6034f
C331 w[9] w[27] 9.52949f
C332 neuron_4__VIp neuron_4__VKup 1.82963f
C333 DAC_3__Isum_e a_34614_80658# 6.81042f
C334 a_87734_32968# a_89914_32968# 0.02914f
C335 spike[1] w[26] 13.2327f
C336 a_22014_125050# a_19914_125050# 0.57119f
C337 a_89534_14142# neuron_4__VNA 0.16899f
C338 neuron_4__VKup spike[3] 0.07591f
C339 s[3] VDD 2.01963f
C340 w[22] w[1] 0.12355f
C341 VDD a_93348_118168# 2.79898f
C342 w[20] pulse[1] 0.10382f
C343 a_90162_32968# VMEM_1 0.29575f
C344 a_16310_80708# VDD 0.54717f
C345 w[9] w[6] 0.26824f
C346 w[29] w[20] 0.12114f
C347 a_67118_143686# DPI_4__Vthr 2.2169f
C348 a_16558_32028# a_17058_31820# 0.11824f
C349 a_89914_111852# a_90162_111852# 1.31172f
C350 w[31] w[12] 0.15739f
C351 VDD Iref 0.93129f
C352 w[9] w[7] 0.18752f
C353 w[20] w[10] 0.12307f
C354 neuron_4__Vamp_bias neuron_4__VKdn 21.5369f
C355 w[4] s[1] 1.07609f
C356 a_89534_111502# spike[4] 0.14351f
C357 a_90162_14492# VDD 3.95804f
C358 a_34614_50454# DAC_5__Isum_i 0.11679f
C359 DAC_5__Isum_e a_16310_50504# 0.07931f
C360 s[4] w[8] 0.05423f
C361 w[29] pulse[1] 2.73637f
C362 w[30] a_22014_125050# 0.25032f
C363 w[9] w[5] 0.61351f
C364 pulse[1] w[10] 0.19821f
C365 w[17] pulse[1] 0.23597f
C366 a_93976_20808# neuron_4__VNA 0.04168f
C367 a_90542_111852# a_90162_111852# 0.67211f
C368 a_17058_80500# a_34614_80658# 0.75055f
C369 w[17] w[10] 0.13197f
C370 a_90162_111852# VMEM_4 0.29575f
C371 a_89534_14142# a_88272_20808# 0.68101f
C372 a_34614_64642# a_19914_64642# 0.16484f
C373 a_91170_32968# spike[1] 1.13486f
C374 w[31] s[7] 7.91396f
C375 neuron_4__VIp a_89534_111502# 0.07935f
C376 spike[1] neuron_4__VKup 0.06046f
C377 w[18] w[19] 18.741f
C378 a_26214_50454# a_22014_50454# 0.29412f
C379 neuron_4__VK a_91170_81648# 0.04013f
C380 VDD neuron_4__Vamp_bias 12.8088f
C381 w[14] w[20] 4.81571f
C382 s[5] w[1] 0.35296f
C383 a_88272_39284# VMEM_1 1.71072f
C384 neuron_4__Vlk neuron_4__VNA 4.26834f
C385 s[6] w[15] 0.07061f
C386 s[6] w[25] 0.4394f
C387 s[5] w[2] 0.05348f
C388 w[14] pulse[1] 1.38079f
C389 a_17058_13344# w[3] 1.50762f
C390 VT neuron_4__VKup 6.84349f
C391 s[5] w[0] 0.59186f
C392 a_89534_81298# a_89914_81648# 0.60758f
C393 w[17] w[14] 0.13249f
C394 a_89534_14142# neuron_4__VK 0.02793f
C395 w[14] w[10] 0.25757f
C396 a_26214_13502# a_34614_13502# 7.01128f
C397 spike[0] w[8] 0.15659f
C398 a_19914_50454# VDD 0.75723f
C399 w[9] w[23] 0.12425f
C400 w[19] w[12] 0.14994f
C401 w[13] w[22] 0.19176f
C402 s[4] s[3] 0.42086f
C403 VDD a_19914_31978# 0.77619f
C404 a_16310_32028# VDD 2.32564f
C405 w[27] w[8] 0.10555f
C406 a_19914_50454# a_17058_50296# 0.11443f
C407 a_17058_80500# DAC_3__Isum_e 14.2174f
C408 neuron_4__Vamp_bias a_88272_87964# 0.03762f
C409 w[26] w[15] 0.12288f
C410 w[25] w[26] 21.9939f
C411 a_16310_94896# a_16558_94896# 1.6884f
C412 w[9] w[11] 0.60805f
C413 w[21] w[12] 0.12906f
C414 VMEM_1 neuron_4__VKdn 0.24376f
C415 a_93348_87964# neuron_4__VKup 0.04013f
C416 a_16310_13552# w[1] 0.10002f
C417 a_34614_31978# w[4] 0.04246f
C418 a_16310_13552# w[2] 0.18228f
C419 w[8] w[6] 0.50908f
C420 s[7] w[19] 0.04411f
C421 w[8] w[7] 2.90594f
C422 spike[2] VMEM_4 0.30362f
C423 a_62528_83274# a_67078_95402# 0.15017f
C424 a_16558_13552# a_16310_13552# 1.6884f
C425 a_16310_13552# w[0] 0.01848f
C426 w[18] w[3] 0.123f
C427 VDD s[1] 2.69416f
C428 a_90162_32968# a_89534_32618# 14.8965f
C429 spike[1] w[22] 0.21228f
C430 w[8] w[5] 1.04482f
C431 neuron_4__Vlk neuron_4__VK 20.2004f
C432 w[21] s[7] 0.04411f
C433 VT a_89534_111502# 0.51489f
C434 w[13] s[5] 0.06299f
C435 spike[0] s[3] 0.05589f
C436 DAC_7__Vb neuron_4__VNA 0.17425f
C437 spike[0] a_16310_80708# 0.04246f
C438 VMEM_1 VDD 4.51808f
C439 a_93348_57760# a_93976_57760# 0.53841f
C440 VMEM_3 a_93976_87964# 0.93986f
C441 a_90162_81648# VMEM_3 0.29575f
C442 a_90542_32968# spike[1] 1.35619f
C443 spike[0] a_90162_14492# 9.68412f
C444 a_17058_94688# a_16558_94896# 0.11824f
C445 a_89534_111502# a_87734_111852# 0.9311f
C446 VMEM_3 DAC_3__Isum_i 0.58594f
C447 s[3] w[27] 0.0871f
C448 a_16310_94896# a_19914_94846# 17.2602f
C449 VDD a_89914_81648# 0.14568f
C450 a_89914_14492# VMEM_0 0.1368f
C451 a_19914_13502# a_26214_13502# 0.27118f
C452 a_62528_83274# VDD 11.7541f
C453 DAC_1__Isum_i a_26214_110862# 10.8659f
C454 DAC_7__Vb a_22014_31978# 0.37182f
C455 a_26214_13502# VDD 11.1263f
C456 a_89534_14142# neuron_4__VKup 0.15239f
C457 a_26214_64642# DAC_7__Vb 0.18591f
C458 w[19] w[4] 1.69091f
C459 s[3] w[6] 0.02161f
C460 w[28] w[20] 0.1215f
C461 s[3] w[7] 0.02021f
C462 spike[1] s[5] 1.94838f
C463 a_88272_39284# a_89534_32618# 0.68101f
C464 s[6] s[0] 0.11775f
C465 a_16310_94896# a_22014_94846# 15.0391f
C466 s[7] w[3] 0.06269f
C467 w[28] pulse[1] 2.84565f
C468 a_90542_111852# neuron_4__VKdn 0.04013f
C469 w[2] w[1] 7.14561f
C470 w[23] w[8] 0.11175f
C471 a_88272_118168# a_90162_111852# 4.40172f
C472 spike[0] neuron_4__Vamp_bias 0.82345f
C473 w[21] w[4] 7.74471f
C474 s[3] w[5] 0.02178f
C475 a_93348_57760# a_90162_51444# 0.37248f
C476 w[29] w[28] 32.4394f
C477 w[8] w[16] 0.23965f
C478 s[6] w[24] 1.40814f
C479 DAC_5__Isum_e VDD 21.4185f
C480 neuron_4__VIp bias_0__VT_inh 0.15808f
C481 neuron_4__VKdn VMEM_4 0.31794f
C482 w[1] w[0] 6.6254f
C483 a_89914_14492# a_90542_14492# 1.82301f
C484 a_89914_51444# VMEM_2 0.1368f
C485 a_89914_111852# VDD 0.14568f
C486 s[4] s[1] 0.21024f
C487 w[2] w[0] 1.79445f
C488 a_89914_81648# a_88272_87964# 0.09468f
C489 w[8] w[11] 6.93488f
C490 DAC_5__Isum_e a_17058_50296# 14.2174f
C491 DAC_7__Vb neuron_4__VK 0.23342f
C492 w[21] a_26214_94846# 0.08445f
C493 a_17058_94688# a_19914_94846# 0.11443f
C494 w[31] VDD 0.28982f
C495 a_34614_125050# a_22014_125050# 0.11882f
C496 s[6] DAC_7__Vb 6.98569f
C497 DAC_3__Isum_i a_34614_80658# 0.11679f
C498 a_26214_50454# a_19914_50454# 0.27118f
C499 DPI_4__Vthr Iref 4.98084f
C500 VDD a_34614_31978# 0.30771f
C501 w[12] a_16310_64692# 0.01848f
C502 a_19914_94846# DAC_7__Vb 0.74342f
C503 s[3] a_17058_64484# 3.46922f
C504 neuron_4__Vlk neuron_4__VKup 14.5159f
C505 a_93976_57760# VMEM_2 0.93986f
C506 s[2] s[6] 0.11693f
C507 a_90542_111852# VDD 0.15438f
C508 w[22] w[15] 0.1239f
C509 w[26] w[24] 0.08348f
C510 a_17058_94688# a_22014_94846# 0.05882f
C511 VDD VMEM_4 5.13844f
C512 a_62978_119782# VDD 4.61125f
C513 a_17058_110704# DAC_1__Isum_e 14.2174f
C514 DAC_7__Vb a_22014_94846# 0.37182f
C515 pulse[0] s[0] 1.60436f
C516 w[3] w[4] 0.46689f
C517 a_16558_64692# VDD 0.21115f
C518 a_87734_14492# a_88272_20808# 2.33814f
C519 DAC_7__Vb w[26] 1.45018f
C520 DAC_5__Isum_i spike[1] 0.17987f
C521 s[3] w[23] 0.08448f
C522 s[3] w[16] 0.10096f
C523 VMEM_0 DPI_4__VT 0.30011f
C524 DPI_4__Vthr neuron_4__Vamp_bias 0.48017f
C525 a_16310_80708# w[16] 0.01848f
C526 a_16558_80708# DAC_3__Isum_e 2.10366f
C527 s[2] w[26] 0.26991f
C528 a_16310_32028# w[6] 0.18228f
C529 s[3] w[11] 0.01984f
C530 VDD a_89534_32618# 6.10087f
C531 a_19914_31978# w[7] 0.56837f
C532 a_17058_31820# VDD 8.97515f
C533 a_16310_32028# w[7] 0.364f
C534 spike[0] VMEM_1 0.02577f
C535 DAC_3__Isum_i DAC_3__Isum_e 11.4443f
C536 neuron_4__VIp spike[4] 0.11374f
C537 a_90162_51444# VMEM_2 0.29575f
C538 a_22014_125050# VDD 0.42217f
C539 DAC_7__Vb pulse[0] 0.08662f
C540 a_16310_32028# w[5] 0.10002f
C541 s[5] w[15] 7.36008f
C542 w[25] s[5] 0.38478f
C543 a_26214_125050# w[29] 0.08445f
C544 w[19] VDD 0.36147f
C545 neuron_4__Vlk a_89534_111502# 0.03125f
C546 s[2] pulse[0] 0.02302f
C547 spike[3] spike[4] 14.2794f
C548 a_34614_125050# DAC_1__Isum_e 6.81042f
C549 a_62528_34594# DAC_6__Isum_e 7.7433f
C550 w[31] s[4] 0.1745f
C551 w[6] s[1] 0.60645f
C552 spike[2] a_89914_51444# 0.04786f
C553 w[21] VDD 0.97279f
C554 w[7] s[1] 5.59897f
C555 DAC_7__Vb neuron_4__VKup 0.17425f
C556 a_93348_39284# neuron_4__VKup 0.04013f
C557 a_16558_80708# a_17058_80500# 0.11824f
C558 a_22014_80658# a_19914_80658# 0.57119f
C559 a_90162_81648# a_90542_81648# 0.67211f
C560 a_88272_57760# a_89914_51444# 0.09468f
C561 w[5] s[1] 3.83146f
C562 a_19914_110862# a_22014_110862# 0.57119f
C563 spike[2] a_93976_57760# 0.28806f
C564 DAC_3__Isum_i a_17058_80500# 0.05814f
C565 a_16310_94896# w[22] 0.18228f
C566 neuron_4__VIp spike[3] 0.15542f
C567 a_4687_155814# neuron_4__VNA 0.15709f
C568 DAC_7__Isum_e a_17058_13344# 14.2174f
C569 w[29] a_16310_125100# 0.10002f
C570 VDD a_62528_16118# 11.6146f
C571 a_26214_50454# DAC_5__Isum_e 2.06134f
C572 spike[1] spike[4] 0.09117f
C573 a_19914_50454# w[11] 0.56837f
C574 w[9] w[20] 0.1216f
C575 neuron_4__VNA VMEM_2 5.06114f
C576 a_93976_39284# neuron_4__VNA 0.04168f
C577 DPI_4__Vthr VMEM_1 0.21793f
C578 a_26214_125050# DAC_1__Isum_i 10.8659f
C579 a_19914_13502# w[3] 0.56837f
C580 DAC_1__Isum_e a_16558_125100# 2.10366f
C581 VDD w[3] 0.19721f
C582 DAC_1__Isum_e VDD 18.1312f
C583 w[9] pulse[1] 0.22312f
C584 neuron_4__VNA a_90162_111852# 0.40674f
C585 VT spike[4] 0.07353f
C586 a_90162_32968# a_89914_32968# 1.31172f
C587 s[4] w[19] 0.41113f
C588 DAC_7__Vb a_22014_80658# 0.37182f
C589 w[17] w[9] 0.13289f
C590 w[9] w[10] 9.82583f
C591 a_16558_32028# DAC_6__Isum_e 2.10366f
C592 a_62528_83274# DPI_4__Vthr 1.25274f
C593 neuron_4__VIp spike[1] 0.1535f
C594 spike[2] a_90162_51444# 9.68412f
C595 a_87734_51444# VMEM_2 0.27205f
C596 s[6] w[30] 0.12975f
C597 w[21] s[4] 0.12314f
C598 DAC_7__Vb w[22] 1.37823f
C599 a_90542_51444# a_89914_51444# 1.82301f
C600 a_88272_118168# VDD 10.7242f
C601 w[31] w[6] 3.42869f
C602 spike[1] spike[3] 0.08383f
C603 spike[1] w[13] 0.14714f
C604 a_88272_57760# a_90162_51444# 4.40172f
C605 s[1] w[11] 3.15536f
C606 w[31] w[7] 0.13006f
C607 VT neuron_4__VIp 23.9581f
C608 s[2] w[22] 0.5827f
C609 a_16310_125100# DAC_1__Isum_i 1.77847f
C610 DPI_4__Vthr DAC_5__Isum_e 2.8953f
C611 s[5] s[0] 0.13139f
C612 a_4687_155814# neuron_4__VK 0.93193f
C613 w[18] s[6] 0.04109f
C614 w[25] w[1] 0.13813f
C615 w[14] w[9] 0.10318f
C616 a_26214_13502# a_22014_13502# 0.29412f
C617 VT spike[3] 0.15063f
C618 a_17058_13344# pulse[0] 0.37995f
C619 w[24] s[5] 0.38296f
C620 a_88272_39284# a_89914_32968# 0.09468f
C621 spike[0] w[19] 0.2344f
C622 DAC_5__Isum_e a_17058_64484# 14.2174f
C623 neuron_4__VK VMEM_2 2.69771f
C624 a_89914_51444# VDD 0.14568f
C625 neuron_4__VNA a_90162_32968# 0.40552f
C626 VDD a_16310_64692# 0.54717f
C627 a_93348_57760# neuron_4__VKup 0.04013f
C628 a_17058_94688# s[5] 3.46922f
C629 a_67078_65198# a_62978_59374# 9.93393f
C630 spike[2] neuron_4__VNA 0.07507f
C631 spike[0] w[21] 0.13904f
C632 DAC_1__Isum_e a_16310_110912# 0.07931f
C633 s[6] w[12] 0.06614f
C634 DAC_7__Vb s[5] 6.48874f
C635 s[4] w[3] 0.08338f
C636 neuron_4__Vlk bias_0__VT_inh 0.17447f
C637 a_93976_57760# VDD 2.94927f
C638 a_93348_87964# spike[3] 1.98323f
C639 DPI_4__Vthr VMEM_4 3.5521f
C640 a_89914_14492# a_90162_14492# 1.31172f
C641 a_17058_31820# w[7] 1.52889f
C642 w[20] w[8] 0.2156f
C643 s[2] s[5] 0.23942f
C644 a_22014_50454# w[10] 0.25032f
C645 a_88272_57760# neuron_4__VNA 0.33945f
C646 w[19] w[6] 0.11764f
C647 VT spike[1] 0.13048f
C648 a_90542_51444# a_90162_51444# 0.67211f
C649 a_34614_50454# DAC_7__Vb 0.093f
C650 w[19] w[7] 0.20144f
C651 w[8] pulse[1] 0.27587f
C652 w[31] w[16] 0.15971f
C653 s[6] s[7] 49.5553f
C654 a_89534_81298# neuron_4__VNA 0.1689f
C655 a_16558_64692# a_17058_64484# 0.11824f
C656 VMEM_3 neuron_4__Vamp_bias 1.39008f
C657 w[29] w[8] 0.14307f
C658 a_88272_39284# neuron_4__VNA 0.33701f
C659 w[19] w[5] 0.12297f
C660 w[8] w[10] 0.27736f
C661 w[26] w[12] 0.12374f
C662 w[21] w[6] 0.1169f
C663 w[17] w[8] 1.16632f
C664 w[31] w[11] 7.751f
C665 spike[3] a_91170_81648# 1.13486f
C666 w[21] w[7] 2.90342f
C667 a_16310_80708# a_34614_80658# 1.31469f
C668 a_90162_81648# a_93976_87964# 0.04621f
C669 a_88272_57760# a_87734_51444# 2.33814f
C670 w[13] w[15] 25.6638f
C671 DAC_3__Isum_i a_16558_80708# 1.32914f
C672 w[25] w[13] 0.19176f
C673 w[21] w[5] 0.13046f
C674 VDD a_90162_51444# 3.95789f
C675 a_4687_155814# neuron_4__VKup 0.15253f
C676 w[28] a_16310_125100# 0.01848f
C677 a_89914_32968# VDD 0.14568f
C678 VT a_87734_111852# 0.26497f
C679 w[26] s[7] 0.0616f
C680 s[3] w[20] 0.07787f
C681 neuron_4__VKup VMEM_2 0.0647f
C682 w[27] w[3] 1.42948f
C683 w[14] w[8] 0.21139f
C684 spike[2] neuron_4__VK 13.3995f
C685 a_17058_124892# spike[3] 0.37995f
C686 DAC_7__Vb bias_0__VT_inh 0.18693f
C687 neuron_4__Vlk spike[4] 1.91288f
C688 spike[2] s[6] 1.13659f
C689 DAC_7__Isum_e a_34614_13502# 6.81042f
C690 neuron_4__VNA neuron_4__VKdn 0.86752f
C691 s[2] DAC_5__Isum_i 0.01848f
C692 a_17058_110704# s[6] 3.46922f
C693 s[3] pulse[1] 0.14182f
C694 neuron_4__VKup a_90162_111852# 0.83865f
C695 s[6] w[4] 0.05028f
C696 w[3] w[6] 0.28548f
C697 w[29] s[3] 0.09601f
C698 spike[1] w[15] 0.13553f
C699 w[1] s[0] 1.57373f
C700 w[9] w[28] 9.40912f
C701 a_16558_50504# DAC_5__Isum_e 2.10366f
C702 w[25] spike[1] 0.12852f
C703 w[3] w[7] 0.17019f
C704 w[17] s[3] 0.0941f
C705 VMEM_0 a_90542_14492# 0.25888f
C706 DPI_4__Vthr a_62528_16118# 1.25274f
C707 w[2] s[0] 0.63299f
C708 s[3] w[10] 0.02161f
C709 w[19] w[16] 0.66196f
C710 a_26214_31978# a_19914_31978# 0.27118f
C711 w[17] a_16310_80708# 0.10002f
C712 a_16310_32028# a_26214_31978# 1.78781f
C713 DPI_4__VT Iref 0.23534f
C714 w[24] w[1] 0.12274f
C715 a_16310_80708# DAC_3__Isum_e 0.07931f
C716 w[19] w[11] 0.14577f
C717 a_16558_13552# s[0] 0.04246f
C718 w[21] w[23] 0.0901f
C719 neuron_4__Vlk neuron_4__VIp 7.23827f
C720 VMEM_0 a_93348_20808# 0.12888f
C721 w[3] w[5] 0.703f
C722 w[0] s[0] 1.47628f
C723 spike[2] w[26] 0.08662f
C724 a_19914_94846# a_26214_94846# 0.27118f
C725 w[18] a_22014_80658# 0.25032f
C726 w[21] w[16] 0.12073f
C727 neuron_4__VNA VDD 36.3753f
C728 DAC_1__Isum_e DPI_4__Vthr 2.8953f
C729 DAC_7__Vb w[1] 1.4798f
C730 w[21] w[11] 0.14499f
C731 neuron_4__Vlk spike[3] 1.97173f
C732 DAC_7__Vb w[2] 1.78926f
C733 s[2] w[1] 0.89514f
C734 w[14] s[3] 0.35769f
C735 a_22014_94846# a_26214_94846# 0.29412f
C736 a_91170_51444# a_89914_51444# 0.26264f
C737 DPI_4__VT neuron_4__Vamp_bias 0.27069f
C738 a_89534_14142# VT 0.51489f
C739 VMEM_3 a_89914_81648# 0.1368f
C740 VDD a_16558_94896# 0.21115f
C741 s[2] w[2] 0.34892f
C742 a_26214_125050# a_16310_125100# 1.78781f
C743 a_62528_83274# VMEM_3 4.23834f
C744 DAC_5__Isum_e a_62528_53070# 7.72842f
C745 DAC_7__Vb w[0] 7.20632f
C746 a_16310_80708# a_17058_80500# 0.10497f
C747 a_90162_111852# a_89534_111502# 14.8965f
C748 VDD a_87734_51444# 0.22723f
C749 a_90162_32968# neuron_4__VKup 0.83895f
C750 a_22014_31978# VDD 13.3088f
C751 s[2] w[0] 0.21447f
C752 a_26214_64642# VDD 0.26038f
C753 neuron_4__VK neuron_4__VKdn 33.8143f
C754 neuron_4__VNA a_88272_87964# 0.33746f
C755 VDD a_88272_20808# 10.718f
C756 spike[2] neuron_4__VKup 5.15232f
C757 w[30] s[5] 0.14594f
C758 w[12] w[22] 0.12365f
C759 a_22014_110862# DAC_7__Vb 0.37182f
C760 w[23] w[3] 0.24784f
C761 neuron_4__Vlk spike[1] 1.96098f
C762 a_16310_32028# pulse[1] 0.04246f
C763 DAC_7__Isum_e VDD 19.7697f
C764 a_17058_13344# a_16310_13552# 0.10497f
C765 w[13] w[24] 0.20051f
C766 w[3] w[11] 0.37686f
C767 a_88272_57760# neuron_4__VKup 3.23931f
C768 w[18] s[5] 0.84607f
C769 a_16310_94896# spike[1] 0.04246f
C770 VDD DAC_6__Isum_e 19.215f
C771 neuron_4__VIp DAC_7__Vb 0.23515f
C772 VT a_87734_32968# 0.26497f
C773 w[25] w[15] 0.12299f
C774 neuron_4__VK VDD 6.42208f
C775 neuron_4__Vlk VT 7.82613f
C776 s[6] VDD 1.71199f
C777 s[7] w[22] 0.05286f
C778 w[28] w[8] 0.12558f
C779 a_89534_81298# neuron_4__VKup 0.14153f
C780 a_17058_64484# a_16310_64692# 0.10497f
C781 a_88272_39284# neuron_4__VKup 3.24408f
C782 a_19914_94846# VDD 0.75723f
C783 pulse[1] s[1] 6.13764f
C784 DAC_7__Vb spike[3] 20.2795f
C785 DAC_7__Vb w[13] 1.45f
C786 a_34614_110862# a_22014_110862# 0.11882f
C787 a_26214_80658# a_22014_80658# 0.29412f
C788 a_34614_94846# a_19914_94846# 0.16484f
C789 spike[3] a_67078_125606# 0.38425f
C790 a_19914_110862# DAC_7__Vb 0.74342f
C791 w[12] s[5] 0.30524f
C792 s[1] w[10] 0.52403f
C793 VMEM_1 DPI_4__VT 0.36737f
C794 a_22014_94846# VDD 0.42217f
C795 spike[1] w[24] 0.13423f
C796 a_34614_31978# a_26214_31978# 7.01128f
C797 a_34614_94846# a_22014_94846# 0.11882f
C798 w[26] VDD 0.15988f
C799 a_17058_94688# spike[1] 0.37995f
C800 a_22014_64642# a_16310_64692# 15.0391f
C801 a_90542_32968# a_90162_32968# 0.67211f
C802 neuron_4__VKup neuron_4__VKdn 11.3056f
C803 DAC_7__Vb spike[1] 0.52619f
C804 a_62528_83274# DPI_4__VT 1.39296f
C805 s[7] s[5] 0.99904f
C806 spike[0] neuron_4__VNA 0.06368f
C807 spike[1] a_93348_39284# 1.98323f
C808 w[22] w[4] 7.62193f
C809 a_89914_111852# a_91170_111852# 0.26264f
C810 w[14] s[1] 0.30411f
C811 s[3] w[28] 0.0959f
C812 a_34614_110862# a_19914_110862# 0.16484f
C813 s[2] spike[1] 0.31284f
C814 VDD pulse[0] 0.0889f
C815 a_62528_83274# DAC_3__Isum_e 7.73296f
C816 a_34614_50454# a_16310_50504# 1.31469f
C817 a_4687_155814# bias_0__VT_inh 0.15431f
C818 a_90542_111852# a_91170_111852# 1.47502f
C819 DAC_5__Isum_i VMEM_2 0.58594f
C820 s[6] s[4] 19.1151f
C821 a_17058_31820# a_26214_31978# 0.06004f
C822 a_16558_13552# a_17058_13344# 0.11824f
C823 a_89534_51094# neuron_4__Vamp_bias 0.10647f
C824 w[31] w[20] 0.16727f
C825 a_91170_32968# VDD 0.17724f
C826 VDD neuron_4__VKup 15.2843f
C827 a_91170_111852# VMEM_4 3.31883f
C828 w[30] w[1] 0.13409f
C829 spike[0] a_88272_20808# 0.52077f
C830 a_88272_39284# a_90542_32968# 0.01339f
C831 w[31] w[29] 0.0901f
C832 a_90542_81648# a_89914_81648# 1.82301f
C833 s[5] w[4] 0.1781f
C834 a_89534_111502# neuron_4__VKdn 0.04669f
C835 w[26] s[4] 0.1325f
C836 w[18] w[1] 0.21955f
C837 DAC_5__Isum_i a_16310_50504# 1.77847f
C838 w[26] a_16310_110912# 0.18228f
C839 a_16310_80708# a_16558_80708# 1.6884f
C840 DPI_4__Vthr neuron_4__VNA 0.54241f
C841 DPI_4__VT VMEM_4 0.29967f
C842 a_22014_31978# w[6] 0.25032f
C843 w[25] w[24] 22.2157f
C844 neuron_4__VKup a_88272_87964# 3.24806f
C845 w[24] w[15] 0.13181f
C846 spike[0] neuron_4__VK 0.19138f
C847 a_16310_80708# DAC_3__Isum_i 1.77847f
C848 a_34614_64642# DAC_5__Isum_e 6.81042f
C849 VMEM_0 a_90162_14492# 0.29575f
C850 VT a_87734_14492# 0.26497f
C851 a_22014_80658# VDD 0.42217f
C852 VDD a_89534_111502# 6.10375f
C853 a_90542_32968# neuron_4__VKdn 0.04013f
C854 DAC_7__Vb w[15] 1.50623f
C855 s[6] w[27] 0.41594f
C856 w[25] DAC_7__Vb 1.45062f
C857 a_17058_31820# pulse[1] 0.37995f
C858 w[19] w[20] 5.62387f
C859 a_91170_51444# neuron_4__VK 0.04013f
C860 s[2] w[15] 0.08722f
C861 s[2] w[25] 0.2876f
C862 w[9] w[8] 7.21115f
C863 w[19] pulse[1] 0.10988f
C864 w[22] VDD 0.40004f
C865 w[13] w[30] 0.20602f
C866 w[21] w[20] 13.5667f
C867 a_90162_81648# neuron_4__Vamp_bias 0.08699f
C868 s[6] w[6] 0.06793f
C869 w[30] spike[3] 0.08662f
C870 a_26214_64642# a_17058_64484# 0.06004f
C871 VMEM_0 neuron_4__Vamp_bias 1.99513f
C872 s[6] w[7] 0.17829f
C873 w[17] w[19] 0.09024f
C874 DAC_7__Isum_e DPI_4__Vthr 2.8953f
C875 s[7] w[1] 3.64256f
C876 w[19] w[10] 0.1365f
C877 neuron_4__VIp a_4687_155814# 0.35546f
C878 a_34614_13502# a_16310_13552# 1.31469f
C879 a_90162_111852# spike[4] 9.68412f
C880 a_90162_14492# a_90542_14492# 0.67211f
C881 s[7] w[2] 0.03426f
C882 w[21] pulse[1] 0.12705f
C883 a_90542_32968# VDD 0.15438f
C884 w[26] w[27] 18.5141f
C885 s[6] w[5] 0.05264f
C886 w[18] w[13] 0.17895f
C887 s[7] w[0] 0.47023f
C888 neuron_4__VIp VMEM_2 0.23607f
C889 a_90162_14492# a_93348_20808# 0.37248f
C890 a_62978_119782# DAC_1__Isum_i 0.16326f
C891 w[21] w[10] 0.11336f
C892 DPI_4__Vthr DAC_6__Isum_e 2.8953f
C893 VMEM_4 DAC_1__Isum_i 0.58594f
C894 DPI_4__Vthr neuron_4__VK 0.35605f
C895 w[26] w[6] 0.138f
C896 w[26] w[7] 0.107f
C897 neuron_4__VIp a_90162_111852# 0.02258f
C898 DPI_4__VT a_62528_16118# 2.10107f
C899 w[14] w[19] 8.90374f
C900 VDD s[5] 2.51204f
C901 a_26214_64642# a_22014_64642# 0.29412f
C902 spike[0] neuron_4__VKup 0.05793f
C903 w[26] w[5] 0.14329f
C904 w[9] s[3] 0.02161f
C905 neuron_4__Vlk DAC_7__Vb 31.9835f
C906 w[19] a_17058_80500# 1.50762f
C907 w[13] w[12] 10.3995f
C908 a_93976_118168# a_93348_118168# 0.53841f
C909 w[14] w[21] 14.9979f
C910 pulse[0] w[6] 0.02041f
C911 w[1] w[4] 0.5394f
C912 a_22014_125050# DAC_1__Isum_i 12.8867f
C913 w[18] spike[1] 0.06863f
C914 a_17058_94688# a_16310_94896# 0.10497f
C915 a_34614_50454# VDD 0.19093f
C916 w[3] pulse[1] 0.20113f
C917 w[2] w[4] 1.00026f
C918 a_89534_14142# a_87734_14492# 0.9311f
C919 s[4] w[22] 0.14059f
C920 s[6] w[23] 0.05859f
C921 a_67118_143686# neuron_4__Vamp_bias 0.70951f
C922 DAC_7__Vb a_19914_80658# 0.74342f
C923 s[6] w[16] 0.07831f
C924 a_34614_50454# a_17058_50296# 0.75055f
C925 a_19914_94846# w[23] 0.56837f
C926 w[17] w[3] 0.2139f
C927 w[3] w[10] 0.92469f
C928 s[7] spike[3] 1.10853f
C929 spike[2] spike[4] 2.22178f
C930 s[7] w[13] 0.07267f
C931 a_19914_13502# a_16310_13552# 17.2602f
C932 neuron_4__VKdn bias_0__VT_inh 0.20895f
C933 a_93976_39284# spike[1] 0.28806f
C934 s[6] w[11] 0.0554f
C935 VDD a_16310_13552# 2.32564f
C936 spike[1] w[12] 0.14475f
C937 w[31] w[28] 0.08777f
C938 a_34614_13502# w[0] 0.04246f
C939 DAC_7__Vb s[0] 6.32731f
C940 a_88272_118168# DPI_4__VT 0.11609f
C941 a_17058_110704# a_22014_110862# 0.05882f
C942 a_19914_64642# a_16310_64692# 17.2602f
C943 VT VMEM_2 1.82205f
C944 a_90162_81648# a_89914_81648# 1.31172f
C945 s[2] s[0] 0.4417f
C946 DAC_7__Vb w[24] 7.12995f
C947 w[26] w[16] 0.12301f
C948 spike[2] neuron_4__VIp 0.15056f
C949 DAC_5__Isum_i VDD 15.1982f
C950 DPI_4__Vthr neuron_4__VKup 3.54425f
C951 w[14] w[3] 0.44787f
C952 VT a_90162_111852# 0.07035f
C953 s[2] w[24] 0.27872f
C954 VDD bias_0__VT_inh 21.1509f
C955 w[26] w[11] 0.1488f
C956 a_17058_94688# DAC_7__Vb 0.01484f
C957 s[4] s[5] 1.6701f
C958 spike[0] w[22] 13.1745f
C959 DAC_5__Isum_i a_17058_50296# 0.05814f
C960 spike[2] spike[3] 11.5303f
C961 a_87734_81648# VT 0.26497f
C962 DAC_1__Isum_e a_26214_110862# 2.06134f
C963 DAC_1__Isum_e DAC_1__Isum_i 7.67246f
C964 DAC_7__Vb a_67078_125606# 0.2583f
C965 w[30] w[15] 0.13163f
C966 s[2] DAC_7__Vb 10.8191f
C967 spike[2] a_16558_110912# 0.01869f
C968 a_17058_124892# a_19914_125050# 0.11443f
C969 a_34614_110862# w[24] 0.04246f
C970 a_17058_110704# a_16558_110912# 0.11824f
C971 a_17058_110704# a_19914_110862# 0.11443f
C972 pulse[0] w[11] 0.35877f
C973 a_62528_113478# a_67078_125606# 0.15017f
C974 VMEM_3 neuron_4__VNA 4.27759f
C975 spike[1] a_90162_32968# 9.68412f
C976 s[3] w[8] 0.01984f
C977 a_89534_81298# spike[3] 0.14351f
C978 w[18] w[15] 0.11331f
C979 w[22] w[6] 0.1344f
C980 neuron_4__VKdn spike[4] 0.10816f
C981 w[22] w[7] 0.10904f
C982 VDD w[1] 0.08575f
C983 a_34614_110862# DAC_7__Vb 0.093f
C984 w[9] s[1] 0.19948f
C985 VDD w[2] 0.08809f
C986 spike[2] spike[1] 6.65476f
C987 w[14] a_16310_64692# 0.18228f
C988 w[22] w[5] 0.14143f
C989 VT a_90162_32968# 0.07035f
C990 a_34614_64642# a_16310_64692# 1.31469f
C991 a_16558_13552# VDD 1.5403f
C992 VDD w[0] 0.0835f
C993 VDD a_91170_14492# 0.17724f
C994 w[12] w[15] 0.22468f
C995 w[25] w[12] 0.12367f
C996 neuron_4__VIp neuron_4__VKdn 70.18829f
C997 s[5] w[27] 0.1522f
C998 spike[2] VT 0.1724f
C999 a_26214_50454# a_34614_50454# 7.01128f
C1000 VDD spike[4] 1.82099f
C1001 a_19914_50454# a_22014_50454# 0.57119f
C1002 a_88272_39284# spike[1] 0.52077f
C1003 a_22014_110862# VDD 0.42217f
C1004 a_89914_14492# a_88272_20808# 0.09468f
C1005 spike[3] neuron_4__VKdn 0.1789f
C1006 VT a_88272_57760# 0.01402f
C1007 s[5] w[6] 0.52902f
C1008 s[5] w[7] 0.84418f
C1009 a_22014_31978# a_26214_31978# 0.29412f
C1010 s[7] w[15] 0.07685f
C1011 w[25] s[7] 0.0616f
C1012 w[31] a_16310_125100# 0.364f
C1013 a_89534_81298# VT 0.51506f
C1014 s[5] w[5] 0.05396f
C1015 a_17058_13344# s[0] 3.46922f
C1016 neuron_4__VIp VDD 31.8227f
C1017 neuron_4__VK VMEM_3 0.94229f
C1018 neuron_4__Vlk a_4687_155814# 0.39695f
C1019 w[22] w[23] 20.4549f
C1020 w[22] w[16] 0.14088f
C1021 a_26214_125050# a_22014_125050# 0.29412f
C1022 VDD spike[3] 5.87802f
C1023 w[13] VDD 0.32965f
C1024 a_16558_125100# spike[3] 0.01869f
C1025 a_26214_50454# DAC_5__Isum_i 10.8659f
C1026 s[4] w[1] 0.06885f
C1027 w[22] w[11] 0.13606f
C1028 a_17058_124892# s[7] 3.46922f
C1029 neuron_4__Vlk VMEM_2 0.27624f
C1030 spike[1] neuron_4__VKdn 0.15271f
C1031 s[4] w[2] 0.04131f
C1032 a_16558_110912# VDD 0.21115f
C1033 a_26214_31978# DAC_6__Isum_e 2.06134f
C1034 a_19914_110862# VDD 0.75723f
C1035 neuron_4__VNA DPI_4__VT 26.1738f
C1036 s[4] w[0] 0.06043f
C1037 spike[2] w[25] 0.08662f
C1038 DAC_7__Vb a_19914_125050# 0.74342f
C1039 a_89534_51094# a_89914_51444# 0.60758f
C1040 VMEM_0 a_62528_16118# 4.23813f
C1041 a_26214_64642# a_19914_64642# 0.27118f
C1042 s[2] a_17058_13344# 0.01005f
C1043 w[8] s[1] 0.20184f
C1044 a_90162_14492# neuron_4__Vamp_bias 0.06057f
C1045 neuron_4__Vamp_bias Iref 0.27353f
C1046 VT neuron_4__VKdn 10.7473f
C1047 a_67078_95402# a_62978_89578# 9.93393f
C1048 w[4] w[15] 0.10594f
C1049 a_93976_118168# VMEM_4 0.93986f
C1050 a_22014_110862# a_16310_110912# 15.0391f
C1051 a_22014_125050# a_16310_125100# 15.0391f
C1052 spike[3] a_88272_87964# 0.52077f
C1053 w[23] s[5] 0.41522f
C1054 spike[1] VDD 7.6119f
C1055 s[5] w[16] 2.58113f
C1056 DAC_7__Vb w[30] 1.3063f
C1057 a_16558_94896# DAC_3__Isum_e 2.10366f
C1058 neuron_4__VK a_91170_111852# 0.04013f
C1059 s[5] w[11] 0.05355f
C1060 s[2] w[30] 3.33972f
C1061 VT VDD 0.90162f
C1062 DPI_4__Vthr DAC_5__Isum_i 2.8953f
C1063 a_4687_155814# DAC_7__Vb 0.33753f
C1064 w[18] DAC_7__Vb 1.58911f
C1065 w[27] w[1] 0.13132f
C1066 DAC_1__Isum_e a_26214_125050# 2.06134f
C1067 VMEM_3 neuron_4__VKup 0.24846f
C1068 a_62978_89578# VDD 4.6034f
C1069 spike[0] a_91170_14492# 1.13486f
C1070 DPI_4__Vthr bias_0__VT_inh 8.76414f
C1071 s[4] w[13] 4.96724f
C1072 w[24] w[12] 0.13231f
C1073 s[6] w[20] 0.05764f
C1074 w[9] w[19] 0.13731f
C1075 s[2] w[18] 0.22943f
C1076 a_22014_13502# a_16310_13552# 15.0391f
C1077 DAC_5__Isum_i a_17058_64484# 0.05814f
C1078 spike[0] spike[4] 2.71454f
C1079 VDD a_87734_111852# 0.22723f
C1080 s[3] s[1] 0.34587f
C1081 s[6] pulse[1] 0.11668f
C1082 w[1] w[6] 1.29582f
C1083 a_16558_110912# a_16310_110912# 1.6884f
C1084 neuron_4__VK DPI_4__VT 0.57235f
C1085 a_93976_39284# a_93348_39284# 0.53841f
C1086 a_19914_110862# a_16310_110912# 17.2602f
C1087 w[2] w[6] 0.32451f
C1088 w[1] w[7] 0.86444f
C1089 a_93348_87964# VDD 2.79898f
C1090 a_89534_51094# a_90162_51444# 14.8965f
C1091 s[6] w[29] 0.1385f
C1092 s[7] s[0] 0.34988f
C1093 w[21] w[9] 0.10592f
C1094 DAC_7__Vb w[12] 7.11999f
C1095 w[2] w[7] 0.09608f
C1096 neuron_4__Vlk spike[2] 2.3397f
C1097 w[17] s[6] 0.04109f
C1098 s[6] w[10] 0.05345f
C1099 a_26214_64642# a_34614_64642# 7.01128f
C1100 a_26214_80658# a_19914_80658# 0.27118f
C1101 w[0] w[6] 0.82316f
C1102 a_17058_124892# a_34614_125050# 0.75055f
C1103 w[1] w[5] 0.38186f
C1104 s[7] w[24] 0.0616f
C1105 VT a_88272_87964# 0.0157f
C1106 s[2] w[12] 0.31326f
C1107 w[0] w[7] 0.56865f
C1108 w[2] w[5] 0.86676f
C1109 w[31] w[8] 0.38925f
C1110 w[26] w[20] 17.3804f
C1111 DAC_1__Isum_e a_16310_125100# 0.07931f
C1112 spike[0] neuron_4__VIp 0.15097f
C1113 spike[1] s[4] 0.24562f
C1114 w[0] w[5] 0.01722f
C1115 w[26] pulse[1] 0.14437f
C1116 DAC_5__Isum_i a_22014_64642# 12.8867f
C1117 DAC_7__Vb s[7] 6.70773f
C1118 a_88272_39284# a_87734_32968# 2.33814f
C1119 spike[0] spike[3] 0.08383f
C1120 spike[0] w[13] 0.06052f
C1121 VDD a_91170_81648# 0.17724f
C1122 w[26] w[10] 9.65917f
C1123 VDD w[15] 0.4671f
C1124 w[25] VDD 0.15754f
C1125 a_16310_32028# a_19914_31978# 17.2602f
C1126 w[14] s[6] 0.06858f
C1127 s[2] s[7] 2.11172f
C1128 a_16310_94896# a_26214_94846# 1.78781f
C1129 w[13] w[27] 0.20051f
C1130 VMEM_1 neuron_4__Vamp_bias 1.79838f
C1131 w[9] w[3] 0.14972f
C1132 spike[2] w[24] 0.08662f
C1133 pulse[0] pulse[1] 0.15952f
C1134 a_89534_51094# neuron_4__VNA 0.16897f
C1135 a_26214_80658# DAC_7__Vb 0.18591f
C1136 a_89534_14142# VDD 6.10103f
C1137 a_22014_13502# w[2] 0.25032f
C1138 a_90162_32968# a_93348_39284# 0.37248f
C1139 a_19914_110862# w[27] 0.56837f
C1140 w[23] w[1] 0.13157f
C1141 s[6] DAC_1__Isum_i 0.01848f
C1142 pulse[0] w[10] 0.08796f
C1143 a_17058_124892# a_16558_125100# 0.11824f
C1144 a_17058_124892# VDD 8.84723f
C1145 w[13] w[7] 3.35548f
C1146 spike[0] spike[1] 23.8091f
C1147 w[31] s[3] 0.16033f
C1148 spike[2] DAC_7__Vb 0.48242f
C1149 DPI_4__VT neuron_4__VKup 1.96461f
C1150 neuron_4__Vlk neuron_4__VKdn 59.5957f
C1151 w[1] w[11] 0.34334f
C1152 w[19] w[8] 8.84234f
C1153 neuron_4__VIp DPI_4__Vthr 0.25418f
C1154 w[2] w[11] 0.99768f
C1155 a_17058_110704# DAC_7__Vb 0.02265f
C1156 DAC_7__Vb w[4] 7.61812f
C1157 a_93976_20808# VDD 2.94927f
C1158 a_89534_51094# a_87734_51444# 0.9311f
C1159 spike[1] w[27] 13.1236f
C1160 spike[2] a_62528_113478# 0.17023f
C1161 a_22014_80658# a_34614_80658# 0.11882f
C1162 a_16558_50504# DAC_5__Isum_i 1.32914f
C1163 s[2] w[4] 3.47891f
C1164 w[0] w[11] 1.23705f
C1165 a_17058_94688# a_26214_94846# 0.06004f
C1166 w[21] w[8] 2.23739f
C1167 DPI_4__Vthr spike[3] 4.94053f
C1168 spike[0] VT 0.13929f
C1169 a_93348_118168# VMEM_4 0.12888f
C1170 a_93348_57760# VMEM_2 0.12888f
C1171 DAC_7__Vb a_34614_13502# 0.093f
C1172 DAC_7__Vb a_26214_94846# 0.18591f
C1173 a_16558_64692# s[3] 0.04246f
C1174 a_87734_32968# VDD 0.22723f
C1175 neuron_4__Vlk VDD 4.92478f
C1176 s[4] w[15] 0.19789f
C1177 w[25] s[4] 0.14125f
C1178 w[25] a_16310_110912# 0.10002f
C1179 a_17058_110704# a_34614_110862# 0.75055f
C1180 a_34614_125050# DAC_7__Vb 0.093f
C1181 a_16310_94896# VDD 0.54717f
C1182 a_19914_80658# VDD 0.75723f
C1183 neuron_4__VNA a_93976_87964# 0.04168f
C1184 DPI_4__VT a_89534_111502# 0.7679f
C1185 w[13] w[23] 0.20051f
C1186 a_90162_81648# neuron_4__VNA 0.40563f
C1187 w[22] w[20] 0.36053f
C1188 w[19] a_16310_80708# 0.364f
C1189 w[19] s[3] 0.0986f
C1190 a_34614_94846# a_16310_94896# 1.31469f
C1191 DPI_4__Vthr spike[1] 0.095f
C1192 neuron_4__Vamp_bias VMEM_4 1.43574f
C1193 w[13] w[16] 0.24255f
C1194 DAC_7__Vb neuron_4__VKdn 0.34214f
C1195 w[22] pulse[1] 0.12687f
C1196 w[8] w[3] 0.57717f
C1197 spike[1] a_17058_64484# 0.37995f
C1198 w[30] w[12] 0.45575f
C1199 s[6] w[28] 0.13861f
C1200 w[21] s[3] 0.08985f
C1201 VDD s[0] 2.00974f
C1202 a_34614_31978# a_19914_31978# 0.16484f
C1203 w[22] w[10] 0.11402f
C1204 a_16310_32028# a_34614_31978# 1.31469f
C1205 DAC_3__Isum_i a_16558_94896# 1.32914f
C1206 w[24] VDD 0.1576f
C1207 spike[0] w[15] 0.06185f
C1208 neuron_4__Vamp_bias a_89534_32618# 0.07771f
C1209 w[18] w[12] 0.12075f
C1210 a_19914_13502# DAC_7__Vb 0.74342f
C1211 a_17058_94688# VDD 8.90886f
C1212 spike[1] w[23] 0.2086f
C1213 VMEM_0 a_88272_20808# 1.71072f
C1214 w[27] w[15] 0.13163f
C1215 a_34614_94846# a_17058_94688# 0.75055f
C1216 w[25] w[27] 0.0901f
C1217 spike[1] w[16] 0.06128f
C1218 s[7] w[30] 0.41245f
C1219 spike[0] a_89534_14142# 0.14351f
C1220 spike[2] a_93348_57760# 1.98323f
C1221 DAC_7__Vb VDD 27.2421f
C1222 w[20] s[5] 1.2406f
C1223 VDD a_93348_39284# 2.79898f
C1224 a_22014_80658# a_17058_80500# 0.05882f
C1225 DAC_7__Isum_e VMEM_0 0.0248f
C1226 VDD a_67078_125606# 12.1331f
C1227 a_67078_65198# DAC_5__Isum_i 6.12944f
C1228 a_34614_94846# DAC_7__Vb 0.093f
C1229 w[14] w[22] 12.6455f
C1230 s[2] VDD 2.29869f
C1231 s[5] pulse[1] 0.11623f
C1232 DAC_7__Vb a_17058_50296# 0.01092f
C1233 w[25] w[6] 0.14454f
C1234 a_62528_113478# VDD 11.805f
C1235 w[29] s[5] 0.1548f
C1236 a_17058_31820# a_19914_31978# 0.11443f
C1237 w[7] w[15] 0.08504f
C1238 w[25] w[7] 0.10722f
C1239 w[18] s[7] 0.04557f
C1240 a_16310_32028# a_17058_31820# 0.10497f
C1241 s[3] w[3] 0.01984f
C1242 s[5] w[10] 0.04442f
C1243 s[2] a_17058_50296# 3.46922f
C1244 w[17] s[5] 0.04325f
C1245 spike[0] a_93976_20808# 0.28806f
C1246 a_89534_51094# neuron_4__VKup 0.1418f
C1247 VMEM_0 neuron_4__VK 0.20559f
C1248 w[5] w[15] 0.09262f
C1249 w[25] w[5] 0.14311f
C1250 a_90542_14492# a_88272_20808# 0.01339f
C1251 a_34614_110862# VDD 0.19093f
C1252 a_17058_13344# a_34614_13502# 0.75055f
C1253 a_19914_94846# DAC_3__Isum_i 0.01896f
C1254 s[4] s[0] 0.13131f
C1255 a_17058_31820# s[1] 3.46922f
C1256 neuron_4__VNA a_93976_118168# 0.04168f
C1257 s[7] w[12] 0.07255f
C1258 spike[0] neuron_4__Vlk 1.95845f
C1259 s[4] w[24] 0.15f
C1260 a_16310_110912# w[24] 0.01848f
C1261 a_17058_64484# w[15] 1.53032f
C1262 DAC_5__Isum_i a_19914_64642# 0.01896f
C1263 w[14] s[5] 0.17784f
C1264 a_22014_94846# DAC_3__Isum_i 12.8867f
C1265 a_89914_14492# a_91170_14492# 0.26264f
C1266 VMEM_1 a_89534_32618# 3.23701f
C1267 a_93976_39284# a_90162_32968# 0.04621f
C1268 a_87734_14492# VDD 0.22723f
C1269 w[18] w[4] 0.18181f
C1270 a_34614_125050# a_19914_125050# 0.16484f
C1271 DAC_7__Vb s[4] 6.63538f
C1272 VDD a_62528_34594# 11.5929f
C1273 spike[2] VMEM_2 2.78018f
C1274 s[2] s[4] 0.15919f
C1275 w[23] w[15] 0.132f
C1276 w[15] w[16] 0.88676f
C1277 DPI_4__VT bias_0__VT_inh 37.3438f
C1278 w[25] w[16] 0.13176f
C1279 a_89914_111852# a_90542_111852# 1.82301f
C1280 a_67118_143686# neuron_4__VK 6.06364f
C1281 neuron_4__VIp VMEM_3 0.24351f
C1282 a_88272_57760# VMEM_2 1.71072f
C1283 w[25] w[11] 0.1488f
C1284 a_89914_111852# VMEM_4 0.1368f
C1285 DAC_5__Isum_e a_16558_64692# 2.10366f
C1286 neuron_4__VIp a_89914_14492# 0.04013f
C1287 w[12] w[4] 0.20404f
C1288 a_90162_81648# neuron_4__VKup 0.836f
C1289 VMEM_3 spike[3] 2.78018f
C1290 a_93348_57760# VDD 2.79898f
C1291 a_34614_110862# a_16310_110912# 1.31469f
C1292 a_90542_111852# VMEM_4 0.25888f
C1293 a_19914_13502# a_17058_13344# 0.11443f
C1294 neuron_4__Vlk DPI_4__Vthr 10.142f
C1295 spike[1] a_62528_53070# 0.0263f
C1296 w[24] w[27] 0.08777f
C1297 s[6] w[9] 0.05345f
C1298 spike[0] DAC_7__Vb 0.66784f
C1299 a_17058_13344# VDD 8.90537f
C1300 a_91170_111852# spike[4] 1.13486f
C1301 a_26214_50454# DAC_7__Vb 0.18591f
C1302 a_62978_119782# VMEM_4 0.20517f
C1303 a_34614_64642# DAC_5__Isum_i 0.11679f
C1304 w[1] pulse[1] 0.36301f
C1305 s[7] w[4] 0.05354f
C1306 VDD a_19914_125050# 0.75723f
C1307 s[2] spike[0] 1.67979f
C1308 a_89534_81298# a_87734_81648# 0.9311f
C1309 w[2] pulse[1] 0.4478f
C1310 w[29] w[1] 0.14293f
C1311 w[3] s[1] 0.51052f
C1312 w[24] w[6] 0.13506f
C1313 a_4687_155814# neuron_4__VKdn 1.14427f
C1314 w[1] w[10] 0.11552f
C1315 DAC_7__Vb w[27] 1.52574f
C1316 w[17] w[1] 0.21921f
C1317 a_17058_31820# a_34614_31978# 0.75055f
C1318 w[24] w[7] 0.08987f
C1319 s[0] w[5] 0.09601f
C1320 w[0] pulse[1] 0.05891f
C1321 w[2] w[10] 1.75867f
C1322 w[17] w[2] 0.67334f
C1323 a_16558_32028# VDD 1.5403f
C1324 s[2] w[27] 0.25231f
C1325 w[30] VDD 0.17671f
C1326 neuron_4__VKdn VMEM_2 0.23672f
C1327 w[24] w[5] 0.12554f
C1328 w[26] w[9] 0.13126f
C1329 w[0] w[10] 0.10775f
C1330 a_90542_51444# VMEM_2 0.25888f
C1331 DAC_7__Vb w[6] 1.36593f
C1332 neuron_4__VKup a_93348_20808# 0.04013f
C1333 DAC_7__Vb w[7] 2.4716f
C1334 VT VMEM_3 1.70036f
C1335 a_22014_80658# DAC_3__Isum_i 12.8867f
C1336 s[2] w[6] 0.4714f
C1337 a_17058_110704# spike[2] 0.37995f
C1338 w[28] s[5] 0.15487f
C1339 s[2] w[7] 0.3556f
C1340 a_4687_155814# VDD 37.2219f
C1341 w[18] VDD 0.41944f
C1342 DAC_7__Vb w[5] 1.85276f
C1343 a_16310_94896# w[23] 0.364f
C1344 w[14] w[1] 0.29531f
C1345 VMEM_3 a_62978_89578# 0.20517f
C1346 w[14] w[2] 0.57764f
C1347 spike[2] a_88272_57760# 0.52077f
C1348 w[9] pulse[0] 0.07356f
C1349 a_88272_39284# a_90162_32968# 4.40172f
C1350 s[2] w[5] 2.16995f
C1351 neuron_4__VIp DPI_4__VT 8.04045f
C1352 neuron_4__Vamp_bias a_90162_51444# 0.08988f
C1353 w[13] w[20] 8.2286f
C1354 VDD VMEM_2 6.49584f
C1355 DPI_4__Vthr DAC_7__Vb 15.116f
C1356 a_93976_39284# VDD 2.94927f
C1357 w[14] w[0] 0.05157f
C1358 DPI_4__Vthr a_67078_125606# 1.85716f
C1359 a_93348_87964# VMEM_3 0.12888f
C1360 w[13] pulse[1] 0.42546f
C1361 DPI_4__VT spike[3] 2.79904f
C1362 VDD a_90162_111852# 3.96172f
C1363 w[12] VDD 0.32741f
C1364 DPI_4__Vthr a_62528_113478# 1.25274f
C1365 w[29] spike[3] 0.08662f
C1366 w[13] w[29] 0.20926f
C1367 w[24] w[23] 15.6775f
C1368 s[0] w[11] 0.72669f
C1369 w[24] w[16] 0.14051f
C1370 w[17] w[13] 0.24264f
C1371 a_87734_81648# VDD 0.22723f
C1372 neuron_4__VNA Iref 0.50943f
C1373 neuron_4__VNA a_90162_14492# 0.40576f
C1374 a_17058_94688# w[23] 1.50762f
C1375 s[6] w[8] 0.04224f
C1376 w[24] w[11] 0.14005f
C1377 DAC_7__Vb a_22014_13502# 0.37182f
C1378 VDD a_16310_50504# 0.54717f
C1379 s[4] w[30] 0.14125f
C1380 w[21] w[19] 1.60931f
C1381 DAC_7__Vb w[23] 1.45633f
C1382 s[7] a_16558_125100# 0.04246f
C1383 s[7] VDD 1.73122f
C1384 VMEM_3 a_91170_81648# 3.31883f
C1385 spike[1] w[20] 0.20651f
C1386 DAC_7__Vb w[16] 7.05203f
C1387 DAC_1__Isum_e VMEM_4 0.0248f
C1388 a_22014_110862# a_26214_110862# 0.29412f
C1389 a_22014_110862# DAC_1__Isum_i 12.8867f
C1390 DAC_3__Isum_i s[5] 0.01848f
C1391 a_17058_50296# a_16310_50504# 0.10497f
C1392 a_89914_111852# a_88272_118168# 0.09468f
C1393 s[2] w[23] 0.27956f
C1394 spike[2] neuron_4__VKdn 0.16731f
C1395 DAC_7__Vb w[11] 2.73822f
C1396 DAC_7__Vb a_22014_64642# 0.37182f
C1397 s[2] w[16] 1.81966f
C1398 spike[1] DPI_4__VT 0.5516f
C1399 a_90542_51444# spike[2] 1.35619f
C1400 w[18] s[4] 0.40259f
C1401 neuron_4__VNA neuron_4__Vamp_bias 1.36561f
C1402 w[14] w[13] 7.70973f
C1403 s[2] w[11] 3.97121f
C1404 a_87734_81648# a_88272_87964# 2.33814f
C1405 w[26] w[8] 0.12327f
C1406 w[17] spike[1] 0.07635f
C1407 a_90162_14492# a_88272_20808# 4.40172f
C1408 a_90542_111852# a_88272_118168# 0.01339f
C1409 DAC_5__Isum_e a_16310_64692# 0.07931f
C1410 a_90162_32968# VDD 3.95783f
C1411 a_90542_81648# spike[3] 1.35619f
C1412 a_26214_80658# VDD 0.26038f
C1413 a_90542_51444# a_88272_57760# 0.01339f
C1414 a_88272_118168# VMEM_4 1.71072f
C1415 DPI_4__Vthr a_62528_34594# 1.25274f
C1416 a_89534_14142# a_89914_14492# 0.60758f
C1417 spike[3] DAC_1__Isum_i 0.06832f
C1418 spike[2] VDD 2.48499f
C1419 a_87734_51444# neuron_4__Vamp_bias 0.05117f
C1420 w[9] w[22] 0.1061f
C1421 a_89914_32968# VMEM_1 0.1368f
C1422 w[19] w[3] 0.1087f
C1423 s[4] w[12] 0.07848f
C1424 s[6] s[3] 0.0907f
C1425 a_17058_110704# VDD 8.84723f
C1426 a_16558_110912# DAC_1__Isum_i 1.32914f
C1427 a_19914_110862# a_26214_110862# 0.27118f
C1428 a_19914_110862# DAC_1__Isum_i 0.01896f
C1429 neuron_4__VK Iref 0.35348f
C1430 VDD w[4] 0.37805f
C1431 a_17058_13344# w[7] 0.01419f
C1432 neuron_4__VK a_90162_14492# 0.03291f
C1433 w[14] spike[1] 0.14659f
C1434 w[28] w[1] 0.14293f
C1435 a_88272_57760# VDD 10.7087f
C1436 a_19914_13502# a_34614_13502# 0.16484f
C1437 w[21] w[3] 0.11524f
C1438 w[18] spike[0] 0.22565f
C1439 a_17058_13344# w[5] 0.04954f
C1440 a_34614_13502# VDD 0.30771f
C1441 VDD a_26214_94846# 0.26038f
C1442 s[7] s[4] 0.15616f
C1443 a_89534_81298# VDD 6.11065f
C1444 a_16558_64692# a_16310_64692# 1.6884f
C1445 neuron_4__Vlk VMEM_3 0.30075f
C1446 a_22014_31978# a_19914_31978# 0.57119f
C1447 a_88272_39284# VDD 10.7084f
C1448 w[26] s[3] 0.07573f
C1449 w[30] w[6] 1.54572f
C1450 a_16310_32028# a_22014_31978# 15.0391f
C1451 a_19914_64642# w[15] 0.56837f
C1452 spike[0] VMEM_2 0.02182f
C1453 a_34614_94846# a_26214_94846# 7.01128f
C1454 w[30] w[7] 0.13006f
C1455 s[2] a_16558_50504# 0.04246f
C1456 neuron_4__VK neuron_4__Vamp_bias 5.08603f
C1457 a_90542_51444# neuron_4__VKdn 0.04013f
C1458 w[25] w[20] 17.493f
C1459 w[20] w[15] 2.34965f
C1460 w[9] s[5] 0.0585f
C1461 a_34614_125050# VDD 0.19093f
C1462 w[30] w[5] 1.63676f
C1463 spike[0] w[12] 0.05766f
C1464 neuron_4__VNA VMEM_1 2.65322f
C1465 w[18] w[6] 0.11674f
C1466 pulse[1] w[15] 0.44632f
C1467 a_91170_51444# VMEM_2 3.31883f
C1468 w[25] pulse[1] 0.12687f
C1469 s[3] pulse[0] 0.36428f
C1470 w[18] w[7] 0.20322f
C1471 w[29] w[15] 0.14038f
C1472 w[12] w[27] 0.13267f
C1473 a_89534_81298# a_88272_87964# 0.68101f
C1474 a_17058_13344# a_22014_13502# 0.05882f
C1475 w[17] w[15] 0.11105f
C1476 a_67078_95402# VDD 11.6719f
C1477 w[25] w[10] 0.13265f
C1478 spike[0] a_16310_50504# 0.04246f
C1479 w[18] w[5] 0.11995f
C1480 a_16310_32028# DAC_6__Isum_e 0.07931f
C1481 a_26214_50454# a_16310_50504# 1.78781f
C1482 spike[2] a_16310_110912# 0.04246f
C1483 VDD neuron_4__VKdn 4.62982f
C1484 a_90542_51444# VDD 0.15438f
C1485 neuron_4__VKup a_93348_118168# 0.04013f
C1486 a_17058_110704# a_16310_110912# 0.10497f
C1487 s[4] w[4] 0.06038f
C1488 DPI_4__Vthr a_4687_155814# 12.6006f
C1489 spike[3] w[28] 0.08662f
C1490 w[13] w[28] 0.20926f
C1491 VMEM_0 a_91170_14492# 3.31883f
C1492 a_17058_13344# w[11] 0.03003f
C1493 neuron_4__VKup Iref 0.56184f
C1494 s[7] w[27] 0.0616f
C1495 a_90162_14492# neuron_4__VKup 0.84327f
C1496 w[22] w[8] 2.15834f
C1497 w[12] w[5] 0.01575f
C1498 DPI_4__Vthr VMEM_2 2.71399f
C1499 a_19914_13502# VDD 0.77619f
C1500 w[14] w[15] 7.35219f
C1501 w[30] w[16] 0.13176f
C1502 a_90542_81648# a_91170_81648# 1.47502f
C1503 a_16558_125100# VDD 0.21115f
C1504 a_19914_80658# a_34614_80658# 0.16484f
C1505 s[6] s[1] 0.19998f
C1506 s[7] w[6] 2.10799f
C1507 a_34614_94846# VDD 0.19093f
C1508 a_89914_32968# a_89534_32618# 0.60758f
C1509 VMEM_1 DAC_6__Isum_e 0.0248f
C1510 s[7] w[7] 0.18838f
C1511 w[30] w[11] 0.15868f
C1512 a_17058_50296# VDD 8.89784f
C1513 neuron_4__VK VMEM_1 0.35297f
C1514 spike[0] spike[2] 0.07991f
C1515 VT a_89534_51094# 0.51489f
C1516 a_90542_14492# a_91170_14492# 1.47502f
C1517 w[25] a_26214_110862# 0.08445f
C1518 neuron_4__VKup neuron_4__Vamp_bias 4.71551f
C1519 DAC_7__Isum_e a_26214_13502# 2.06134f
C1520 w[18] w[16] 0.64568f
C1521 neuron_4__VIp VMEM_0 0.18393f
C1522 s[7] w[5] 0.30545f
C1523 neuron_4__Vlk DPI_4__VT 0.24036f
C1524 a_16310_94896# w[20] 0.01848f
C1525 DAC_7__Vb a_26214_31978# 0.18591f
C1526 a_22014_80658# a_16310_80708# 15.0391f
C1527 a_26214_64642# DAC_5__Isum_e 2.06134f
C1528 spike[3] a_93976_87964# 0.28806f
C1529 w[18] w[11] 0.13822f
C1530 spike[2] w[27] 0.07426f
C1531 a_34614_50454# a_22014_50454# 0.11882f
C1532 a_90162_81648# spike[3] 9.68412f
C1533 a_91170_51444# spike[2] 1.13486f
C1534 neuron_4__VNA VMEM_4 0.13915f
C1535 a_17058_110704# w[27] 1.50762f
C1536 s[5] w[8] 1.0216f
C1537 VDD a_88272_87964# 10.7282f
C1538 a_17058_124892# DAC_1__Isum_i 0.05814f
C1539 w[22] s[3] 0.07573f
C1540 w[12] w[23] 0.13231f
C1541 a_22014_31978# a_34614_31978# 0.11882f
C1542 w[12] w[16] 25.6928f
C1543 a_16310_94896# DAC_3__Isum_e 0.07931f
C1544 DAC_7__Vb a_34614_80658# 0.093f
C1545 a_34614_50454# w[8] 0.04246f
C1546 w[9] w[1] 0.49376f
C1547 w[6] w[4] 0.26424f
C1548 w[24] w[20] 0.26009f
C1549 w[9] w[2] 1.97715f
C1550 neuron_4__VNA a_89534_32618# 0.16882f
C1551 w[12] w[11] 0.12822f
C1552 s[0] pulse[1] 2.04666f
C1553 pulse[0] s[1] 0.5167f
C1554 w[7] w[4] 2.52537f
C1555 DAC_7__Vb a_19914_64642# 0.74342f
C1556 w[9] w[0] 0.29893f
C1557 w[5] w[4] 7.1498f
C1558 s[4] VDD 1.97221f
C1559 w[24] pulse[1] 0.10938f
C1560 s[7] w[23] 0.0616f
C1561 a_89534_111502# neuron_4__Vamp_bias 0.07771f
C1562 a_16310_110912# VDD 0.54717f
C1563 a_87734_14492# a_89914_14492# 0.02914f
C1564 s[7] w[16] 0.07641f
C1565 spike[2] DPI_4__Vthr 0.15537f
C1566 DAC_5__Isum_i a_22014_50454# 12.8867f
C1567 a_16310_50504# w[11] 0.364f
C1568 DAC_7__Vb w[20] 7.49763f
C1569 s[6] w[31] 0.1558f
C1570 w[24] w[10] 8.23383f
C1571 a_34614_31978# DAC_6__Isum_e 6.81042f
C1572 a_93976_118168# spike[4] 0.28806f
C1573 s[7] w[11] 0.29188f
C1574 spike[0] neuron_4__VKdn 0.15019f
C1575 s[2] w[20] 0.25839f
C1576 a_17058_31820# a_22014_31978# 0.05882f
C1577 DAC_7__Vb pulse[1] 0.28658f
C1578 s[3] s[5] 23.6701f
C1579 a_90162_81648# VT 0.07055f
C1580 DAC_7__Vb DPI_4__VT 0.73397f
C1581 VT VMEM_0 1.93165f
C1582 DAC_7__Vb w[29] 1.30647f
C1583 spike[3] a_16310_125100# 0.04246f
C1584 a_17058_94688# DAC_3__Isum_e 14.2174f
C1585 a_19914_80658# a_17058_80500# 0.11443f
C1586 a_91170_32968# VMEM_1 3.31883f
C1587 VMEM_1 neuron_4__VKup 0.14837f
C1588 w[17] DAC_7__Vb 6.53486f
C1589 DPI_4__VT a_67078_125606# 1.70518f
C1590 s[2] pulse[1] 1.8573f
C1591 neuron_4__VK VMEM_4 2.52795f
C1592 DAC_7__Vb w[10] 1.39109f
C1593 s[2] w[29] 0.2803f
C1594 w[14] s[0] 0.08734f
C1595 w[28] w[15] 0.14038f
C1596 DAC_3__Isum_i a_62978_89578# 0.15462f
C1597 a_62528_113478# DPI_4__VT 1.38978f
C1598 a_91170_51444# a_90542_51444# 1.47502f
C1599 s[2] w[17] 3.30276f
C1600 s[2] w[10] 0.51508f
C1601 a_93348_87964# a_93976_87964# 0.53841f
C1602 a_93348_87964# a_90162_81648# 0.37248f
C1603 spike[0] VDD 2.85868f
C1604 a_26214_50454# VDD 0.26038f
C1605 a_17058_31820# DAC_6__Isum_e 14.2174f
C1606 w[4] w[16] 0.25718f
C1607 spike[0] a_17058_50296# 0.37995f
C1608 a_34614_13502# a_22014_13502# 0.11882f
C1609 a_26214_50454# a_17058_50296# 0.06004f
C1610 w[14] DAC_7__Vb 7.07258f
C1611 a_89914_51444# a_90162_51444# 1.31172f
C1612 VDD w[27] 0.27298f
C1613 w[4] w[11] 0.26345f
C1614 a_91170_51444# VDD 0.17724f
C1615 DAC_5__Isum_i a_62978_59374# 0.15476f
C1616 a_34614_64642# DAC_7__Vb 0.093f
C1617 a_16558_50504# a_16310_50504# 1.6884f
C1618 s[6] w[19] 0.04109f
C1619 a_67078_95402# DPI_4__Vthr 1.73852f
C1620 s[2] w[14] 0.21552f
C1621 DAC_7__Vb a_17058_80500# 0.04761f
C1622 w[8] w[1] 0.09841f
C1623 DPI_4__Vthr neuron_4__VKdn 0.27333f
C1624 a_62528_53070# VMEM_2 4.23737f
C1625 DAC_5__Isum_i s[3] 0.01848f
C1626 VDD w[6] 0.32954f
C1627 w[8] w[2] 0.15232f
C1628 a_93976_57760# a_90162_51444# 0.04621f
C1629 DAC_7__Vb a_26214_110862# 0.18591f
C1630 DAC_7__Vb DAC_1__Isum_i 0.21628f
C1631 VDD w[7] 0.40925f
C1632 w[21] s[6] 0.04109f
C1633 a_67078_125606# DAC_1__Isum_i 6.16686f
C1634 w[8] w[0] 0.19117f
C1635 DAC_7__Isum_e a_62528_16118# 7.71728f
C1636 a_88272_118168# neuron_4__VNA 0.33887f
C1637 DPI_4__VT a_62528_34594# 2.10536f
C1638 VDD w[5] 0.38087f
C1639 Iref bias_0__VT_inh 0.10346f
C1640 a_34614_50454# a_19914_50454# 0.16484f
C1641 a_89534_14142# VMEM_0 3.23701f
C1642 neuron_4__VKup VMEM_4 0.08489f
C1643 a_90542_32968# VMEM_1 0.25888f
C1644 DPI_4__Vthr VDD 0.12963p
C1645 a_34614_110862# a_26214_110862# 7.01128f
C1646 a_34614_110862# DAC_1__Isum_i 0.11679f
C1647 spike[0] s[4] 1.01f
C1648 VDD a_17058_64484# 8.92389f
C1649 s[5] s[1] 0.2294f
C1650 s[3] w[1] 0.02161f
C1651 a_87734_81648# VMEM_3 0.27205f
C1652 a_67078_65198# VMEM_2 6.40836f
C1653 VMEM_0 a_93976_20808# 0.93986f
C1654 s[3] w[2] 0.01984f
C1655 a_17058_124892# a_26214_125050# 0.06004f
C1656 neuron_4__Vamp_bias bias_0__VT_inh 10.1987f
C1657 a_19914_13502# a_22014_13502# 0.57119f
C1658 a_89914_111852# a_89534_111502# 0.60758f
C1659 neuron_4__VKup a_89534_32618# 0.14162f
C1660 a_16310_110912# w[27] 0.364f
C1661 s[4] w[27] 0.14125f
C1662 s[6] w[3] 0.06991f
C1663 VDD a_22014_13502# 13.3088f
C1664 a_93976_57760# neuron_4__VNA 0.04168f
C1665 VDD w[23] 0.42095f
C1666 s[3] w[0] 0.01993f
C1667 a_89914_51444# a_87734_51444# 0.02914f
C1668 DAC_5__Isum_i a_19914_50454# 0.01896f
C1669 s[4] w[6] 0.08012f
C1670 VDD w[16] 0.19195f
C1671 w[30] w[20] 0.12099f
C1672 a_26214_64642# a_16310_64692# 1.78781f
C1673 s[4] w[7] 2.47243f
C1674 a_93348_118168# spike[4] 1.98323f
C1675 neuron_4__Vlk VMEM_0 0.22624f
C1676 a_16558_32028# pulse[1] 0.01869f
C1677 a_22014_64642# VDD 0.42217f
C1678 a_89534_111502# VMEM_4 3.23701f
C1679 VDD w[11] 2.38095f
C1680 s[4] w[5] 0.06098f
C1681 w[26] w[3] 1.55934f
C1682 w[29] w[30] 32.9732f
C1683 DAC_7__Vb w[28] 6.95216f
C1684 a_17058_50296# w[11] 1.52978f
C1685 a_17058_124892# a_16310_125100# 0.10497f
C1686 w[25] w[9] 8.21813f
C1687 a_16310_94896# DAC_3__Isum_i 1.77847f
C1688 s[2] w[28] 0.27687f
C1689 DAC_3__Isum_i a_19914_80658# 0.01896f
C1690 neuron_4__VNA a_90162_51444# 0.40573f
C1691 a_93976_20808# a_93348_20808# 0.53841f
C1692 a_4687_155814# DPI_4__VT 0.13965f
C1693 w[18] pulse[1] 0.108f
C1694 spike[2] VMEM_3 0.21453f
C1695 w[3] pulse[0] 0.99085f
C1696 w[18] w[17] 39.1806f
C1697 w[18] w[10] 0.11889f
C1698 neuron_4__VIp Iref 20.598f
C1699 DPI_4__VT VMEM_2 0.91683f
C1700 w[13] s[3] 0.81342f
C1701 w[12] w[20] 0.11913f
C1702 neuron_4__Vamp_bias spike[4] 0.25184f
C1703 w[31] s[5] 0.1587f
C1704 a_34614_50454# DAC_5__Isum_e 6.81042f
C1705 a_26214_13502# a_16310_13552# 1.78781f
C1706 a_19914_125050# DAC_1__Isum_i 0.01896f
C1707 w[12] pulse[1] 0.73448f
C1708 DPI_4__VT a_90162_111852# 0.24171f
C1709 w[27] w[6] 3.1781f
C1710 a_89534_81298# VMEM_3 3.23701f
C1711 s[4] w[23] 0.15f
C1712 w[29] w[12] 0.45575f
C1713 w[27] w[7] 0.09825f
C1714 s[4] w[16] 1.40036f
C1715 a_16558_50504# VDD 0.21115f
C1716 a_17058_94688# DAC_3__Isum_i 0.05814f
C1717 w[17] w[12] 0.28446f
C1718 s[7] w[20] 0.06099f
C1719 a_26214_80658# a_34614_80658# 7.01128f
C1720 spike[0] DPI_4__Vthr 1.75824f
C1721 w[18] w[14] 0.12269f
C1722 neuron_4__VIp neuron_4__Vamp_bias 4.3348f
C1723 w[27] w[5] 0.1352f
C1724 s[4] w[11] 0.52839f
C1725 a_16558_50504# a_17058_50296# 0.11824f
C1726 w[21] w[22] 15.26f
C1727 w[1] s[1] 0.32531f
C1728 w[7] w[6] 7.64961f
C1729 s[7] pulse[1] 0.14625f
C1730 spike[1] s[3] 1.75633f
C1731 a_88272_118168# neuron_4__VKup 3.24448f
C1732 w[2] s[1] 0.95652f
C1733 a_16310_50504# w[10] 0.18228f
C1734 s[7] w[29] 0.43857f
C1735 spike[3] neuron_4__Vamp_bias 5.06112f
C1736 DAC_7__Vb a_26214_125050# 0.18591f
C1737 w[6] w[5] 7.77711f
C1738 w[17] s[7] 0.04557f
C1739 s[7] w[10] 0.04615f
C1740 w[0] s[1] 1.06512f
C1741 w[7] w[5] 0.96516f
C1742 DAC_5__Isum_i DAC_5__Isum_e 11.3441f
C1743 a_67078_95402# VMEM_3 6.40836f
C1744 w[14] w[12] 0.2472f
C1745 a_34614_64642# w[12] 0.04246f
C1746 VMEM_3 neuron_4__VKdn 0.28005f
C1747 w[19] s[5] 0.85638f
C1748 a_62528_53070# VDD 11.5972f
C1749 spike[0] w[23] 13.0548f
C1750 w[8] w[15] 1.04684f
C1751 spike[0] w[16] 0.08662f
C1752 VT a_90162_14492# 0.07044f
C1753 w[25] w[8] 0.13217f
C1754 a_26214_13502# w[1] 0.08445f
C1755 w[17] a_26214_80658# 0.08445f
C1756 w[20] w[4] 0.35383f
C1757 neuron_4__VNA a_88272_20808# 0.33796f
C1758 spike[0] w[11] 0.13553f
C1759 a_26214_80658# DAC_3__Isum_e 2.06134f
C1760 w[21] s[5] 0.4075f
C1761 spike[1] neuron_4__Vamp_bias 0.14219f
C1762 spike[2] DPI_4__VT 0.31375f
C1763 w[14] s[7] 0.07159f
C1764 w[22] w[3] 0.24838f
C1765 w[27] w[16] 0.13176f
C1766 w[4] pulse[1] 0.72551f
C1767 VMEM_3 VDD 5.15407f
C1768 a_88272_118168# a_89534_111502# 0.68101f
C1769 a_87734_14492# VMEM_0 0.27205f
C1770 w[27] w[11] 0.14093f
C1771 w[9] w[24] 8.22468f
C1772 w[23] w[6] 0.13473f
C1773 w[4] w[10] 0.10721f
C1774 w[17] w[4] 0.86523f
C1775 DAC_5__Isum_i a_16558_64692# 1.32914f
C1776 w[23] w[7] 0.09899f
C1777 s[7] DAC_1__Isum_i 0.01848f
C1778 VT neuron_4__Vamp_bias 20.9839f
C1779 a_89914_14492# VDD 0.14568f
C1780 neuron_4__VIp VMEM_1 0.25802f
C1781 neuron_4__VK neuron_4__VNA 36.2281f
C1782 w[6] w[11] 0.1364f
C1783 w[23] w[5] 0.1325f
C1784 w[31] w[1] 0.62265f
C1785 w[30] w[28] 0.08348f
C1786 w[7] w[11] 1.38154f
C1787 DAC_7__Vb w[9] 1.55064f
C1788 a_67078_65198# VDD 11.616f
C1789 w[5] w[16] 0.01623f
C1790 a_26214_80658# a_17058_80500# 0.06004f
C1791 VDD a_26214_31978# 11.1263f
C1792 neuron_4__Vamp_bias a_87734_111852# 0.05117f
C1793 a_26214_94846# DAC_3__Isum_e 2.06134f
C1794 s[2] w[9] 0.51263f
C1795 w[25] s[3] 0.07573f
C1796 neuron_4__VIp a_89914_81648# 0.04013f
C1797 w[5] w[11] 2.89303f
C1798 s[3] w[15] 0.54536f
C1799 a_89534_51094# VMEM_2 3.23701f
C1800 VMEM_3 a_88272_87964# 1.71072f
C1801 neuron_4__VKup a_90162_51444# 0.84828f
C1802 s[5] w[3] 0.10366f
C1803 w[14] w[4] 1.07551f
C1804 a_89914_111852# spike[4] 0.04786f
C1805 a_91170_32968# a_89914_32968# 0.26264f
C1806 spike[3] a_89914_81648# 0.04786f
C1807 spike[0] a_16558_50504# 0.01869f
C1808 neuron_4__VK a_88272_20808# 0.04423f
C1809 a_67078_95402# DPI_4__VT 2.17032f
C1810 VDD a_34614_80658# 0.19093f
C1811 a_17058_110704# a_26214_110862# 0.06004f
C1812 a_17058_110704# DAC_1__Isum_i 0.05814f
C1813 a_22014_64642# a_17058_64484# 0.05882f
C1814 a_89534_14142# a_90162_14492# 14.8965f
C1815 DPI_4__VT neuron_4__VKdn 0.28477f
C1816 a_90542_111852# spike[4] 1.35619f
C1817 VDD a_91170_111852# 0.17724f
C1818 spike[1] VMEM_1 2.79261f
C1819 VMEM_4 spike[4] 2.75441f
C1820 w[12] w[28] 0.14207f
C1821 a_19914_64642# VDD 0.75723f
C1822 neuron_4__VIp a_89914_111852# 0.04013f
C1823 w[3] VSS 15.2389f
C1824 w[2] VSS 6.85336f
C1825 w[1] VSS 7.62883f
C1826 w[0] VSS 5.0036f
C1827 pulse[0] VSS 6.37818f
C1828 s[0] VSS 21.5576f
C1829 w[7] VSS 16.3779f
C1830 w[6] VSS 10.1253f
C1831 w[5] VSS 9.08577f
C1832 w[4] VSS 6.53681f
C1833 pulse[1] VSS 8.00844f
C1834 s[1] VSS 22.9392f
C1835 w[11] VSS 22.7945f
C1836 w[10] VSS 8.47374f
C1837 w[9] VSS 7.31696f
C1838 w[8] VSS 9.50543f
C1839 s[2] VSS 31.3906f
C1840 w[15] VSS 18.7329f
C1841 w[14] VSS 9.01251f
C1842 w[13] VSS 9.12484f
C1843 w[12] VSS 8.54134f
C1844 s[3] VSS 28.4477f
C1845 w[19] VSS 18.888f
C1846 w[18] VSS 8.98404f
C1847 w[17] VSS 8.97333f
C1848 w[16] VSS 19.914f
C1849 spike[0] VSS 57.0293f
C1850 s[4] VSS 27.7416f
C1851 w[23] VSS 19.0585f
C1852 w[22] VSS 10.0909f
C1853 w[21] VSS 16.4699f
C1854 w[20] VSS 10.5874f
C1855 spike[1] VSS 58.0401f
C1856 s[5] VSS 32.2325f
C1857 VT VSS 23.7918f
C1858 w[27] VSS 17.9439f
C1859 w[26] VSS 10.5667f
C1860 w[25] VSS 17.7392f
C1861 w[24] VSS 20.862f
C1862 spike[2] VSS 62.203f
C1863 spike[4] VSS 32.8035f
C1864 s[6] VSS 29.1235f
C1865 w[31] VSS 22.6736f
C1866 w[30] VSS 12.437f
C1867 w[29] VSS 11.147f
C1868 w[28] VSS 11.9426f
C1869 spike[3] VSS 55.1713f
C1870 s[7] VSS 31.5353f
C1871 Iref VSS 0.12772p
C1872 VDD VSS 4.48303p
C1873 a_91170_14492# VSS 4.53886f $ **FLOATING
C1874 a_90542_14492# VSS 3.65994f $ **FLOATING
C1875 a_89914_14492# VSS 5.91238f $ **FLOATING
C1876 a_87734_14492# VSS 5.03265f $ **FLOATING
C1877 a_62528_16118# VSS 9.9446f $ **FLOATING
C1878 a_34614_13502# VSS 5.10168f $ **FLOATING
C1879 a_26214_13502# VSS 9.33535f $ **FLOATING
C1880 a_22014_13502# VSS 16.5225f $ **FLOATING
C1881 a_19914_13502# VSS 43.9107f $ **FLOATING
C1882 a_16558_13552# VSS 2.88389f $ **FLOATING
C1883 a_16310_13552# VSS 9.72397f $ **FLOATING
C1884 a_93976_20808# VSS 0.1558f $ **FLOATING
C1885 VMEM_0 VSS 27.1819f $ **FLOATING
C1886 a_93348_20808# VSS 0.36469f $ **FLOATING
C1887 a_90162_14492# VSS 4.59089f $ **FLOATING
C1888 a_89534_14142# VSS 7.31948f $ **FLOATING
C1889 a_88272_20808# VSS 4.46601f $ **FLOATING
C1890 a_17058_13344# VSS 9.84118f $ **FLOATING
C1891 a_91170_32968# VSS 4.53886f $ **FLOATING
C1892 a_90542_32968# VSS 3.65994f $ **FLOATING
C1893 a_89914_32968# VSS 5.91238f $ **FLOATING
C1894 a_87734_32968# VSS 5.03265f $ **FLOATING
C1895 a_62528_34594# VSS 9.96068f $ **FLOATING
C1896 a_34614_31978# VSS 5.10168f $ **FLOATING
C1897 a_26214_31978# VSS 9.33535f $ **FLOATING
C1898 a_22014_31978# VSS 16.5225f $ **FLOATING
C1899 a_19914_31978# VSS 43.9107f $ **FLOATING
C1900 a_16558_32028# VSS 2.88389f $ **FLOATING
C1901 a_16310_32028# VSS 9.72397f $ **FLOATING
C1902 a_93976_39284# VSS 0.1558f $ **FLOATING
C1903 VMEM_1 VSS 25.8967f $ **FLOATING
C1904 a_93348_39284# VSS 0.36469f $ **FLOATING
C1905 a_90162_32968# VSS 4.6117f $ **FLOATING
C1906 a_89534_32618# VSS 7.34925f $ **FLOATING
C1907 a_88272_39284# VSS 4.48872f $ **FLOATING
C1908 a_17058_31820# VSS 9.82687f $ **FLOATING
C1909 a_91170_51444# VSS 4.53886f $ **FLOATING
C1910 a_90542_51444# VSS 3.65994f $ **FLOATING
C1911 a_89914_51444# VSS 5.91238f $ **FLOATING
C1912 a_87734_51444# VSS 5.03265f $ **FLOATING
C1913 a_62528_53070# VSS 9.81856f $ **FLOATING
C1914 a_34614_50454# VSS 5.10168f $ **FLOATING
C1915 a_26214_50454# VSS 9.33535f $ **FLOATING
C1916 a_22014_50454# VSS 16.5225f $ **FLOATING
C1917 a_19914_50454# VSS 43.9107f $ **FLOATING
C1918 a_16558_50504# VSS 2.88389f $ **FLOATING
C1919 a_16310_50504# VSS 9.72397f $ **FLOATING
C1920 a_93976_57760# VSS 0.1558f $ **FLOATING
C1921 a_93348_57760# VSS 0.36469f $ **FLOATING
C1922 a_90162_51444# VSS 4.58399f $ **FLOATING
C1923 a_89534_51094# VSS 7.32779f $ **FLOATING
C1924 a_88272_57760# VSS 4.47347f $ **FLOATING
C1925 VMEM_2 VSS 33.5651f $ **FLOATING
C1926 a_17058_50296# VSS 9.82629f $ **FLOATING
C1927 a_62978_59374# VSS 16.6941f $ **FLOATING
C1928 a_67078_65198# VSS 13.1702f $ **FLOATING
C1929 a_34614_64642# VSS 5.10168f $ **FLOATING
C1930 a_26214_64642# VSS 9.33535f $ **FLOATING
C1931 a_22014_64642# VSS 16.5225f $ **FLOATING
C1932 a_19914_64642# VSS 43.9107f $ **FLOATING
C1933 a_16558_64692# VSS 2.88389f $ **FLOATING
C1934 a_16310_64692# VSS 9.72397f $ **FLOATING
C1935 a_17058_64484# VSS 9.81068f $ **FLOATING
C1936 a_91170_81648# VSS 4.53886f $ **FLOATING
C1937 a_90542_81648# VSS 3.65994f $ **FLOATING
C1938 a_89914_81648# VSS 5.91238f $ **FLOATING
C1939 a_87734_81648# VSS 5.03265f $ **FLOATING
C1940 a_62528_83274# VSS 10.2696f $ **FLOATING
C1941 a_34614_80658# VSS 5.10168f $ **FLOATING
C1942 a_26214_80658# VSS 9.33535f $ **FLOATING
C1943 a_22014_80658# VSS 16.5225f $ **FLOATING
C1944 a_19914_80658# VSS 43.9107f $ **FLOATING
C1945 a_16558_80708# VSS 2.88389f $ **FLOATING
C1946 a_16310_80708# VSS 9.72397f $ **FLOATING
C1947 a_93976_87964# VSS 0.1558f $ **FLOATING
C1948 a_93348_87964# VSS 0.36469f $ **FLOATING
C1949 a_90162_81648# VSS 4.59032f $ **FLOATING
C1950 a_89534_81298# VSS 7.32187f $ **FLOATING
C1951 a_88272_87964# VSS 4.45951f $ **FLOATING
C1952 VMEM_3 VSS 35.0683f $ **FLOATING
C1953 a_17058_80500# VSS 9.82641f $ **FLOATING
C1954 a_62978_89578# VSS 16.6889f $ **FLOATING
C1955 a_67078_95402# VSS 13.1153f $ **FLOATING
C1956 a_34614_94846# VSS 5.10168f $ **FLOATING
C1957 a_26214_94846# VSS 9.33535f $ **FLOATING
C1958 a_22014_94846# VSS 16.5225f $ **FLOATING
C1959 a_19914_94846# VSS 43.9107f $ **FLOATING
C1960 a_16558_94896# VSS 2.88389f $ **FLOATING
C1961 a_16310_94896# VSS 9.72397f $ **FLOATING
C1962 a_17058_94688# VSS 9.83244f $ **FLOATING
C1963 a_91170_111852# VSS 4.53886f $ **FLOATING
C1964 a_90542_111852# VSS 3.65994f $ **FLOATING
C1965 a_89914_111852# VSS 5.91238f $ **FLOATING
C1966 a_87734_111852# VSS 5.03265f $ **FLOATING
C1967 a_62528_113478# VSS 10.1567f $ **FLOATING
C1968 a_34614_110862# VSS 5.10168f $ **FLOATING
C1969 a_26214_110862# VSS 9.33535f $ **FLOATING
C1970 a_22014_110862# VSS 16.5225f $ **FLOATING
C1971 a_19914_110862# VSS 43.9107f $ **FLOATING
C1972 a_16558_110912# VSS 2.88389f $ **FLOATING
C1973 a_16310_110912# VSS 9.72397f $ **FLOATING
C1974 a_93976_118168# VSS 0.1558f $ **FLOATING
C1975 a_93348_118168# VSS 0.36469f $ **FLOATING
C1976 a_90162_111852# VSS 4.5174f $ **FLOATING
C1977 a_89534_111502# VSS 7.06891f $ **FLOATING
C1978 a_88272_118168# VSS 4.43928f $ **FLOATING
C1979 VMEM_4 VSS 35.645f $ **FLOATING
C1980 a_17058_110704# VSS 9.86847f $ **FLOATING
C1981 a_62978_119782# VSS 16.6244f $ **FLOATING
C1982 a_67078_125606# VSS 12.8962f $ **FLOATING
C1983 a_34614_125050# VSS 5.10168f $ **FLOATING
C1984 a_26214_125050# VSS 9.33535f $ **FLOATING
C1985 a_22014_125050# VSS 16.5225f $ **FLOATING
C1986 a_19914_125050# VSS 43.9107f $ **FLOATING
C1987 a_16558_125100# VSS 2.88389f $ **FLOATING
C1988 a_16310_125100# VSS 9.72397f $ **FLOATING
C1989 a_17058_124892# VSS 9.86051f $ **FLOATING
C1990 a_67118_143686# VSS 16.6633f $ **FLOATING
C1991 bias_0__VT_inh VSS 41.6058f $ **FLOATING
C1992 neuron_4__Vlk VSS 68.7108f $ **FLOATING
C1993 neuron_4__VNA VSS 39.1892f $ **FLOATING
C1994 neuron_4__VKup VSS 54.0014f $ **FLOATING
C1995 DPI_4__VT VSS 0.11237p $ **FLOATING
C1996 DPI_4__Vthr VSS 0.12056p $ **FLOATING
C1997 neuron_4__VIp VSS 42.6818f $ **FLOATING
C1998 neuron_4__Vamp_bias VSS 68.2396f $ **FLOATING
C1999 neuron_4__VK VSS 91.23129f $ **FLOATING
C2000 DAC_7__Vb VSS 0.71455p $ **FLOATING
C2001 neuron_4__VKdn VSS 48.2113f $ **FLOATING
C2002 a_4687_155814# VSS 18.5377f $ **FLOATING
C2003 DAC_7__Isum_e VSS 17.2603f $ **FLOATING
C2004 DAC_6__Isum_e VSS 17.7405f $ **FLOATING
C2005 DAC_5__Isum_e VSS 21.5617f $ **FLOATING
C2006 DAC_5__Isum_i VSS 29.1939f $ **FLOATING
C2007 DAC_3__Isum_e VSS 22.802f $ **FLOATING
C2008 DAC_3__Isum_i VSS 29.1301f $ **FLOATING
C2009 DAC_1__Isum_e VSS 23.2855f $ **FLOATING
C2010 DAC_1__Isum_i VSS 30.1867f $ **FLOATING
.ends
