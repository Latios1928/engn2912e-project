* NGSPICE file created from SNN_signed_flat__ext - technology: gf180mcuD

.subckt SNN_signed_flat trim[3] trim[2] trim[1] trim[0] cal w[31] w[30] w[29] w[28]  w[27] w[26] w[25] w[24] w[23] w[22] w[21] w[20] w[19] w[18] w[17] w[16] w[15] w[14]  w[13] w[12] w[11] w[10] w[9] w[8] w[7] w[6] w[5] w[4] w[3] w[2] w[1] w[0] s[7] s[6]  s[5] s[4] s[3] s[2] s[1] s[0] pulse[1] pulse[0] VDD VSS VT spike[4] spike[3] spike[2]  spike[1] spike[0] Imon
X4 VDD a_89872_39970# a_91134_33304# VDD pfet_03v3 ad=0.3p pd=2.2u as=0.3p ps=2.2u w=0.5u l=8u
X5 VDD bias_0__VT_inh bias_0__VT_inh VDD pfet_03v3 ad=0.2464p pd=1.44u as=0.2464p ps=1.44u w=0.88u l=1.12u
X8 a_21514_51140# w[11] a_17910_51190# VSS nfet_03v3 ad=0.14p pd=1.06u as=0.14p ps=1.06u w=0.5u l=0.64u
X15 a_8522_190701# a_21494_196237# VDD VDD pfet_03v3 ad=0.28p pd=1.56u as=0.6p ps=3.2u w=1u l=6u
X16 DPI_4__VT DPI_4__VT VDD VDD pfet_03v3 ad=1.12p pd=4.56u as=1.12p ps=4.56u w=4u l=5.12u
X17 w_151668_188170# a_8522_190701# a_21494_196237# VSS nfet_03v3 ad=0.28p pd=1.56u as=0.28p ps=1.56u w=1u l=6u
X28 VDD a_91134_112188# a_91762_112538# VDD pfet_03v3 ad=0.3p pd=2.2u as=0.3p ps=2.2u w=0.5u l=0.64u
X36 VDD DPI_4__Vthr DPI_4__Vthr VDD pfet_03v3 ad=1.12p pd=4.56u as=1.12p ps=4.56u w=4u l=5.12u
X39 w_151668_188170# a_8522_190701# a_21494_196237# VSS nfet_03v3 ad=0.28p pd=1.56u as=0.28p ps=1.56u w=1u l=6u
X42 VDD DPI_4__VT DPI_4__VT VDD pfet_03v3 ad=1.12p pd=4.56u as=1.12p ps=4.56u w=4u l=5.12u
X57 a_23614_95532# w[22] a_17910_95582# VSS nfet_03v3 ad=0.14p pd=1.06u as=0.14p ps=1.06u w=0.5u l=0.64u
X58 trim_steer_0__Iref a_8522_190701# VSS VSS nfet_03v3 ad=0.6p pd=3.2u as=0.6p ps=3.2u w=1u l=6u
X61 VMEM_4 spike[4] a_92770_112538# VSS nfet_03v3 ad=0.3p pd=2.2u as=0.3p ps=2.2u w=0.5u l=11.36u
X62 VDD a_64128_53756# VMEM_2 VDD pfet_03v3 ad=2.4p pd=9.2u as=2.4p ps=9.2u w=4u l=5.12u
X71 w_151668_188170# a_8522_190701# a_21494_196237# VSS nfet_03v3 ad=0.28p pd=1.56u as=0.28p ps=1.56u w=1u l=6u
X76 a_38750_170674# a_37150_170466# VSS VSS nfet_03v3 ad=6p pd=21.2u as=6p ps=21.2u w=10u l=8u
X80 a_23614_65328# DAC_7__Vb VSS VSS nfet_03v3 ad=0.6p pd=3.2u as=0.6p ps=3.2u w=1u l=8u
X81 a_9722_190909# a_8522_190701# VSS VSS nfet_03v3 ad=0.6p pd=3.2u as=0.6p ps=3.2u w=1u l=6u
X90 a_21494_196237# a_8522_190701# w_151668_188170# VSS nfet_03v3 ad=0.28p pd=1.56u as=0.28p ps=1.56u w=1u l=6u
X108 a_42850_171366# trim[3] VSS VSS nfet_03v3 ad=0.375p pd=2.5u as=0.375p ps=2.5u w=0.5u l=0.28u
X123 a_21514_81344# DAC_7__Vb VSS VSS nfet_03v3 ad=0.6p pd=3.2u as=0.6p ps=3.2u w=1u l=8u
X125 VDD neuron_4__VKup a_94948_118854# VDD pfet_03v3 ad=0.6p pd=3.2u as=0.6p ps=3.2u w=1u l=1u
X136 VDD DPI_4__Vthr DPI_4__Vthr VDD pfet_03v3 ad=1.12p pd=4.56u as=1.12p ps=4.56u w=4u l=5.12u
X144 VDD DPI_4__VT DPI_4__VT VDD pfet_03v3 ad=1.12p pd=4.56u as=1.12p ps=4.56u w=4u l=5.12u
X153 VDD a_8859_157048# a_8859_157048# VDD pfet_03v3 ad=6p pd=21.2u as=6p ps=21.2u w=10u l=8u
X159 VMEM_2 neuron_4__Vlk VSS VSS nfet_03v3 ad=0.6p pd=3.2u as=0.6p ps=3.2u w=1u l=1u
X161 a_27814_111548# DAC_7__Vb VSS VSS nfet_03v3 ad=0.6p pd=3.2u as=0.6p ps=3.2u w=1u l=8u
X170 a_21514_51140# w[11] a_17910_51190# VSS nfet_03v3 ad=0.14p pd=1.06u as=0.14p ps=1.06u w=0.5u l=0.64u
X177 a_23614_14188# w[2] a_17910_14238# VSS nfet_03v3 ad=0.3p pd=2.2u as=0.14p ps=1.06u w=0.5u l=0.64u
X185 a_17910_81394# w[18] a_23614_81344# VSS nfet_03v3 ad=0.14p pd=1.06u as=0.14p ps=1.06u w=0.5u l=0.64u
X189 a_9722_190909# a_8522_190701# VSS VSS nfet_03v3 ad=0.6p pd=3.2u as=0.6p ps=3.2u w=1u l=6u
X193 a_23614_51140# DAC_7__Vb VSS VSS nfet_03v3 ad=0.6p pd=3.2u as=0.6p ps=3.2u w=1u l=8u
X197 VSS neuron_4__Vlk neuron_4__Vlk VSS nfet_03v3 ad=0.6p pd=3.2u as=0.28p ps=1.56u w=1u l=1u
X202 a_18158_81394# spike[0] a_17910_81394# VSS nfet_03v3 ad=0.3p pd=2.2u as=0.3p ps=2.2u w=0.5u l=0.64u
X205 w_151668_188170# a_8522_190701# a_21494_196237# VSS nfet_03v3 ad=0.28p pd=1.56u as=0.28p ps=1.56u w=1u l=6u
X208 a_21514_14188# w[3] a_17910_14238# VSS nfet_03v3 ad=0.14p pd=1.06u as=0.14p ps=1.06u w=0.5u l=0.64u
X210 DPI_4__VT DPI_4__VT VDD VDD pfet_03v3 ad=1.12p pd=4.56u as=1.12p ps=4.56u w=4u l=5.12u
X228 VDD DPI_4__VT DPI_4__VT VDD pfet_03v3 ad=1.12p pd=4.56u as=1.12p ps=4.56u w=4u l=5.12u
X229 VDD a_64128_53756# cap_mim_2f0_m4m5_noshield c_width=22.18u c_length=22.18u
X245 w_86458_180350# trim_steer_0__Iref VSS nwell r_width=2u r_length=50u
X248 VMEM_4 VSS cap_mim_2f0_m4m5_noshield c_width=22.18u c_length=22.18u
X263 a_21494_196237# a_8522_190701# w_151668_188170# VSS nfet_03v3 ad=0.28p pd=1.56u as=0.28p ps=1.56u w=1u l=6u
X270 a_17910_111598# w[26] a_23614_111548# VSS nfet_03v3 ad=0.14p pd=1.06u as=0.14p ps=1.06u w=0.5u l=0.64u
X274 a_64128_114164# a_64128_114164# DAC_1__Isum_e DAC_1__Isum_e nfet_03v3 ad=2.4p pd=9.2u as=2.4p ps=9.2u w=4u l=5.12u
X285 VDD a_8859_157048# DAC_7__Vb VDD pfet_03v3 ad=0.864p pd=4.08u as=0.864p ps=4.08u w=1.44u l=8u
X289 a_27814_65328# DAC_7__Vb VSS VSS nfet_03v3 ad=0.6p pd=3.2u as=0.6p ps=3.2u w=1u l=8u
X292 VDD bias_0__VT_inh bias_0__VT_inh VDD pfet_03v3 ad=0.2464p pd=1.44u as=0.2464p ps=1.44u w=0.88u l=1.12u
X298 VDD DPI_4__Vthr DAC_3__Isum_e DAC_3__Isum_e nfet_03v3 ad=2.4p pd=9.2u as=2.4p ps=9.2u w=4u l=5.12u
X320 a_21514_81344# DAC_7__Vb VSS VSS nfet_03v3 ad=0.6p pd=3.2u as=0.6p ps=3.2u w=1u l=8u
X338 a_21514_95532# DAC_7__Vb VSS VSS nfet_03v3 ad=0.6p pd=3.2u as=0.6p ps=3.2u w=1u l=8u
X347 trim_steer_0__Iref a_8522_190701# VSS VSS nfet_03v3 ad=0.6p pd=3.2u as=0.6p ps=3.2u w=1u l=6u
X350 a_21514_14188# DAC_7__Vb VSS VSS nfet_03v3 ad=0.6p pd=3.2u as=0.6p ps=3.2u w=1u l=8u
X357 a_21514_14188# w[3] a_17910_14238# VSS nfet_03v3 ad=0.3p pd=2.2u as=0.14p ps=1.06u w=0.5u l=0.64u
X362 w_151668_188170# a_8522_190701# a_21494_196237# VSS nfet_03v3 ad=0.28p pd=1.56u as=0.28p ps=1.56u w=1u l=6u
X366 a_17910_81394# w[19] a_21514_81344# VSS nfet_03v3 ad=0.14p pd=1.06u as=0.14p ps=1.06u w=0.5u l=0.64u
X373 a_9722_190909# a_8522_190701# VSS VSS nfet_03v3 ad=0.6p pd=3.2u as=0.6p ps=3.2u w=1u l=6u
X375 a_23614_32664# DAC_7__Vb VSS VSS nfet_03v3 ad=0.6p pd=3.2u as=0.6p ps=3.2u w=1u l=8u
X384 w_151668_188170# a_8522_190701# a_21494_196237# VSS nfet_03v3 ad=0.28p pd=1.56u as=0.28p ps=1.56u w=1u l=6u
X385 a_27814_125736# DAC_7__Vb VSS VSS nfet_03v3 ad=0.6p pd=3.2u as=0.6p ps=3.2u w=1u l=8u
X392 a_89872_118854# VMEM_4 a_89334_112538# VSS nfet_03v3 ad=2.4p pd=9.2u as=2.4p ps=9.2u w=4u l=2u
X411 a_17910_95582# w[22] a_23614_95532# VSS nfet_03v3 ad=0.14p pd=1.06u as=0.14p ps=1.06u w=0.5u l=0.64u
X421 VDD DPI_4__VT a_64128_114164# VDD pfet_03v3 ad=2.4p pd=9.2u as=2.4p ps=9.2u w=4u l=5.12u
X431 a_23614_81344# DAC_7__Vb VSS VSS nfet_03v3 ad=0.6p pd=3.2u as=0.6p ps=3.2u w=1u l=8u
X437 a_21494_196237# a_8522_190701# w_151668_188170# VSS nfet_03v3 ad=0.28p pd=1.56u as=0.28p ps=1.56u w=1u l=6u
X438 a_18158_95582# spike[1] a_17910_95582# VSS nfet_03v3 ad=0.3p pd=2.2u as=0.3p ps=2.2u w=0.5u l=0.64u
X441 DAC_5__Isum_e a_18658_65170# a_18158_65378# VSS nfet_03v3 ad=0.3p pd=2.2u as=0.3p ps=2.2u w=0.5u l=0.64u
X453 a_18658_14030# s[0] VSS VSS nfet_03v3 ad=0.3p pd=2.2u as=0.3p ps=2.2u w=0.5u l=0.64u
X464 a_21494_196237# a_8522_190701# w_151668_188170# VSS nfet_03v3 ad=0.28p pd=1.56u as=0.28p ps=1.56u w=1u l=6u
X476 DPI_4__VT DPI_4__VT VDD VDD pfet_03v3 ad=1.12p pd=4.56u as=1.12p ps=4.56u w=4u l=5.12u
X487 a_92770_15178# neuron_4__VK VSS VSS nfet_03v3 ad=0.6p pd=3.2u as=0.6p ps=3.2u w=1u l=1u
X505 VDD neuron_4__VKup a_94948_39970# VDD pfet_03v3 ad=0.6p pd=3.2u as=0.6p ps=3.2u w=1u l=1u
X509 spike[3] a_91762_82334# a_92142_82334# VSS nfet_03v3 ad=0.3p pd=2.2u as=0.3p ps=2.2u w=0.5u l=0.64u
X517 a_17910_125786# w[30] a_23614_125736# VSS nfet_03v3 ad=0.14p pd=1.06u as=0.14p ps=1.06u w=0.5u l=0.64u
X528 VDD cal a_46000_171624# VDD pfet_03v3 ad=0.75p pd=3.5u as=0.75p ps=3.5u w=1u l=0.28u
X536 VDD a_68678_65884# a_64578_60060# VDD pfet_03v3 ad=2.4p pd=9.2u as=2.4p ps=9.2u w=4u l=5.12u
X547 VDD DPI_4__VT DPI_4__VT VDD pfet_03v3 ad=1.12p pd=4.56u as=1.12p ps=4.56u w=4u l=5.12u
X550 a_18158_111598# spike[2] a_17910_111598# VSS nfet_03v3 ad=0.3p pd=2.2u as=0.3p ps=2.2u w=0.5u l=0.64u
X564 w_151668_188170# a_8522_190701# a_21494_196237# VSS nfet_03v3 ad=0.28p pd=1.56u as=0.28p ps=1.56u w=1u l=6u
X569 a_21514_111548# DAC_7__Vb VSS VSS nfet_03v3 ad=0.6p pd=3.2u as=0.6p ps=3.2u w=1u l=8u
X580 a_21514_95532# DAC_7__Vb VSS VSS nfet_03v3 ad=0.6p pd=3.2u as=0.6p ps=3.2u w=1u l=8u
X595 a_23614_14188# w[2] a_17910_14238# VSS nfet_03v3 ad=0.14p pd=1.06u as=0.14p ps=1.06u w=0.5u l=0.64u
X600 VDD bias_0__VT_inh bias_0__VT_inh VDD pfet_03v3 ad=0.2464p pd=1.44u as=0.2464p ps=1.44u w=0.88u l=1.12u
X604 a_17910_81394# w[18] a_23614_81344# VSS nfet_03v3 ad=0.14p pd=1.06u as=0.3p ps=2.2u w=0.5u l=0.64u
X610 VDD s[1] a_18158_32714# VSS nfet_03v3 ad=0.3p pd=2.2u as=0.3p ps=2.2u w=0.5u l=0.64u
X613 a_27814_32664# DAC_7__Vb VSS VSS nfet_03v3 ad=0.6p pd=3.2u as=0.6p ps=3.2u w=1u l=8u
X625 a_17910_95582# w[23] a_21514_95532# VSS nfet_03v3 ad=0.14p pd=1.06u as=0.14p ps=1.06u w=0.5u l=0.64u
X634 a_8522_190701# a_21494_196237# VDD VDD pfet_03v3 ad=0.28p pd=1.56u as=0.28p ps=1.56u w=1u l=6u
X635 a_8522_190701# a_8522_190701# VSS VSS nfet_03v3 ad=0.6p pd=3.2u as=0.6p ps=3.2u w=1u l=6u
X638 w_151668_188170# a_8522_190701# a_21494_196237# VSS nfet_03v3 ad=0.28p pd=1.56u as=0.28p ps=1.56u w=1u l=6u
X639 a_21494_196237# a_8522_190701# w_151668_188170# VSS nfet_03v3 ad=0.28p pd=1.56u as=0.28p ps=1.56u w=1u l=6u
X644 VDD trim_steer_0__Iref trim_steer_0__Iref VDD pfet_03v3 ad=0.28p pd=1.56u as=0.28p ps=1.56u w=1u l=6u
X647 a_17910_81394# w[19] a_21514_81344# VSS nfet_03v3 ad=0.14p pd=1.06u as=0.14p ps=1.06u w=0.5u l=0.64u
X653 a_89872_21494# VMEM_0 a_89334_15178# VSS nfet_03v3 ad=2.4p pd=9.2u as=2.4p ps=9.2u w=4u l=2u
X660 a_8522_190701# a_8522_190701# VSS VSS nfet_03v3 ad=0.6p pd=3.2u as=0.6p ps=3.2u w=1u l=6u
X669 VDD neuron_4__VNA a_95576_21494# VDD pfet_03v3 ad=0.6p pd=3.2u as=0.6p ps=3.2u w=1u l=1u
X670 a_27814_65328# w[13] a_17910_65378# VSS nfet_03v3 ad=0.3p pd=2.2u as=0.14p ps=1.06u w=0.5u l=0.64u
X673 VDD a_8859_157048# neuron_4__VKdn VDD pfet_03v3 ad=7.764p pd=27.08u as=7.764p ps=27.08u w=12.94u l=8u
X677 DPI_4__VT DPI_4__VT VDD VDD pfet_03v3 ad=1.12p pd=4.56u as=1.12p ps=4.56u w=4u l=5.12u
X684 DPI_4__Vthr bias_0__Iref VSS VSS nfet_03v3 ad=0.546p pd=3.02u as=0.546p ps=3.02u w=0.91u l=32u
X690 VDD trim[3] a_42850_171366# VDD pfet_03v3 ad=0.75p pd=3.5u as=0.75p ps=3.5u w=1u l=0.28u
X692 a_23614_95532# DAC_7__Vb VSS VSS nfet_03v3 ad=0.6p pd=3.2u as=0.6p ps=3.2u w=1u l=8u
X702 a_21494_196237# a_8522_190701# w_151668_188170# VSS nfet_03v3 ad=0.28p pd=1.56u as=0.6p ps=3.2u w=1u l=6u
X704 VDD DPI_4__VT DPI_4__VT VDD pfet_03v3 ad=1.12p pd=4.56u as=1.12p ps=4.56u w=4u l=5.12u
X716 VDD trim[1] a_39850_171366# VDD pfet_03v3 ad=0.75p pd=3.5u as=0.75p ps=3.5u w=1u l=0.28u
X727 spike[0] VSS cap_mim_2f0_m4m5_noshield c_width=10u c_length=10u
X731 a_95576_118854# a_91762_112538# VMEM_4 VDD pfet_03v3 ad=0.3p pd=2.2u as=0.3p ps=2.2u w=0.5u l=0.64u
X737 a_9722_190909# a_8522_190701# VSS VSS nfet_03v3 ad=0.6p pd=3.2u as=0.6p ps=3.2u w=1u l=6u
X740 VDD DPI_4__Vthr DPI_4__Vthr VDD pfet_03v3 ad=1.12p pd=4.56u as=1.12p ps=4.56u w=4u l=5.12u
X767 a_10219_180030# w_87818_180350# VDD VDD pfet_03v3 ad=0.28p pd=1.56u as=0.28p ps=1.56u w=1u l=6u
X770 VMEM_2 spike[2] a_92770_52130# VSS nfet_03v3 ad=0.3p pd=2.2u as=0.3p ps=2.2u w=0.5u l=11.36u
X771 a_21494_196237# a_8522_190701# w_151668_188170# VSS nfet_03v3 ad=0.28p pd=1.56u as=0.28p ps=1.56u w=1u l=6u
X775 a_17910_81394# w[16] a_36214_81344# VSS nfet_03v3 ad=0.3p pd=2.2u as=0.3p ps=2.2u w=0.5u l=0.64u
X779 a_23614_111548# w[26] a_17910_111598# VSS nfet_03v3 ad=0.14p pd=1.06u as=0.14p ps=1.06u w=0.5u l=0.64u
X780 VDD DPI_4__VT a_64128_16804# VDD pfet_03v3 ad=2.4p pd=9.2u as=2.4p ps=9.2u w=4u l=5.12u
X788 VDD w_87818_180350# a_10219_180030# VDD pfet_03v3 ad=0.28p pd=1.56u as=0.28p ps=1.56u w=1u l=6u
X797 a_21514_65328# DAC_7__Vb VSS VSS nfet_03v3 ad=0.6p pd=3.2u as=0.6p ps=3.2u w=1u l=8u
X807 a_18158_125786# spike[3] a_17910_125786# VSS nfet_03v3 ad=0.3p pd=2.2u as=0.3p ps=2.2u w=0.5u l=0.64u
X810 w_151668_188170# a_8522_190701# a_21494_196237# VSS nfet_03v3 ad=0.28p pd=1.56u as=0.28p ps=1.56u w=1u l=6u
X811 a_17910_81394# w[19] a_21514_81344# VSS nfet_03v3 ad=0.14p pd=1.06u as=0.14p ps=1.06u w=0.5u l=0.64u
X813 VDD trim_steer_0__Iref trim_steer_0__Iref VDD pfet_03v3 ad=0.28p pd=1.56u as=0.28p ps=1.56u w=1u l=6u
X816 a_21514_125736# DAC_7__Vb VSS VSS nfet_03v3 ad=0.6p pd=3.2u as=0.6p ps=3.2u w=1u l=8u
X828 VDD DPI_4__Vthr DPI_4__Vthr VDD pfet_03v3 ad=1.12p pd=4.56u as=1.12p ps=4.56u w=4u l=5.12u
X829 w_151668_188170# a_8522_190701# a_21494_196237# VSS nfet_03v3 ad=0.28p pd=1.56u as=0.28p ps=1.56u w=1u l=6u
X847 trim_steer_0__Iref trim_steer_0__Iref VDD VDD pfet_03v3 ad=0.28p pd=1.56u as=0.28p ps=1.56u w=1u l=6u
X849 a_17910_95582# w[22] a_23614_95532# VSS nfet_03v3 ad=0.14p pd=1.06u as=0.3p ps=2.2u w=0.5u l=0.64u
X850 a_36214_111548# DAC_7__Vb VSS VSS nfet_03v3 ad=0.6p pd=3.2u as=0.6p ps=3.2u w=1u l=8u
X855 a_92142_52130# neuron_4__VKdn VSS VSS nfet_03v3 ad=0.6p pd=3.2u as=0.6p ps=3.2u w=1u l=1u
X858 VDD a_8859_157048# neuron_4__Vlk VDD pfet_03v3 ad=0.504p pd=2.88u as=0.504p ps=2.88u w=0.84u l=16u
X861 a_64578_90264# a_64578_90264# VSS VSS nfet_03v3 ad=1.2p pd=5.2u as=1.2p ps=5.2u w=2u l=8u
X866 VDD a_64128_35280# VMEM_1 VDD pfet_03v3 ad=2.4p pd=9.2u as=2.4p ps=9.2u w=4u l=5.12u
X881 a_17910_95582# w[23] a_21514_95532# VSS nfet_03v3 ad=0.14p pd=1.06u as=0.14p ps=1.06u w=0.5u l=0.64u
X885 a_42236_196335# VSS a_51826_196335# VDD pfet_03v3 ad=0.3p pd=2.2u as=0.3p ps=2.2u w=0.5u l=45.45u
X886 a_21494_196237# a_8522_190701# w_151668_188170# VSS nfet_03v3 ad=0.28p pd=1.56u as=0.28p ps=1.56u w=1u l=6u
X894 a_21514_51140# DAC_7__Vb VSS VSS nfet_03v3 ad=0.6p pd=3.2u as=0.6p ps=3.2u w=1u l=8u
X897 a_23614_32664# w[6] a_17910_32714# VSS nfet_03v3 ad=0.3p pd=2.2u as=0.14p ps=1.06u w=0.5u l=0.64u
X905 a_71006_196335# VSS a_80596_196335# VDD pfet_03v3 ad=0.3p pd=2.2u as=0.3p ps=2.2u w=0.5u l=45.45u
X914 a_21514_81344# DAC_7__Vb VSS VSS nfet_03v3 ad=0.6p pd=3.2u as=0.6p ps=3.2u w=1u l=8u
X918 VDD neuron_4__VNA a_95576_118854# VDD pfet_03v3 ad=0.6p pd=3.2u as=0.6p ps=3.2u w=1u l=1u
X929 a_21514_32664# w[7] a_17910_32714# VSS nfet_03v3 ad=0.14p pd=1.06u as=0.14p ps=1.06u w=0.5u l=0.64u
X932 a_64128_35280# a_64128_35280# DAC_6__Isum_e DAC_6__Isum_e nfet_03v3 ad=2.4p pd=9.2u as=2.4p ps=9.2u w=4u l=5.12u
X947 w_151668_188170# a_8522_190701# a_21494_196237# VSS nfet_03v3 ad=0.28p pd=1.56u as=0.28p ps=1.56u w=1u l=6u
X951 VDD w_87818_180350# a_10219_180030# VDD pfet_03v3 ad=0.28p pd=1.56u as=0.28p ps=1.56u w=1u l=6u
X952 a_21514_14188# DAC_7__Vb VSS VSS nfet_03v3 ad=0.6p pd=3.2u as=0.6p ps=3.2u w=1u l=8u
X954 a_8522_190701# a_8522_190701# VSS VSS nfet_03v3 ad=0.6p pd=3.2u as=0.6p ps=3.2u w=1u l=6u
X964 VDD DPI_4__VT a_68678_96088# VDD pfet_03v3 ad=2.4p pd=9.2u as=2.4p ps=9.2u w=4u l=5.12u
X965 a_17910_14238# w[2] a_23614_14188# VSS nfet_03v3 ad=0.14p pd=1.06u as=0.14p ps=1.06u w=0.5u l=0.64u
X980 w_151668_188170# a_8522_190701# a_21494_196237# VSS nfet_03v3 ad=0.28p pd=1.56u as=0.28p ps=1.56u w=1u l=6u
X982 a_18158_14238# pulse[0] a_17910_14238# VSS nfet_03v3 ad=0.3p pd=2.2u as=0.3p ps=2.2u w=0.5u l=0.64u
X991 a_91134_51780# VT a_89334_52130# VSS nfet_03v3 ad=2.4p pd=9.2u as=2.4p ps=9.2u w=4u l=2u
X993 VDD trim_steer_0__Iref trim_steer_0__Iref VDD pfet_03v3 ad=0.28p pd=1.56u as=0.28p ps=1.56u w=1u l=6u
X995 a_17910_95582# w[20] a_36214_95532# VSS nfet_03v3 ad=0.3p pd=2.2u as=0.3p ps=2.2u w=0.5u l=0.64u
X998 a_23614_125736# w[30] a_17910_125786# VSS nfet_03v3 ad=0.14p pd=1.06u as=0.14p ps=1.06u w=0.5u l=0.64u
X1000 a_17910_51190# w[9] a_27814_51140# VSS nfet_03v3 ad=0.14p pd=1.06u as=0.3p ps=2.2u w=0.5u l=0.64u
X1008 a_21494_196237# a_21494_196237# VDD VDD pfet_03v3 ad=0.28p pd=1.56u as=0.6p ps=3.2u w=1u l=6u
X1021 trim_steer_0__Iref trim_steer_0__Iref VDD VDD pfet_03v3 ad=0.28p pd=1.56u as=0.28p ps=1.56u w=1u l=6u
X1023 a_109366_196335# VSS a_9722_190909# VDD pfet_03v3 ad=0.3p pd=2.2u as=0.3p ps=2.2u w=0.5u l=45.45u
X1026 a_23614_81344# DAC_7__Vb VSS VSS nfet_03v3 ad=0.6p pd=3.2u as=0.6p ps=3.2u w=1u l=8u
X1028 a_17910_95582# w[23] a_21514_95532# VSS nfet_03v3 ad=0.14p pd=1.06u as=0.14p ps=1.06u w=0.5u l=0.64u
X1029 VDD neuron_4__VNA a_95576_88650# VDD pfet_03v3 ad=0.6p pd=3.2u as=0.6p ps=3.2u w=1u l=1u
X1036 a_21494_196237# a_8522_190701# w_151668_188170# VSS nfet_03v3 ad=0.28p pd=1.56u as=0.28p ps=1.56u w=1u l=6u
X1044 a_17910_81394# w[19] a_21514_81344# VSS nfet_03v3 ad=0.14p pd=1.06u as=0.3p ps=2.2u w=0.5u l=0.64u
X1051 a_36214_14188# DAC_7__Vb VSS VSS nfet_03v3 ad=0.6p pd=3.2u as=0.6p ps=3.2u w=1u l=8u
X1069 DPI_4__VT DPI_4__VT VDD VDD pfet_03v3 ad=1.12p pd=4.56u as=1.12p ps=4.56u w=4u l=5.12u
X1075 a_36214_125736# DAC_7__Vb VSS VSS nfet_03v3 ad=0.6p pd=3.2u as=0.6p ps=3.2u w=1u l=8u
X1076 a_21514_32664# DAC_7__Vb VSS VSS nfet_03v3 ad=0.6p pd=3.2u as=0.6p ps=3.2u w=1u l=8u
X1080 a_21514_32664# w[7] a_17910_32714# VSS nfet_03v3 ad=0.3p pd=2.2u as=0.14p ps=1.06u w=0.5u l=0.64u
X1085 VDD a_89872_118854# a_89872_118854# VDD pfet_03v3 ad=0.3p pd=2.2u as=0.3p ps=2.2u w=0.5u l=8u
X1088 VDD w_87818_180350# a_33687_180030# VDD pfet_03v3 ad=0.6p pd=3.2u as=0.28p ps=1.56u w=1u l=6u
X1091 VDD DPI_4__VT DPI_4__VT VDD pfet_03v3 ad=1.12p pd=4.56u as=1.12p ps=4.56u w=4u l=5.12u
X1096 VDD a_89872_21494# a_89872_21494# VDD pfet_03v3 ad=0.3p pd=2.2u as=0.3p ps=2.2u w=0.5u l=8u
X1100 w_151668_188170# a_8522_190701# a_21494_196237# VSS nfet_03v3 ad=0.28p pd=1.56u as=0.28p ps=1.56u w=1u l=6u
X1109 DPI_4__VT DPI_4__VT VDD VDD pfet_03v3 ad=1.12p pd=4.56u as=1.12p ps=4.56u w=4u l=5.12u
X1119 a_17910_111598# w[27] a_21514_111548# VSS nfet_03v3 ad=0.14p pd=1.06u as=0.14p ps=1.06u w=0.5u l=0.64u
X1126 a_21514_95532# DAC_7__Vb VSS VSS nfet_03v3 ad=0.6p pd=3.2u as=0.6p ps=3.2u w=1u l=8u
X1129 a_17910_14238# w[3] a_21514_14188# VSS nfet_03v3 ad=0.14p pd=1.06u as=0.14p ps=1.06u w=0.5u l=0.64u
X1137 a_21514_14188# DAC_7__Vb VSS VSS nfet_03v3 ad=0.6p pd=3.2u as=0.6p ps=3.2u w=1u l=8u
X1148 a_92142_112538# neuron_4__VKdn VSS VSS nfet_03v3 ad=0.6p pd=3.2u as=0.6p ps=3.2u w=1u l=1u
X1150 VDD DPI_4__Vthr DPI_4__Vthr VDD pfet_03v3 ad=1.12p pd=4.56u as=1.12p ps=4.56u w=4u l=5.12u
X1152 w_151668_188170# a_8522_190701# a_21494_196237# VSS nfet_03v3 ad=0.6p pd=3.2u as=0.28p ps=1.56u w=1u l=6u
X1154 a_18658_32506# s[1] VSS VSS nfet_03v3 ad=0.3p pd=2.2u as=0.3p ps=2.2u w=0.5u l=0.64u
X1163 VDD neuron_4__VKup a_94948_58446# VDD pfet_03v3 ad=0.6p pd=3.2u as=0.6p ps=3.2u w=1u l=1u
X1169 VDD trim_steer_0__Iref trim_steer_0__Iref VDD pfet_03v3 ad=0.28p pd=1.56u as=0.6p ps=3.2u w=1u l=6u
X1170 VDD DPI_4__VT DPI_4__VT VDD pfet_03v3 ad=1.12p pd=4.56u as=1.12p ps=4.56u w=4u l=5.12u
X1181 a_92770_33654# neuron_4__VK VSS VSS nfet_03v3 ad=0.6p pd=3.2u as=0.6p ps=3.2u w=1u l=1u
X1203 spike[3] VSS cap_mim_2f0_m4m5_noshield c_width=10u c_length=10u
X1204 VDD trim_steer_0__Iref trim_steer_0__Iref VDD pfet_03v3 ad=0.28p pd=1.56u as=0.28p ps=1.56u w=1u l=6u
X1211 w_151668_188170# a_8522_190701# a_21494_196237# VSS nfet_03v3 ad=0.28p pd=1.56u as=0.28p ps=1.56u w=1u l=6u
X1213 VDD trim_steer_0__Iref trim_steer_0__Iref VDD pfet_03v3 ad=0.6p pd=3.2u as=0.28p ps=1.56u w=1u l=6u
X1221 VDD DPI_4__Vthr DPI_4__Vthr VDD pfet_03v3 ad=1.12p pd=4.56u as=1.12p ps=4.56u w=4u l=5.12u
X1224 VDD w_87818_180350# a_39323_180030# VDD pfet_03v3 ad=0.28p pd=1.56u as=0.28p ps=1.56u w=1u l=6u
X1225 VDD a_64128_35280# cap_mim_2f0_m4m5_noshield c_width=22.18u c_length=22.18u
X1230 a_23614_95532# DAC_7__Vb VSS VSS nfet_03v3 ad=0.6p pd=3.2u as=0.6p ps=3.2u w=1u l=8u
X1232 VDD DPI_4__Vthr DPI_4__Vthr VDD pfet_03v3 ad=1.12p pd=4.56u as=1.12p ps=4.56u w=4u l=5.12u
X1244 VDD DPI_4__VT DPI_4__VT VDD pfet_03v3 ad=1.12p pd=4.56u as=1.12p ps=4.56u w=4u l=5.12u
X1248 a_17910_95582# w[23] a_21514_95532# VSS nfet_03v3 ad=0.14p pd=1.06u as=0.3p ps=2.2u w=0.5u l=0.64u
X1251 a_30675_180030# w_87818_180350# VDD VDD pfet_03v3 ad=0.28p pd=1.56u as=0.6p ps=3.2u w=1u l=6u
X1255 a_21494_196237# a_8522_190701# w_151668_188170# VSS nfet_03v3 ad=0.28p pd=1.56u as=0.28p ps=1.56u w=1u l=6u
X1260 w_151668_188170# a_8522_190701# a_21494_196237# VSS nfet_03v3 ad=0.28p pd=1.56u as=0.28p ps=1.56u w=1u l=6u
X1261 a_10219_180030# w_87818_180350# VDD VDD pfet_03v3 ad=0.28p pd=1.56u as=0.28p ps=1.56u w=1u l=6u
X1263 VDD s[1] a_18658_32506# VDD pfet_03v3 ad=0.3p pd=2.2u as=0.3p ps=2.2u w=0.5u l=0.32u
X1267 a_23614_32664# w[6] a_17910_32714# VSS nfet_03v3 ad=0.14p pd=1.06u as=0.14p ps=1.06u w=0.5u l=0.64u
X1277 VMEM_3 a_64578_90264# VSS VSS nfet_03v3 ad=1.44p pd=6u as=1.44p ps=6u w=2.4u l=8u
X1282 VDD a_91134_14828# a_91762_15178# VDD pfet_03v3 ad=0.3p pd=2.2u as=0.3p ps=2.2u w=0.5u l=0.64u
X1286 VDD a_8859_157048# neuron_4__VIp VDD pfet_03v3 ad=1.404p pd=5.88u as=1.404p ps=5.88u w=2.34u l=8u
X1289 bias_0__VT_inh bias_0__VT_inh VDD VDD pfet_03v3 ad=0.2464p pd=1.44u as=0.2464p ps=1.44u w=0.88u l=1.12u
X1290 a_23614_111548# DAC_7__Vb VSS VSS nfet_03v3 ad=0.6p pd=3.2u as=0.6p ps=3.2u w=1u l=8u
X1302 bias_0__VT_inh bias_0__VT_inh VDD VDD pfet_03v3 ad=0.2464p pd=1.44u as=0.528p ps=2.96u w=0.88u l=1.12u
X1315 a_23614_51140# DAC_7__Vb VSS VSS nfet_03v3 ad=0.6p pd=3.2u as=0.6p ps=3.2u w=1u l=8u
X1317 a_21514_65328# DAC_7__Vb VSS VSS nfet_03v3 ad=0.6p pd=3.2u as=0.6p ps=3.2u w=1u l=8u
X1318 VDD DPI_4__Vthr DPI_4__Vthr VDD pfet_03v3 ad=1.12p pd=4.56u as=1.12p ps=4.56u w=4u l=5.12u
X1322 VDD w_87818_180350# a_10219_180030# VDD pfet_03v3 ad=0.28p pd=1.56u as=0.28p ps=1.56u w=1u l=6u
X1324 a_17910_125786# w[31] a_21514_125736# VSS nfet_03v3 ad=0.14p pd=1.06u as=0.14p ps=1.06u w=0.5u l=0.64u
X1329 a_17910_14238# w[2] a_23614_14188# VSS nfet_03v3 ad=0.14p pd=1.06u as=0.3p ps=2.2u w=0.5u l=0.64u
X1335 neuron_4__VKdn neuron_4__VKdn VSS VSS nfet_03v3 ad=0.28p pd=1.56u as=0.28p ps=1.56u w=1u l=1u
X1347 a_21494_196237# a_8522_190701# w_151668_188170# VSS nfet_03v3 ad=0.28p pd=1.56u as=0.28p ps=1.56u w=1u l=6u
X1355 a_42250_171366# trim[2] VSS VSS nfet_03v3 ad=0.375p pd=2.5u as=0.375p ps=2.5u w=0.5u l=0.28u
X1361 a_17910_14238# w[3] a_21514_14188# VSS nfet_03v3 ad=0.14p pd=1.06u as=0.14p ps=1.06u w=0.5u l=0.64u
X1366 a_21514_81344# w[19] a_17910_81394# VSS nfet_03v3 ad=0.14p pd=1.06u as=0.14p ps=1.06u w=0.5u l=0.64u
X1377 a_91762_15178# a_91134_14828# a_91514_15178# VSS nfet_03v3 ad=0.3p pd=2.2u as=0.3p ps=2.2u w=0.5u l=0.64u
X1378 VDD w_87818_180350# a_39323_180030# VDD pfet_03v3 ad=0.6p pd=3.2u as=0.28p ps=1.56u w=1u l=6u
X1381 w_151668_188170# a_8522_190701# a_21494_196237# VSS nfet_03v3 ad=0.28p pd=1.56u as=0.28p ps=1.56u w=1u l=6u
X1386 trim_steer_0__Iref trim_steer_0__Iref VDD VDD pfet_03v3 ad=0.28p pd=1.56u as=0.28p ps=1.56u w=1u l=6u
X1392 a_72340_144600# neuron_4__VK VSS VSS nfet_03v3 ad=0.3p pd=2.2u as=0.3p ps=2.2u w=0.5u l=45.45u
X1404 VDD DPI_4__Vthr DPI_4__Vthr VDD pfet_03v3 ad=1.12p pd=4.56u as=1.12p ps=4.56u w=4u l=5.12u
X1407 a_21494_196237# a_8522_190701# w_151668_188170# VSS nfet_03v3 ad=0.28p pd=1.56u as=0.28p ps=1.56u w=1u l=6u
X1408 a_36214_65328# DAC_7__Vb VSS VSS nfet_03v3 ad=0.6p pd=3.2u as=0.6p ps=3.2u w=1u l=8u
X1413 a_10219_180030# w_87818_180350# VDD VDD pfet_03v3 ad=0.28p pd=1.56u as=0.28p ps=1.56u w=1u l=6u
X1414 a_39323_180030# w_87818_180350# VDD VDD pfet_03v3 ad=0.28p pd=1.56u as=0.28p ps=1.56u w=1u l=6u
X1419 VDD a_89872_88650# a_89872_88650# VDD pfet_03v3 ad=0.3p pd=2.2u as=0.3p ps=2.2u w=0.5u l=8u
X1426 a_17910_111598# w[27] a_21514_111548# VSS nfet_03v3 ad=0.14p pd=1.06u as=0.14p ps=1.06u w=0.5u l=0.64u
X1440 w_149628_198022# w_148948_188170# VSS nwell r_width=2u r_length=48.78u
X1442 w_151668_188170# a_8522_190701# a_21494_196237# VSS nfet_03v3 ad=0.28p pd=1.56u as=0.28p ps=1.56u w=1u l=6u
X1462 DAC_5__Isum_i s[3] a_18158_65378# VSS nfet_03v3 ad=0.3p pd=2.2u as=0.3p ps=2.2u w=0.5u l=0.64u
X1467 a_17910_14238# w[0] a_36214_14188# VSS nfet_03v3 ad=0.3p pd=2.2u as=0.3p ps=2.2u w=0.5u l=0.64u
X1474 a_89334_112538# neuron_4__Vamp_bias VSS VSS nfet_03v3 ad=0.3p pd=2.2u as=0.3p ps=2.2u w=0.5u l=0.64u
X1475 VDD w_87818_180350# a_10219_180030# VDD pfet_03v3 ad=0.28p pd=1.56u as=0.28p ps=1.56u w=1u l=6u
X1482 VDD trim_steer_0__Iref trim_steer_0__Iref VDD pfet_03v3 ad=0.28p pd=1.56u as=0.28p ps=1.56u w=1u l=6u
X1498 VMEM_3 neuron_4__Vlk VSS VSS nfet_03v3 ad=0.6p pd=3.2u as=0.6p ps=3.2u w=1u l=1u
X1507 a_17910_14238# w[3] a_21514_14188# VSS nfet_03v3 ad=0.14p pd=1.06u as=0.14p ps=1.06u w=0.5u l=0.64u
X1508 a_21514_65328# DAC_7__Vb VSS VSS nfet_03v3 ad=0.6p pd=3.2u as=0.6p ps=3.2u w=1u l=8u
X1515 spike[2] VSS cap_mim_2f0_m4m5_noshield c_width=10u c_length=10u
X1518 a_23614_125736# DAC_7__Vb VSS VSS nfet_03v3 ad=0.6p pd=3.2u as=0.6p ps=3.2u w=1u l=8u
X1522 a_21514_81344# w[19] a_17910_81394# VSS nfet_03v3 ad=0.14p pd=1.06u as=0.14p ps=1.06u w=0.5u l=0.64u
X1524 a_27814_51140# DAC_7__Vb VSS VSS nfet_03v3 ad=0.6p pd=3.2u as=0.6p ps=3.2u w=1u l=8u
X1528 neuron_4__VKdn neuron_4__VKdn VSS VSS nfet_03v3 ad=0.28p pd=1.56u as=0.6p ps=3.2u w=1u l=1u
X1530 a_21514_111548# w[27] a_17910_111598# VSS nfet_03v3 ad=0.14p pd=1.06u as=0.14p ps=1.06u w=0.5u l=0.64u
X1545 a_23614_81344# DAC_7__Vb VSS VSS nfet_03v3 ad=0.6p pd=3.2u as=0.6p ps=3.2u w=1u l=8u
X1551 VDD a_8859_157048# neuron_4__VK VDD pfet_03v3 ad=6.27p pd=22.1u as=6.27p ps=22.1u w=10.45u l=8u
X1555 trim_steer_0__Iref trim_steer_0__Iref VDD VDD pfet_03v3 ad=0.28p pd=1.56u as=0.28p ps=1.56u w=1u l=6u
X1560 a_89872_39970# VMEM_1 a_89334_33654# VSS nfet_03v3 ad=2.4p pd=9.2u as=2.4p ps=9.2u w=4u l=2u
X1562 DPI_4__VT DPI_4__VT VDD VDD pfet_03v3 ad=1.12p pd=4.56u as=1.12p ps=4.56u w=4u l=5.12u
X1575 w_145548_198022# w_144868_188170# VSS nwell r_width=2u r_length=48.78u
X1582 a_27814_14188# DAC_7__Vb VSS VSS nfet_03v3 ad=0.6p pd=3.2u as=0.6p ps=3.2u w=1u l=8u
X1591 a_21494_196237# a_8522_190701# w_151668_188170# VSS nfet_03v3 ad=0.28p pd=1.56u as=0.28p ps=1.56u w=1u l=6u
X1600 a_21514_95532# w[23] a_17910_95582# VSS nfet_03v3 ad=0.14p pd=1.06u as=0.14p ps=1.06u w=0.5u l=0.64u
X1602 a_37150_170466# a_46000_171624# VSS VSS nfet_03v3 ad=0.3p pd=2.2u as=0.3p ps=2.2u w=0.5u l=45.45u
X1604 a_18658_111390# s[6] VSS VSS nfet_03v3 ad=0.3p pd=2.2u as=0.3p ps=2.2u w=0.5u l=0.64u
X1607 w_151668_188170# a_8522_190701# a_21494_196237# VSS nfet_03v3 ad=0.28p pd=1.56u as=0.28p ps=1.56u w=1u l=6u
X1610 a_21514_32664# DAC_7__Vb VSS VSS nfet_03v3 ad=0.6p pd=3.2u as=0.6p ps=3.2u w=1u l=8u
X1618 VSS neuron_4__Vlk neuron_4__Vlk VSS nfet_03v3 ad=0.28p pd=1.56u as=0.28p ps=1.56u w=1u l=1u
X1623 a_17910_32714# w[6] a_23614_32664# VSS nfet_03v3 ad=0.14p pd=1.06u as=0.14p ps=1.06u w=0.5u l=0.64u
X1637 VDD a_91134_81984# a_91762_82334# VDD pfet_03v3 ad=0.3p pd=2.2u as=0.3p ps=2.2u w=0.5u l=0.64u
X1638 DPI_4__Vthr DPI_4__Vthr VDD VDD pfet_03v3 ad=1.12p pd=4.56u as=1.12p ps=4.56u w=4u l=5.12u
X1639 a_18158_32714# pulse[1] a_17910_32714# VSS nfet_03v3 ad=0.3p pd=2.2u as=0.3p ps=2.2u w=0.5u l=0.64u
X1654 a_64128_16804# a_64128_16804# DAC_7__Isum_e DAC_7__Isum_e nfet_03v3 ad=2.4p pd=9.2u as=2.4p ps=9.2u w=4u l=5.12u
X1665 a_17910_125786# w[31] a_21514_125736# VSS nfet_03v3 ad=0.14p pd=1.06u as=0.14p ps=1.06u w=0.5u l=0.64u
X1667 DAC_5__Isum_e a_18658_50982# a_18158_51190# VSS nfet_03v3 ad=0.3p pd=2.2u as=0.3p ps=2.2u w=0.5u l=0.64u
X1668 VDD s[2] a_18658_50982# VDD pfet_03v3 ad=0.3p pd=2.2u as=0.3p ps=2.2u w=0.5u l=0.32u
X1678 w_149628_198022# w_150308_188170# VSS nwell r_width=2u r_length=48.78u
X1684 a_21514_14188# DAC_7__Vb VSS VSS nfet_03v3 ad=0.6p pd=3.2u as=0.6p ps=3.2u w=1u l=8u
X1705 a_36214_32664# DAC_7__Vb VSS VSS nfet_03v3 ad=0.6p pd=3.2u as=0.6p ps=3.2u w=1u l=8u
X1712 VDD DPI_4__Vthr DAC_5__Isum_i DAC_5__Isum_i nfet_03v3 ad=2.4p pd=9.2u as=2.4p ps=9.2u w=4u l=5.12u
X1724 DPI_4__Vthr DPI_4__Vthr VDD VDD pfet_03v3 ad=1.12p pd=4.56u as=1.12p ps=4.56u w=4u l=5.12u
X1741 DAC_1__Isum_i s[6] a_18158_111598# VSS nfet_03v3 ad=0.3p pd=2.2u as=0.3p ps=2.2u w=0.5u l=0.64u
X1744 neuron_4__Vlk neuron_4__Vlk VSS VSS nfet_03v3 ad=0.28p pd=1.56u as=0.6p ps=3.2u w=1u l=1u
X1746 VMEM_0 VSS cap_mim_2f0_m4m5_noshield c_width=22.18u c_length=22.18u
X1747 a_23614_65328# w[14] a_17910_65378# VSS nfet_03v3 ad=0.3p pd=2.2u as=0.14p ps=1.06u w=0.5u l=0.64u
X1753 a_21514_95532# w[23] a_17910_95582# VSS nfet_03v3 ad=0.14p pd=1.06u as=0.14p ps=1.06u w=0.5u l=0.64u
X1762 a_21514_125736# w[31] a_17910_125786# VSS nfet_03v3 ad=0.14p pd=1.06u as=0.14p ps=1.06u w=0.5u l=0.64u
X1770 a_17910_14238# w[3] a_21514_14188# VSS nfet_03v3 ad=0.14p pd=1.06u as=0.3p ps=2.2u w=0.5u l=0.64u
X1784 VDD a_64128_114164# VMEM_4 VDD pfet_03v3 ad=2.4p pd=9.2u as=2.4p ps=9.2u w=4u l=5.12u
X1785 a_23614_95532# DAC_7__Vb VSS VSS nfet_03v3 ad=0.6p pd=3.2u as=0.6p ps=3.2u w=1u l=8u
X1787 a_21514_65328# w[15] a_17910_65378# VSS nfet_03v3 ad=0.14p pd=1.06u as=0.14p ps=1.06u w=0.5u l=0.64u
X1798 w_151668_188170# a_8522_190701# a_21494_196237# VSS nfet_03v3 ad=0.28p pd=1.56u as=0.28p ps=1.56u w=1u l=6u
X1801 w_146908_198022# w_147588_188170# VSS nwell r_width=2u r_length=48.78u
X1807 a_9722_190909# a_8522_190701# VSS VSS nfet_03v3 ad=0.6p pd=3.2u as=0.6p ps=3.2u w=1u l=6u
X1816 a_17910_32714# w[7] a_21514_32664# VSS nfet_03v3 ad=0.14p pd=1.06u as=0.14p ps=1.06u w=0.5u l=0.64u
X1820 a_21514_32664# DAC_7__Vb VSS VSS nfet_03v3 ad=0.6p pd=3.2u as=0.6p ps=3.2u w=1u l=8u
X1832 a_8522_190701# a_8522_190701# VSS VSS nfet_03v3 ad=0.6p pd=3.2u as=0.6p ps=3.2u w=1u l=6u
X1848 a_18658_125578# s[7] VSS VSS nfet_03v3 ad=0.3p pd=2.2u as=0.3p ps=2.2u w=0.5u l=0.64u
X1849 a_64128_53756# a_64128_53756# DAC_5__Isum_e DAC_5__Isum_e nfet_03v3 ad=2.4p pd=9.2u as=2.4p ps=9.2u w=4u l=5.12u
X1880 a_27814_51140# w[9] a_17910_51190# VSS nfet_03v3 ad=0.3p pd=2.2u as=0.14p ps=1.06u w=0.5u l=0.64u
X1887 a_21514_111548# w[27] a_17910_111598# VSS nfet_03v3 ad=0.3p pd=2.2u as=0.14p ps=1.06u w=0.5u l=0.64u
X1899 a_95576_21494# a_91762_15178# VMEM_0 VDD pfet_03v3 ad=0.3p pd=2.2u as=0.3p ps=2.2u w=0.5u l=0.64u
X1902 bias_0__VT_inh bias_0__Iref VSS VSS nfet_03v3 ad=0.378p pd=2.46u as=0.378p ps=2.46u w=0.63u l=32u
X1923 VDD w_87818_180350# a_39323_180030# VDD pfet_03v3 ad=0.28p pd=1.56u as=0.28p ps=1.56u w=1u l=6u
X1924 a_27814_111548# w[25] a_17910_111598# VSS nfet_03v3 ad=0.3p pd=2.2u as=0.14p ps=1.06u w=0.5u l=0.64u
X1925 a_99776_196335# VSS a_109366_196335# VDD pfet_03v3 ad=0.3p pd=2.2u as=0.3p ps=2.2u w=0.5u l=45.45u
X1934 a_89334_15178# neuron_4__Vamp_bias VSS VSS nfet_03v3 ad=0.3p pd=2.2u as=0.3p ps=2.2u w=0.5u l=0.64u
X1942 a_21514_65328# w[15] a_17910_65378# VSS nfet_03v3 ad=0.3p pd=2.2u as=0.14p ps=1.06u w=0.5u l=0.64u
X1943 a_10219_180030# w_87818_180350# VDD VDD pfet_03v3 ad=0.28p pd=1.56u as=0.6p ps=3.2u w=1u l=6u
X1950 VMEM_1 VSS cap_mim_2f0_m4m5_noshield c_width=22.18u c_length=22.18u
X1955 VDD a_89872_21494# a_91134_14828# VDD pfet_03v3 ad=0.3p pd=2.2u as=0.3p ps=2.2u w=0.5u l=8u
X1958 a_23614_111548# DAC_7__Vb VSS VSS nfet_03v3 ad=0.6p pd=3.2u as=0.6p ps=3.2u w=1u l=8u
X1961 w_151668_188170# a_8522_190701# a_21494_196237# VSS nfet_03v3 ad=0.28p pd=1.56u as=0.28p ps=1.56u w=1u l=6u
X1985 w_151668_188170# a_8522_190701# a_21494_196237# VSS nfet_03v3 ad=0.28p pd=1.56u as=0.28p ps=1.56u w=1u l=6u
X1993 DAC_1__Isum_i s[7] a_18158_125786# VSS nfet_03v3 ad=0.3p pd=2.2u as=0.3p ps=2.2u w=0.5u l=0.64u
X1997 a_21514_51140# DAC_7__Vb VSS VSS nfet_03v3 ad=0.6p pd=3.2u as=0.6p ps=3.2u w=1u l=8u
X1998 a_39323_180030# w_87818_180350# VDD VDD pfet_03v3 ad=0.28p pd=1.56u as=0.28p ps=1.56u w=1u l=6u
X1999 a_27814_65328# DAC_7__Vb VSS VSS nfet_03v3 ad=0.6p pd=3.2u as=0.6p ps=3.2u w=1u l=8u
X2002 bias_0__VT_inh bias_0__VT_inh VDD VDD pfet_03v3 ad=0.2464p pd=1.44u as=0.2464p ps=1.44u w=0.88u l=1.12u
X2022 a_39323_180030# w_87818_180350# VDD VDD pfet_03v3 ad=0.28p pd=1.56u as=0.28p ps=1.56u w=1u l=6u
X2031 VDD w_87818_180350# a_30675_180030# VDD pfet_03v3 ad=0.6p pd=3.2u as=0.28p ps=1.56u w=1u l=6u
X2036 a_18658_65170# s[3] VSS VSS nfet_03v3 ad=0.3p pd=2.2u as=0.3p ps=2.2u w=0.5u l=0.64u
X2045 a_17910_32714# w[6] a_23614_32664# VSS nfet_03v3 ad=0.14p pd=1.06u as=0.3p ps=2.2u w=0.5u l=0.64u
X2063 a_21514_14188# DAC_7__Vb VSS VSS nfet_03v3 ad=0.6p pd=3.2u as=0.6p ps=3.2u w=1u l=8u
X2067 a_21514_111548# DAC_7__Vb VSS VSS nfet_03v3 ad=0.6p pd=3.2u as=0.6p ps=3.2u w=1u l=8u
X2071 bias_0__Iref bias_0__Iref VSS VSS nfet_03v3 ad=6p pd=21.2u as=6p ps=21.2u w=10u l=8u
X2072 a_91514_52130# neuron_4__VIp VSS VSS nfet_03v3 ad=0.6p pd=3.2u as=0.6p ps=3.2u w=1u l=1u
X2073 a_9722_190909# a_8522_190701# VSS VSS nfet_03v3 ad=0.6p pd=3.2u as=0.6p ps=3.2u w=1u l=6u
X2079 a_17910_32714# w[7] a_21514_32664# VSS nfet_03v3 ad=0.14p pd=1.06u as=0.14p ps=1.06u w=0.5u l=0.64u
X2093 DPI_4__Vthr DPI_4__Vthr VDD VDD pfet_03v3 ad=1.12p pd=4.56u as=1.12p ps=4.56u w=4u l=5.12u
X2095 a_91762_33654# a_91134_33304# a_91514_33654# VSS nfet_03v3 ad=0.3p pd=2.2u as=0.3p ps=2.2u w=0.5u l=0.64u
X2098 a_94948_58446# a_91762_52130# spike[2] VDD pfet_03v3 ad=0.3p pd=2.2u as=0.3p ps=2.2u w=0.5u l=0.64u
X2102 VDD DPI_4__VT a_64128_53756# VDD pfet_03v3 ad=2.4p pd=9.2u as=2.4p ps=9.2u w=4u l=5.12u
X2103 VMEM_3 spike[3] a_92770_82334# VSS nfet_03v3 ad=0.3p pd=2.2u as=0.3p ps=2.2u w=0.5u l=11.36u
X2106 a_21514_65328# DAC_7__Vb VSS VSS nfet_03v3 ad=0.6p pd=3.2u as=0.6p ps=3.2u w=1u l=8u
X2114 a_9722_190909# a_8522_190701# VSS VSS nfet_03v3 ad=0.6p pd=3.2u as=0.6p ps=3.2u w=1u l=6u
X2122 a_30675_180030# trim[1] bias_0__Iref VSS nfet_03v3 ad=0.6p pd=3.2u as=0.6p ps=3.2u w=1u l=0.5u
X2124 a_91762_112538# a_91134_112188# a_91514_112538# VSS nfet_03v3 ad=0.3p pd=2.2u as=0.3p ps=2.2u w=0.5u l=0.64u
X2128 a_21514_125736# w[31] a_17910_125786# VSS nfet_03v3 ad=0.3p pd=2.2u as=0.14p ps=1.06u w=0.5u l=0.64u
X2138 a_8522_190701# a_8522_190701# VSS VSS nfet_03v3 ad=0.6p pd=3.2u as=0.6p ps=3.2u w=1u l=6u
X2143 a_21514_14188# w[3] a_17910_14238# VSS nfet_03v3 ad=0.14p pd=1.06u as=0.14p ps=1.06u w=0.5u l=0.64u
X2146 VDD a_68678_96088# a_64578_90264# VDD pfet_03v3 ad=2.4p pd=9.2u as=2.4p ps=9.2u w=4u l=5.12u
X2152 VDD a_64128_114164# cap_mim_2f0_m4m5_noshield c_width=22.18u c_length=22.18u
X2165 a_27814_125736# w[29] a_17910_125786# VSS nfet_03v3 ad=0.3p pd=2.2u as=0.14p ps=1.06u w=0.5u l=0.64u
X2166 a_23614_65328# w[14] a_17910_65378# VSS nfet_03v3 ad=0.14p pd=1.06u as=0.14p ps=1.06u w=0.5u l=0.64u
X2181 a_17910_32714# w[4] a_36214_32664# VSS nfet_03v3 ad=0.3p pd=2.2u as=0.3p ps=2.2u w=0.5u l=0.64u
X2185 VDD w_87818_180350# a_33687_180030# VDD pfet_03v3 ad=0.28p pd=1.56u as=0.28p ps=1.56u w=1u l=6u
X2186 a_92142_82334# neuron_4__VKdn VSS VSS nfet_03v3 ad=0.6p pd=3.2u as=0.6p ps=3.2u w=1u l=1u
X2187 a_23614_125736# DAC_7__Vb VSS VSS nfet_03v3 ad=0.6p pd=3.2u as=0.6p ps=3.2u w=1u l=8u
X2204 VDD s[7] a_18658_125578# VDD pfet_03v3 ad=0.3p pd=2.2u as=0.3p ps=2.2u w=0.5u l=0.32u
X2217 a_17910_32714# w[7] a_21514_32664# VSS nfet_03v3 ad=0.14p pd=1.06u as=0.14p ps=1.06u w=0.5u l=0.64u
X2228 a_21514_81344# DAC_7__Vb VSS VSS nfet_03v3 ad=0.6p pd=3.2u as=0.6p ps=3.2u w=1u l=8u
X2236 DPI_4__VT bias_0__Iref VSS VSS nfet_03v3 ad=0.702p pd=3.54u as=0.702p ps=3.54u w=1.17u l=32u
X2245 a_21494_196237# a_8522_190701# w_151668_188170# VSS nfet_03v3 ad=0.28p pd=1.56u as=0.28p ps=1.56u w=1u l=6u
X2251 a_95576_88650# a_91762_82334# VMEM_3 VDD pfet_03v3 ad=0.3p pd=2.2u as=0.3p ps=2.2u w=0.5u l=0.64u
X2257 a_21514_14188# DAC_7__Vb VSS VSS nfet_03v3 ad=0.6p pd=3.2u as=0.6p ps=3.2u w=1u l=8u
X2258 VMEM_0 neuron_4__Vlk VSS VSS nfet_03v3 ad=0.6p pd=3.2u as=0.6p ps=3.2u w=1u l=1u
X2278 bias_0__VT_inh bias_0__VT_inh VDD VDD pfet_03v3 ad=0.2464p pd=1.44u as=0.2464p ps=1.44u w=0.88u l=1.12u
X2280 a_21514_14188# w[3] a_17910_14238# VSS nfet_03v3 ad=0.14p pd=1.06u as=0.14p ps=1.06u w=0.5u l=0.64u
X2282 a_21514_125736# DAC_7__Vb VSS VSS nfet_03v3 ad=0.6p pd=3.2u as=0.6p ps=3.2u w=1u l=8u
X2285 a_27814_32664# DAC_7__Vb VSS VSS nfet_03v3 ad=0.6p pd=3.2u as=0.6p ps=3.2u w=1u l=8u
X2305 VDD a_89872_88650# a_91134_81984# VDD pfet_03v3 ad=0.3p pd=2.2u as=0.3p ps=2.2u w=0.5u l=8u
X2312 a_91134_81984# VT a_89334_82334# VSS nfet_03v3 ad=2.4p pd=9.2u as=2.4p ps=9.2u w=4u l=2u
X2323 a_17910_81394# w[17] a_27814_81344# VSS nfet_03v3 ad=0.14p pd=1.06u as=0.3p ps=2.2u w=0.5u l=0.64u
X2327 a_8522_190701# a_8522_190701# VSS VSS nfet_03v3 ad=0.6p pd=3.2u as=0.6p ps=3.2u w=1u l=6u
X2331 neuron_4__VK neuron_4__VK a_72340_144600# VSS nfet_03v3 ad=0.3p pd=2.2u as=0.3p ps=2.2u w=0.5u l=45.45u
X2343 a_9722_190909# a_8522_190701# VSS VSS nfet_03v3 ad=0.6p pd=3.2u as=0.6p ps=3.2u w=1u l=6u
X2345 VDD trim[2] a_42250_171366# VDD pfet_03v3 ad=0.75p pd=3.5u as=0.75p ps=3.5u w=1u l=0.28u
X2351 a_23614_14188# DAC_7__Vb VSS VSS nfet_03v3 ad=0.6p pd=3.2u as=0.6p ps=3.2u w=1u l=8u
X2353 VMEM_4 a_64578_120468# VSS VSS nfet_03v3 ad=1.44p pd=6u as=1.44p ps=6u w=2.4u l=8u
X2359 w_150988_198022# w_150308_188170# VSS nwell r_width=2u r_length=48.78u
X2366 VDD trim[0] a_39250_171366# VDD pfet_03v3 ad=0.75p pd=3.5u as=0.75p ps=3.5u w=1u l=0.28u
X2370 a_21514_32664# DAC_7__Vb VSS VSS nfet_03v3 ad=0.6p pd=3.2u as=0.6p ps=3.2u w=1u l=8u
X2375 a_9722_190909# a_8522_190701# VSS VSS nfet_03v3 ad=0.6p pd=3.2u as=0.6p ps=3.2u w=1u l=6u
X2392 VDD DPI_4__Vthr DPI_4__Vthr VDD pfet_03v3 ad=1.12p pd=4.56u as=1.12p ps=4.56u w=4u l=5.12u
X2400 a_8522_190701# a_8522_190701# VSS VSS nfet_03v3 ad=0.6p pd=3.2u as=0.6p ps=3.2u w=1u l=6u
X2407 spike[0] a_91762_15178# a_92142_15178# VSS nfet_03v3 ad=0.3p pd=2.2u as=0.3p ps=2.2u w=0.5u l=0.64u
X2410 VDD DPI_4__VT DPI_4__VT VDD pfet_03v3 ad=1.12p pd=4.56u as=1.12p ps=4.56u w=4u l=5.12u
X2413 VDD DPI_4__Vthr DPI_4__Vthr VDD pfet_03v3 ad=1.12p pd=4.56u as=1.12p ps=4.56u w=4u l=5.12u
X2415 VDD neuron_4__VKup a_94948_21494# VDD pfet_03v3 ad=0.6p pd=3.2u as=0.6p ps=3.2u w=1u l=1u
X2421 neuron_4__Vlk neuron_4__Vlk VSS VSS nfet_03v3 ad=0.28p pd=1.56u as=0.28p ps=1.56u w=1u l=1u
X2427 a_21514_65328# DAC_7__Vb VSS VSS nfet_03v3 ad=0.6p pd=3.2u as=0.6p ps=3.2u w=1u l=8u
X2433 a_23614_111548# DAC_7__Vb VSS VSS nfet_03v3 ad=0.6p pd=3.2u as=0.6p ps=3.2u w=1u l=8u
X2435 DPI_4__Vthr DPI_4__Vthr VDD VDD pfet_03v3 ad=1.12p pd=4.56u as=1.12p ps=4.56u w=4u l=5.12u
X2438 a_21514_95532# DAC_7__Vb VSS VSS nfet_03v3 ad=0.6p pd=3.2u as=0.6p ps=3.2u w=1u l=8u
X2448 a_91514_112538# neuron_4__VIp VSS VSS nfet_03v3 ad=0.6p pd=3.2u as=0.6p ps=3.2u w=1u l=1u
X2449 a_17910_32714# w[7] a_21514_32664# VSS nfet_03v3 ad=0.14p pd=1.06u as=0.3p ps=2.2u w=0.5u l=0.64u
X2466 w_86458_180350# w_87138_170254# VSS nwell r_width=2u r_length=50u
X2485 a_17910_65378# w[14] a_23614_65328# VSS nfet_03v3 ad=0.14p pd=1.06u as=0.14p ps=1.06u w=0.5u l=0.64u
X2492 a_68678_96088# a_68678_96088# DAC_3__Isum_i DAC_3__Isum_i nfet_03v3 ad=2.4p pd=9.2u as=2.4p ps=9.2u w=4u l=5.12u
X2498 a_18158_65378# spike[1] a_17910_65378# VSS nfet_03v3 ad=0.3p pd=2.2u as=0.3p ps=2.2u w=0.5u l=0.64u
X2502 VDD a_64128_83960# cap_mim_2f0_m4m5_noshield c_width=22.18u c_length=22.18u
X2520 a_17910_95582# w[21] a_27814_95532# VSS nfet_03v3 ad=0.14p pd=1.06u as=0.3p ps=2.2u w=0.5u l=0.64u
X2522 a_21514_51140# DAC_7__Vb VSS VSS nfet_03v3 ad=0.6p pd=3.2u as=0.6p ps=3.2u w=1u l=8u
X2525 bias_0__VT_inh bias_0__VT_inh VDD VDD pfet_03v3 ad=0.2464p pd=1.44u as=0.2464p ps=1.44u w=0.88u l=1.12u
X2561 w_87818_180350# w_87138_170254# VSS nwell r_width=2u r_length=50u
X2563 w_151668_188170# a_8522_190701# a_21494_196237# VSS nfet_03v3 ad=0.28p pd=1.56u as=0.28p ps=1.56u w=1u l=6u
X2565 a_94948_39970# a_91762_33654# spike[1] VDD pfet_03v3 ad=0.3p pd=2.2u as=0.3p ps=2.2u w=0.5u l=0.64u
X2572 VDD a_21494_196237# a_21494_196237# VDD pfet_03v3 ad=0.6p pd=3.2u as=0.28p ps=1.56u w=1u l=6u
X2579 VDD DPI_4__VT a_68678_126292# VDD pfet_03v3 ad=2.4p pd=9.2u as=2.4p ps=9.2u w=4u l=5.12u
X2591 a_89334_33654# neuron_4__Vamp_bias VSS VSS nfet_03v3 ad=0.3p pd=2.2u as=0.3p ps=2.2u w=0.5u l=0.64u
X2608 a_9722_190909# a_8522_190701# VSS VSS nfet_03v3 ad=0.6p pd=3.2u as=0.6p ps=3.2u w=1u l=6u
X2615 a_30675_180030# a_39850_171366# a_38750_170674# VSS nfet_03v3 ad=0.6p pd=3.2u as=0.6p ps=3.2u w=1u l=0.5u
X2620 a_36214_51140# DAC_7__Vb VSS VSS nfet_03v3 ad=0.6p pd=3.2u as=0.6p ps=3.2u w=1u l=8u
X2622 DPI_4__VT DPI_4__VT VDD VDD pfet_03v3 ad=1.12p pd=4.56u as=1.12p ps=4.56u w=4u l=5.12u
X2623 a_21514_65328# DAC_7__Vb VSS VSS nfet_03v3 ad=0.6p pd=3.2u as=0.6p ps=3.2u w=1u l=8u
X2633 a_9722_190909# a_8522_190701# VSS VSS nfet_03v3 ad=0.6p pd=3.2u as=0.6p ps=3.2u w=1u l=6u
X2636 a_23614_125736# DAC_7__Vb VSS VSS nfet_03v3 ad=0.6p pd=3.2u as=0.6p ps=3.2u w=1u l=8u
X2638 a_23614_81344# DAC_7__Vb VSS VSS nfet_03v3 ad=0.6p pd=3.2u as=0.6p ps=3.2u w=1u l=8u
X2645 neuron_4__Vlk neuron_4__Vlk VSS VSS nfet_03v3 ad=0.28p pd=1.56u as=0.28p ps=1.56u w=1u l=1u
X2651 VDD a_68678_96088# cap_mim_2f0_m4m5_noshield c_width=22.18u c_length=22.18u
X2658 a_17910_65378# w[15] a_21514_65328# VSS nfet_03v3 ad=0.14p pd=1.06u as=0.14p ps=1.06u w=0.5u l=0.64u
X2668 DAC_5__Isum_i s[2] a_18158_51190# VSS nfet_03v3 ad=0.3p pd=2.2u as=0.3p ps=2.2u w=0.5u l=0.64u
X2673 a_21514_111548# DAC_7__Vb VSS VSS nfet_03v3 ad=0.6p pd=3.2u as=0.6p ps=3.2u w=1u l=8u
X2686 VDD DPI_4__VT DPI_4__VT VDD pfet_03v3 ad=1.12p pd=4.56u as=1.12p ps=4.56u w=4u l=5.12u
X2687 VSS neuron_4__VKdn neuron_4__VKdn VSS nfet_03v3 ad=0.28p pd=1.56u as=0.28p ps=1.56u w=1u l=1u
X2695 a_21514_32664# DAC_7__Vb VSS VSS nfet_03v3 ad=0.6p pd=3.2u as=0.6p ps=3.2u w=1u l=8u
X2701 DPI_4__VT DPI_4__VT VDD VDD pfet_03v3 ad=1.12p pd=4.56u as=1.12p ps=4.56u w=4u l=5.12u
X2702 a_17910_111598# w[26] a_23614_111548# VSS nfet_03v3 ad=0.14p pd=1.06u as=0.3p ps=2.2u w=0.5u l=0.64u
X2707 a_21514_51140# DAC_7__Vb VSS VSS nfet_03v3 ad=0.6p pd=3.2u as=0.6p ps=3.2u w=1u l=8u
X2708 a_23614_65328# DAC_7__Vb VSS VSS nfet_03v3 ad=0.6p pd=3.2u as=0.6p ps=3.2u w=1u l=8u
X2727 VDD a_21494_196237# a_8522_190701# VDD pfet_03v3 ad=0.28p pd=1.56u as=0.28p ps=1.56u w=1u l=6u
X2728 a_21494_196237# a_8522_190701# w_151668_188170# VSS nfet_03v3 ad=0.28p pd=1.56u as=0.28p ps=1.56u w=1u l=6u
X2731 w_151668_188170# a_8522_190701# a_21494_196237# VSS nfet_03v3 ad=0.28p pd=1.56u as=0.28p ps=1.56u w=1u l=6u
X2736 trim_steer_0__Iref trim_steer_0__Iref VDD VDD pfet_03v3 ad=0.28p pd=1.56u as=0.28p ps=1.56u w=1u l=6u
X2739 VDD neuron_4__VKup a_94948_88650# VDD pfet_03v3 ad=0.6p pd=3.2u as=0.6p ps=3.2u w=1u l=1u
X2754 VDD DPI_4__Vthr DAC_1__Isum_i DAC_1__Isum_i nfet_03v3 ad=2.4p pd=9.2u as=2.4p ps=9.2u w=4u l=5.12u
X2761 a_21514_14188# DAC_7__Vb VSS VSS nfet_03v3 ad=0.6p pd=3.2u as=0.6p ps=3.2u w=1u l=8u
X2762 a_21514_32664# w[7] a_17910_32714# VSS nfet_03v3 ad=0.14p pd=1.06u as=0.14p ps=1.06u w=0.5u l=0.64u
X2766 DPI_4__Vthr DPI_4__Vthr VDD VDD pfet_03v3 ad=1.12p pd=4.56u as=1.12p ps=4.56u w=4u l=5.12u
X2777 DPI_4__VT DPI_4__VT VDD VDD pfet_03v3 ad=1.12p pd=4.56u as=2.4p ps=9.2u w=4u l=5.12u
X2788 DPI_4__VT DPI_4__VT VDD VDD pfet_03v3 ad=1.12p pd=4.56u as=1.12p ps=4.56u w=4u l=5.12u
X2797 VDD trim_steer_0__Iref trim_steer_0__Iref VDD pfet_03v3 ad=0.28p pd=1.56u as=0.28p ps=1.56u w=1u l=6u
X2805 VDD DPI_4__VT a_64128_35280# VDD pfet_03v3 ad=2.4p pd=9.2u as=2.4p ps=9.2u w=4u l=5.12u
X2831 a_38750_170674# cal a_37150_170466# VSS nfet_03v3 ad=0.6p pd=3.2u as=0.6p ps=3.2u w=1u l=0.5u
X2833 VDD a_64128_83960# VMEM_3 VDD pfet_03v3 ad=2.4p pd=9.2u as=2.4p ps=9.2u w=4u l=5.12u
X2840 a_27814_81344# DAC_7__Vb VSS VSS nfet_03v3 ad=0.6p pd=3.2u as=0.6p ps=3.2u w=1u l=8u
X2842 VDD w_87818_180350# a_10219_180030# VDD pfet_03v3 ad=0.28p pd=1.56u as=0.28p ps=1.56u w=1u l=6u
X2856 a_23614_95532# DAC_7__Vb VSS VSS nfet_03v3 ad=0.6p pd=3.2u as=0.6p ps=3.2u w=1u l=8u
X2862 DPI_4__Vthr DPI_4__Vthr VDD VDD pfet_03v3 ad=1.12p pd=4.56u as=1.12p ps=4.56u w=4u l=5.12u
X2864 a_17910_65378# w[14] a_23614_65328# VSS nfet_03v3 ad=0.14p pd=1.06u as=0.3p ps=2.2u w=0.5u l=0.64u
X2865 neuron_4__VNA bias_0__Iref VSS VSS nfet_03v3 ad=3.456p pd=12.72u as=3.456p ps=12.72u w=5.76u l=8u
X2872 VDD DPI_4__Vthr DAC_6__Isum_e DAC_6__Isum_e nfet_03v3 ad=2.4p pd=9.2u as=2.4p ps=9.2u w=4u l=5.12u
X2873 a_64578_60060# a_64578_60060# VSS VSS nfet_03v3 ad=1.2p pd=5.2u as=1.2p ps=5.2u w=2u l=8u
X2881 a_23614_14188# DAC_7__Vb VSS VSS nfet_03v3 ad=0.6p pd=3.2u as=0.6p ps=3.2u w=1u l=8u
X2882 a_92142_15178# neuron_4__VKdn VSS VSS nfet_03v3 ad=0.6p pd=3.2u as=0.6p ps=3.2u w=1u l=1u
X2885 DPI_4__VT DPI_4__VT VDD VDD pfet_03v3 ad=1.12p pd=4.56u as=1.12p ps=4.56u w=4u l=5.12u
X2890 a_9722_190909# a_8522_190701# VSS VSS nfet_03v3 ad=0.6p pd=3.2u as=0.6p ps=3.2u w=1u l=6u
X2891 a_21494_196237# a_8522_190701# w_151668_188170# VSS nfet_03v3 ad=0.28p pd=1.56u as=0.28p ps=1.56u w=1u l=6u
X2895 a_21514_125736# DAC_7__Vb VSS VSS nfet_03v3 ad=0.6p pd=3.2u as=0.6p ps=3.2u w=1u l=8u
X2900 a_17910_65378# w[15] a_21514_65328# VSS nfet_03v3 ad=0.14p pd=1.06u as=0.14p ps=1.06u w=0.5u l=0.64u
X2911 VMEM_1 neuron_4__Vlk VSS VSS nfet_03v3 ad=0.6p pd=3.2u as=0.6p ps=3.2u w=1u l=1u
X2912 a_21514_32664# DAC_7__Vb VSS VSS nfet_03v3 ad=0.6p pd=3.2u as=0.6p ps=3.2u w=1u l=8u
X2915 a_21494_196237# a_8522_190701# w_151668_188170# VSS nfet_03v3 ad=0.28p pd=1.56u as=0.28p ps=1.56u w=1u l=6u
X2917 a_9722_190909# a_8522_190701# VSS VSS nfet_03v3 ad=0.6p pd=3.2u as=0.6p ps=3.2u w=1u l=6u
X2918 trim_steer_0__Iref trim_steer_0__Iref VDD VDD pfet_03v3 ad=0.28p pd=1.56u as=0.28p ps=1.56u w=1u l=6u
X2928 a_21514_32664# w[7] a_17910_32714# VSS nfet_03v3 ad=0.14p pd=1.06u as=0.14p ps=1.06u w=0.5u l=0.64u
X2931 a_17910_125786# w[30] a_23614_125736# VSS nfet_03v3 ad=0.14p pd=1.06u as=0.3p ps=2.2u w=0.5u l=0.64u
X2939 VDD a_68678_126292# cap_mim_2f0_m4m5_noshield c_width=22.18u c_length=22.18u
X2947 a_23614_51140# w[10] a_17910_51190# VSS nfet_03v3 ad=0.3p pd=2.2u as=0.14p ps=1.06u w=0.5u l=0.64u
X2968 a_91762_52130# a_91134_51780# a_91514_52130# VSS nfet_03v3 ad=0.3p pd=2.2u as=0.3p ps=2.2u w=0.5u l=0.64u
X2971 VDD a_68678_65884# cap_mim_2f0_m4m5_noshield c_width=22.18u c_length=22.18u
X2975 VMEM_4 neuron_4__Vlk VSS VSS nfet_03v3 ad=0.6p pd=3.2u as=0.6p ps=3.2u w=1u l=1u
X2976 a_21514_51140# w[11] a_17910_51190# VSS nfet_03v3 ad=0.14p pd=1.06u as=0.14p ps=1.06u w=0.5u l=0.64u
X2984 VDD trim_steer_0__Iref trim_steer_0__Iref VDD pfet_03v3 ad=0.28p pd=1.56u as=0.28p ps=1.56u w=1u l=6u
X2985 DAC_3__Isum_e a_18658_81186# a_18158_81394# VSS nfet_03v3 ad=0.3p pd=2.2u as=0.3p ps=2.2u w=0.5u l=0.64u
X2996 neuron_4__VKup bias_0__Iref VSS VSS nfet_03v3 ad=3.606p pd=13.22u as=3.606p ps=13.22u w=6.01u l=8u
X3011 a_23614_32664# DAC_7__Vb VSS VSS nfet_03v3 ad=0.6p pd=3.2u as=0.6p ps=3.2u w=1u l=8u
X3017 a_17910_65378# w[12] a_36214_65328# VSS nfet_03v3 ad=0.3p pd=2.2u as=0.3p ps=2.2u w=0.5u l=0.64u
X3023 VDD a_89872_118854# a_91134_112188# VDD pfet_03v3 ad=0.3p pd=2.2u as=0.3p ps=2.2u w=0.5u l=8u
X3026 a_91134_14828# VT a_89334_15178# VSS nfet_03v3 ad=2.4p pd=9.2u as=2.4p ps=9.2u w=4u l=2u
X3032 a_17910_14238# w[1] a_27814_14188# VSS nfet_03v3 ad=0.14p pd=1.06u as=0.3p ps=2.2u w=0.5u l=0.64u
X3042 VDD s[6] a_18658_111390# VDD pfet_03v3 ad=0.3p pd=2.2u as=0.3p ps=2.2u w=0.5u l=0.32u
X3056 VSS neuron_4__VKdn neuron_4__VKdn VSS nfet_03v3 ad=0.6p pd=3.2u as=0.28p ps=1.56u w=1u l=1u
X3060 a_17910_65378# w[15] a_21514_65328# VSS nfet_03v3 ad=0.14p pd=1.06u as=0.14p ps=1.06u w=0.5u l=0.64u
X3066 a_21514_111548# w[27] a_17910_111598# VSS nfet_03v3 ad=0.14p pd=1.06u as=0.14p ps=1.06u w=0.5u l=0.64u
X3068 a_21494_196237# a_21494_196237# VDD VDD pfet_03v3 ad=0.28p pd=1.56u as=0.28p ps=1.56u w=1u l=6u
X3073 spike[1] a_91762_33654# a_92142_33654# VSS nfet_03v3 ad=0.3p pd=2.2u as=0.3p ps=2.2u w=0.5u l=0.64u
X3077 a_27814_95532# DAC_7__Vb VSS VSS nfet_03v3 ad=0.6p pd=3.2u as=0.6p ps=3.2u w=1u l=8u
X3080 a_21494_196237# a_8522_190701# w_151668_188170# VSS nfet_03v3 ad=0.28p pd=1.56u as=0.28p ps=1.56u w=1u l=6u
X3085 trim_steer_0__Iref trim_steer_0__Iref VDD VDD pfet_03v3 ad=0.28p pd=1.56u as=0.28p ps=1.56u w=1u l=6u
X3094 a_21494_196237# a_8522_190701# w_151668_188170# VSS nfet_03v3 ad=0.28p pd=1.56u as=0.28p ps=1.56u w=1u l=6u
X3104 VDD DPI_4__Vthr DPI_4__Vthr VDD pfet_03v3 ad=2.4p pd=9.2u as=1.12p ps=4.56u w=4u l=5.12u
X3130 a_21514_51140# w[11] a_17910_51190# VSS nfet_03v3 ad=0.3p pd=2.2u as=0.14p ps=1.06u w=0.5u l=0.64u
X3131 VDD a_21494_196237# a_21494_196237# VDD pfet_03v3 ad=0.28p pd=1.56u as=0.28p ps=1.56u w=1u l=6u
X3139 a_23614_111548# w[26] a_17910_111598# VSS nfet_03v3 ad=0.3p pd=2.2u as=0.14p ps=1.06u w=0.5u l=0.64u
X3147 a_8859_157048# bias_0__Iref VSS VSS nfet_03v3 ad=6p pd=21.2u as=6p ps=21.2u w=10u l=8u
X3148 a_21514_111548# DAC_7__Vb VSS VSS nfet_03v3 ad=0.6p pd=3.2u as=0.6p ps=3.2u w=1u l=8u
X3152 VDD trim_steer_0__Iref trim_steer_0__Iref VDD pfet_03v3 ad=0.28p pd=1.56u as=0.28p ps=1.56u w=1u l=6u
X3162 VDD s[0] a_18658_14030# VDD pfet_03v3 ad=0.3p pd=2.2u as=0.3p ps=2.2u w=0.5u l=0.32u
X3163 a_64128_83960# a_64128_83960# DAC_3__Isum_e DAC_3__Isum_e nfet_03v3 ad=2.4p pd=9.2u as=2.4p ps=9.2u w=4u l=5.12u
X3172 a_21514_65328# DAC_7__Vb VSS VSS nfet_03v3 ad=0.6p pd=3.2u as=0.6p ps=3.2u w=1u l=8u
X3188 a_27814_51140# DAC_7__Vb VSS VSS nfet_03v3 ad=0.6p pd=3.2u as=0.6p ps=3.2u w=1u l=8u
X3191 a_33687_180030# w_87818_180350# VDD VDD pfet_03v3 ad=0.28p pd=1.56u as=0.28p ps=1.56u w=1u l=6u
X3195 a_27814_81344# w[17] a_17910_81394# VSS nfet_03v3 ad=0.3p pd=2.2u as=0.14p ps=1.06u w=0.5u l=0.64u
X3204 bias_0__VT_inh bias_0__VT_inh VDD VDD pfet_03v3 ad=0.2464p pd=1.44u as=0.2464p ps=1.44u w=0.88u l=1.12u
X3214 VMEM_3 VSS cap_mim_2f0_m4m5_noshield c_width=22.18u c_length=22.18u
X3215 a_18658_50982# s[2] VSS VSS nfet_03v3 ad=0.3p pd=2.2u as=0.3p ps=2.2u w=0.5u l=0.64u
X3217 VDD DPI_4__VT DPI_4__VT VDD pfet_03v3 ad=1.12p pd=4.56u as=1.12p ps=4.56u w=4u l=5.12u
X3218 bias_0__VT_inh bias_0__VT_inh VDD VDD pfet_03v3 ad=0.2464p pd=1.44u as=0.2464p ps=1.44u w=0.88u l=1.12u
X3225 a_9722_190909# a_8522_190701# VSS VSS nfet_03v3 ad=0.6p pd=3.2u as=0.6p ps=3.2u w=1u l=6u
X3226 DAC_3__Isum_e a_18658_95374# a_18158_95582# VSS nfet_03v3 ad=0.3p pd=2.2u as=0.3p ps=2.2u w=0.5u l=0.64u
X3247 a_21494_196237# a_8522_190701# w_151668_188170# VSS nfet_03v3 ad=0.28p pd=1.56u as=0.28p ps=1.56u w=1u l=6u
X3254 a_92770_52130# neuron_4__VK VSS VSS nfet_03v3 ad=0.6p pd=3.2u as=0.6p ps=3.2u w=1u l=1u
X3273 a_21494_196237# a_8522_190701# w_151668_188170# VSS nfet_03v3 ad=0.28p pd=1.56u as=0.28p ps=1.56u w=1u l=6u
X3276 DPI_4__Vthr DPI_4__Vthr VDD VDD pfet_03v3 ad=1.12p pd=4.56u as=1.12p ps=4.56u w=4u l=5.12u
X3284 a_27655_180030# a_39250_171366# a_38750_170674# VSS nfet_03v3 ad=0.6p pd=3.2u as=0.6p ps=3.2u w=1u l=0.5u
X3293 a_21514_51140# DAC_7__Vb VSS VSS nfet_03v3 ad=0.6p pd=3.2u as=0.6p ps=3.2u w=1u l=8u
X3294 a_23614_65328# DAC_7__Vb VSS VSS nfet_03v3 ad=0.6p pd=3.2u as=0.6p ps=3.2u w=1u l=8u
X3300 a_46000_171624# cal VSS VSS nfet_03v3 ad=0.375p pd=2.5u as=0.375p ps=2.5u w=0.5u l=0.28u
X3308 a_21514_125736# w[31] a_17910_125786# VSS nfet_03v3 ad=0.14p pd=1.06u as=0.14p ps=1.06u w=0.5u l=0.64u
X3311 a_17910_65378# w[15] a_21514_65328# VSS nfet_03v3 ad=0.14p pd=1.06u as=0.3p ps=2.2u w=0.5u l=0.64u
X3312 a_21514_81344# DAC_7__Vb VSS VSS nfet_03v3 ad=0.6p pd=3.2u as=0.6p ps=3.2u w=1u l=8u
X3313 w_151668_188170# a_8522_190701# a_21494_196237# VSS nfet_03v3 ad=0.28p pd=1.56u as=0.28p ps=1.56u w=1u l=6u
X3322 VDD DPI_4__VT DPI_4__VT VDD pfet_03v3 ad=1.12p pd=4.56u as=1.12p ps=4.56u w=4u l=5.12u
X3331 a_21494_196237# a_8522_190701# w_151668_188170# VSS nfet_03v3 ad=0.28p pd=1.56u as=0.28p ps=1.56u w=1u l=6u
X3338 trim_steer_0__Iref trim_steer_0__Iref VDD VDD pfet_03v3 ad=0.28p pd=1.56u as=0.28p ps=1.56u w=1u l=6u
X3339 DPI_4__VT DPI_4__VT VDD VDD pfet_03v3 ad=1.12p pd=4.56u as=1.12p ps=4.56u w=4u l=5.12u
X3341 neuron_4__Vlk neuron_4__Vlk VSS VSS nfet_03v3 ad=0.28p pd=1.56u as=0.28p ps=1.56u w=1u l=1u
X3345 VMEM_2 a_64578_60060# VSS VSS nfet_03v3 ad=1.44p pd=6u as=1.44p ps=6u w=2.4u l=8u
X3364 a_23614_51140# w[10] a_17910_51190# VSS nfet_03v3 ad=0.14p pd=1.06u as=0.14p ps=1.06u w=0.5u l=0.64u
X3367 a_39323_180030# w_87818_180350# VDD VDD pfet_03v3 ad=0.28p pd=1.56u as=0.6p ps=3.2u w=1u l=6u
X3368 DPI_4__Vthr DPI_4__Vthr VDD VDD pfet_03v3 ad=1.12p pd=4.56u as=1.12p ps=4.56u w=4u l=5.12u
X3377 a_23614_125736# w[30] a_17910_125786# VSS nfet_03v3 ad=0.3p pd=2.2u as=0.14p ps=1.06u w=0.5u l=0.64u
X3382 a_91514_82334# neuron_4__VIp VSS VSS nfet_03v3 ad=0.6p pd=3.2u as=0.6p ps=3.2u w=1u l=1u
X3383 a_21514_125736# DAC_7__Vb VSS VSS nfet_03v3 ad=0.6p pd=3.2u as=0.6p ps=3.2u w=1u l=8u
X3387 w_151668_188170# a_8522_190701# a_21494_196237# VSS nfet_03v3 ad=0.28p pd=1.56u as=0.28p ps=1.56u w=1u l=6u
X3391 a_21494_196237# a_8522_190701# w_151668_188170# VSS nfet_03v3 ad=0.28p pd=1.56u as=0.28p ps=1.56u w=1u l=6u
X3402 a_89872_58446# VMEM_2 a_89334_52130# VSS nfet_03v3 ad=2.4p pd=9.2u as=2.4p ps=9.2u w=4u l=2u
X3405 DPI_4__Vthr DPI_4__Vthr VDD VDD pfet_03v3 ad=1.12p pd=4.56u as=1.12p ps=4.56u w=4u l=5.12u
X3412 a_21514_111548# w[27] a_17910_111598# VSS nfet_03v3 ad=0.14p pd=1.06u as=0.14p ps=1.06u w=0.5u l=0.64u
X3414 VDD neuron_4__VKup neuron_4__VKup VDD pfet_03v3 ad=0.6p pd=3.2u as=0.6p ps=3.2u w=1u l=8u
X3418 a_10219_180030# VDD bias_0__Iref VSS nfet_03v3 ad=0.6p pd=3.2u as=0.6p ps=3.2u w=1u l=0.5u
X3424 a_27814_95532# w[21] a_17910_95582# VSS nfet_03v3 ad=0.3p pd=2.2u as=0.14p ps=1.06u w=0.5u l=0.64u
X3435 VDD a_21494_196237# a_8522_190701# VDD pfet_03v3 ad=0.6p pd=3.2u as=0.28p ps=1.56u w=1u l=6u
X3448 a_23614_14188# DAC_7__Vb VSS VSS nfet_03v3 ad=0.6p pd=3.2u as=0.6p ps=3.2u w=1u l=8u
X3456 a_10219_180030# w_87818_180350# VDD VDD pfet_03v3 ad=0.28p pd=1.56u as=0.28p ps=1.56u w=1u l=6u
X3464 VSS neuron_4__Vlk neuron_4__Vlk VSS nfet_03v3 ad=0.28p pd=1.56u as=0.28p ps=1.56u w=1u l=1u
X3470 a_21514_32664# DAC_7__Vb VSS VSS nfet_03v3 ad=0.6p pd=3.2u as=0.6p ps=3.2u w=1u l=8u
X3473 a_10219_180030# w_87818_180350# VDD VDD pfet_03v3 ad=0.28p pd=1.56u as=0.28p ps=1.56u w=1u l=6u
X3486 VDD a_89872_58446# a_89872_58446# VDD pfet_03v3 ad=0.3p pd=2.2u as=0.3p ps=2.2u w=0.5u l=8u
X3487 bias_0__VT_inh bias_0__VT_inh VDD VDD pfet_03v3 ad=0.2464p pd=1.44u as=0.2464p ps=1.44u w=0.88u l=1.12u
X3492 trim_steer_0__Iref trim_steer_0__Iref VDD VDD pfet_03v3 ad=0.28p pd=1.56u as=0.28p ps=1.56u w=1u l=6u
X3501 VSS a_37150_170466# VSS VSS nfet_03v3 ad=3p pd=11.2u as=0 ps=0 w=5u l=5u
X3502 DPI_4__Vthr DPI_4__Vthr VDD VDD pfet_03v3 ad=1.12p pd=4.56u as=1.12p ps=4.56u w=4u l=5.12u
X3503 VDD a_68678_126292# a_64578_120468# VDD pfet_03v3 ad=2.4p pd=9.2u as=2.4p ps=9.2u w=4u l=5.12u
X3510 a_33687_180030# trim[2] bias_0__Iref VSS nfet_03v3 ad=0.6p pd=3.2u as=0.6p ps=3.2u w=1u l=0.5u
X3523 VDD s[4] a_18658_81186# VDD pfet_03v3 ad=0.3p pd=2.2u as=0.3p ps=2.2u w=0.5u l=0.32u
X3526 a_89334_52130# neuron_4__Vamp_bias VSS VSS nfet_03v3 ad=0.3p pd=2.2u as=0.3p ps=2.2u w=0.5u l=0.64u
X3531 VDD trim_steer_0__Iref trim_steer_0__Iref VDD pfet_03v3 ad=0.28p pd=1.56u as=0.28p ps=1.56u w=1u l=6u
X3534 a_17910_111598# w[27] a_21514_111548# VSS nfet_03v3 ad=0.14p pd=1.06u as=0.3p ps=2.2u w=0.5u l=0.64u
X3536 a_21514_95532# DAC_7__Vb VSS VSS nfet_03v3 ad=0.6p pd=3.2u as=0.6p ps=3.2u w=1u l=8u
X3537 VMEM_2 VSS cap_mim_2f0_m4m5_noshield c_width=22.18u c_length=22.18u
X3543 a_27814_111548# DAC_7__Vb VSS VSS nfet_03v3 ad=0.6p pd=3.2u as=0.6p ps=3.2u w=1u l=8u
X3547 w_151668_188170# a_8522_190701# a_21494_196237# VSS nfet_03v3 ad=0.28p pd=1.56u as=0.28p ps=1.56u w=1u l=6u
X3572 VDD w_87818_180350# a_10219_180030# VDD pfet_03v3 ad=0.6p pd=3.2u as=0.28p ps=1.56u w=1u l=6u
X3576 a_39850_171366# trim[1] VSS VSS nfet_03v3 ad=0.375p pd=2.5u as=0.375p ps=2.5u w=0.5u l=0.28u
X3581 a_21494_196237# a_8522_190701# w_151668_188170# VSS nfet_03v3 ad=0.28p pd=1.56u as=0.28p ps=1.56u w=1u l=6u
X3583 a_92142_33654# neuron_4__VKdn VSS VSS nfet_03v3 ad=0.6p pd=3.2u as=0.6p ps=3.2u w=1u l=1u
X3584 a_23614_32664# DAC_7__Vb VSS VSS nfet_03v3 ad=0.6p pd=3.2u as=0.6p ps=3.2u w=1u l=8u
X3590 VDD neuron_4__VNA a_95576_39970# VDD pfet_03v3 ad=0.6p pd=3.2u as=0.6p ps=3.2u w=1u l=1u
X3599 VDD a_64128_16804# VMEM_0 VDD pfet_03v3 ad=2.4p pd=9.2u as=2.4p ps=9.2u w=4u l=5.12u
X3619 a_39323_180030# a_42850_171366# a_38750_170674# VSS nfet_03v3 ad=0.6p pd=3.2u as=0.6p ps=3.2u w=1u l=0.5u
X3626 VDD a_64128_16804# cap_mim_2f0_m4m5_noshield c_width=22.18u c_length=22.18u
X3633 a_10219_180030# w_87818_180350# VDD VDD pfet_03v3 ad=0.28p pd=1.56u as=0.28p ps=1.56u w=1u l=6u
X3637 a_21514_51140# DAC_7__Vb VSS VSS nfet_03v3 ad=0.6p pd=3.2u as=0.6p ps=3.2u w=1u l=8u
X3640 a_21514_125736# w[31] a_17910_125786# VSS nfet_03v3 ad=0.14p pd=1.06u as=0.14p ps=1.06u w=0.5u l=0.64u
X3642 VDD DPI_4__Vthr DAC_7__Isum_e DAC_7__Isum_e nfet_03v3 ad=2.4p pd=9.2u as=2.4p ps=9.2u w=4u l=5.12u
X3655 VDD DPI_4__VT DPI_4__VT VDD pfet_03v3 ad=1.12p pd=4.56u as=1.12p ps=4.56u w=4u l=5.12u
X3657 VDD DPI_4__Vthr DPI_4__Vthr VDD pfet_03v3 ad=1.12p pd=4.56u as=1.12p ps=4.56u w=4u l=5.12u
X3662 a_21514_65328# w[15] a_17910_65378# VSS nfet_03v3 ad=0.14p pd=1.06u as=0.14p ps=1.06u w=0.5u l=0.64u
X3670 trim_steer_0__Iref trim_steer_0__Iref VDD VDD pfet_03v3 ad=0.28p pd=1.56u as=0.28p ps=1.56u w=1u l=6u
X3684 VDD trim_steer_0__Iref trim_steer_0__Iref VDD pfet_03v3 ad=0.28p pd=1.56u as=0.28p ps=1.56u w=1u l=6u
X3700 VDD a_91134_51780# a_91762_52130# VDD pfet_03v3 ad=0.3p pd=2.2u as=0.3p ps=2.2u w=0.5u l=0.64u
X3704 a_17910_51190# w[10] a_23614_51140# VSS nfet_03v3 ad=0.14p pd=1.06u as=0.14p ps=1.06u w=0.5u l=0.64u
X3718 a_17910_32714# w[5] a_27814_32664# VSS nfet_03v3 ad=0.14p pd=1.06u as=0.3p ps=2.2u w=0.5u l=0.64u
X3719 a_18158_51190# spike[0] a_17910_51190# VSS nfet_03v3 ad=0.3p pd=2.2u as=0.3p ps=2.2u w=0.5u l=0.64u
X3722 w_151668_188170# a_8522_190701# a_21494_196237# VSS nfet_03v3 ad=0.28p pd=1.56u as=0.28p ps=1.56u w=1u l=6u
X3723 a_21494_196237# a_9722_190909# VSS VSS nfet_03v3 ad=0.3p pd=2.2u as=0.3p ps=2.2u w=0.5u l=4u
X3725 DPI_4__VT DPI_4__VT VDD VDD pfet_03v3 ad=1.12p pd=4.56u as=1.12p ps=4.56u w=4u l=5.12u
X3733 DAC_7__Isum_e a_18658_14030# a_18158_14238# VSS nfet_03v3 ad=0.3p pd=2.2u as=0.3p ps=2.2u w=0.5u l=0.64u
X3747 a_92770_112538# neuron_4__VK VSS VSS nfet_03v3 ad=0.6p pd=3.2u as=0.6p ps=3.2u w=1u l=1u
X3751 a_17910_125786# w[31] a_21514_125736# VSS nfet_03v3 ad=0.14p pd=1.06u as=0.3p ps=2.2u w=0.5u l=0.64u
X3753 a_21494_196237# a_8522_190701# w_151668_188170# VSS nfet_03v3 ad=0.28p pd=1.56u as=0.28p ps=1.56u w=1u l=6u
X3763 w_145548_198022# w_146228_188170# VSS nwell r_width=2u r_length=48.78u
X3766 a_27814_125736# DAC_7__Vb VSS VSS nfet_03v3 ad=0.6p pd=3.2u as=0.6p ps=3.2u w=1u l=8u
X3787 DPI_4__Vthr DPI_4__Vthr VDD VDD pfet_03v3 ad=1.12p pd=4.56u as=1.12p ps=4.56u w=4u l=5.12u
X3790 VDD w_87818_180350# a_27655_180030# VDD pfet_03v3 ad=0.6p pd=3.2u as=0.6p ps=3.2u w=1u l=6u
X3792 VDD DPI_4__Vthr DAC_1__Isum_e DAC_1__Isum_e nfet_03v3 ad=2.4p pd=9.2u as=2.4p ps=9.2u w=4u l=5.12u
X3796 Imon bias_0__Iref VSS VSS nfet_03v3 ad=6p pd=21.2u as=6p ps=21.2u w=10u l=8u
X3797 a_21514_111548# DAC_7__Vb VSS VSS nfet_03v3 ad=0.6p pd=3.2u as=0.6p ps=3.2u w=1u l=8u
X3808 a_21514_65328# w[15] a_17910_65378# VSS nfet_03v3 ad=0.14p pd=1.06u as=0.14p ps=1.06u w=0.5u l=0.64u
X3811 VDD neuron_4__VNA neuron_4__VNA VDD pfet_03v3 ad=0.3p pd=2.2u as=0.3p ps=2.2u w=0.5u l=45.45u
X3812 VDD DPI_4__Vthr DPI_4__Vthr VDD pfet_03v3 ad=1.12p pd=4.56u as=1.12p ps=4.56u w=4u l=5.12u
X3820 VDD DPI_4__Vthr DAC_5__Isum_e DAC_5__Isum_e nfet_03v3 ad=2.4p pd=9.2u as=2.4p ps=9.2u w=4u l=5.12u
X3838 a_23614_65328# DAC_7__Vb VSS VSS nfet_03v3 ad=0.6p pd=3.2u as=0.6p ps=3.2u w=1u l=8u
X3842 a_32646_196335# VSS a_42236_196335# VDD pfet_03v3 ad=0.3p pd=2.2u as=0.3p ps=2.2u w=0.5u l=45.45u
X3847 a_17910_111598# w[27] a_21514_111548# VSS nfet_03v3 ad=0.14p pd=1.06u as=0.14p ps=1.06u w=0.5u l=0.64u
X3850 a_21514_51140# DAC_7__Vb VSS VSS nfet_03v3 ad=0.6p pd=3.2u as=0.6p ps=3.2u w=1u l=8u
X3857 trim_steer_0__Iref trim_steer_0__Iref VDD VDD pfet_03v3 ad=0.28p pd=1.56u as=0.28p ps=1.56u w=1u l=6u
X3867 a_61416_196335# VSS a_71006_196335# VDD pfet_03v3 ad=0.3p pd=2.2u as=0.3p ps=2.2u w=0.5u l=45.45u
X3872 a_21514_81344# DAC_7__Vb VSS VSS nfet_03v3 ad=0.6p pd=3.2u as=0.6p ps=3.2u w=1u l=8u
X3881 DPI_4__Vthr DPI_4__Vthr VDD VDD pfet_03v3 ad=1.12p pd=4.56u as=1.12p ps=4.56u w=4u l=5.12u
X3884 DPI_4__VT DPI_4__VT VDD VDD pfet_03v3 ad=1.12p pd=4.56u as=1.12p ps=4.56u w=4u l=5.12u
X3886 a_17910_51190# w[11] a_21514_51140# VSS nfet_03v3 ad=0.14p pd=1.06u as=0.14p ps=1.06u w=0.5u l=0.64u
X3888 w_146908_198022# w_146228_188170# VSS nwell r_width=2u r_length=48.78u
X3905 VDD a_8859_157048# neuron_4__Vamp_bias VDD pfet_03v3 ad=5.484p pd=19.48u as=5.484p ps=19.48u w=9.14u l=8u
X3914 a_21494_196237# a_8522_190701# w_151668_188170# VSS nfet_03v3 ad=0.28p pd=1.56u as=0.28p ps=1.56u w=1u l=6u
X3917 VDD bias_0__VT_inh bias_0__VT_inh VDD pfet_03v3 ad=0.2464p pd=1.44u as=0.2464p ps=1.44u w=0.88u l=1.12u
X3926 a_39323_180030# trim[3] bias_0__Iref VSS nfet_03v3 ad=0.6p pd=3.2u as=0.6p ps=3.2u w=1u l=0.5u
X3931 VDD DPI_4__VT DPI_4__VT VDD pfet_03v3 ad=2.4p pd=9.2u as=1.12p ps=4.56u w=4u l=5.12u
X3935 a_27814_14188# w[1] a_17910_14238# VSS nfet_03v3 ad=0.3p pd=2.2u as=0.14p ps=1.06u w=0.5u l=0.64u
X3944 a_23614_51140# DAC_7__Vb VSS VSS nfet_03v3 ad=0.6p pd=3.2u as=0.6p ps=3.2u w=1u l=8u
X3952 a_91134_33304# VT a_89334_33654# VSS nfet_03v3 ad=2.4p pd=9.2u as=2.4p ps=9.2u w=4u l=2u
X3965 a_36214_81344# DAC_7__Vb VSS VSS nfet_03v3 ad=0.6p pd=3.2u as=0.6p ps=3.2u w=1u l=8u
X3966 VDD w_87818_180350# a_10219_180030# VDD pfet_03v3 ad=0.28p pd=1.56u as=0.28p ps=1.56u w=1u l=6u
X3967 VMEM_0 spike[0] a_92770_15178# VSS nfet_03v3 ad=0.3p pd=2.2u as=0.3p ps=2.2u w=0.5u l=11.36u
X3975 DPI_4__Vthr DPI_4__Vthr VDD VDD pfet_03v3 ad=1.12p pd=4.56u as=1.12p ps=4.56u w=4u l=5.12u
X3976 DPI_4__VT DPI_4__VT VDD VDD pfet_03v3 ad=1.12p pd=4.56u as=1.12p ps=4.56u w=4u l=5.12u
X3979 w_148268_198022# w_147588_188170# VSS nwell r_width=2u r_length=48.78u
X4011 VDD a_89872_39970# a_89872_39970# VDD pfet_03v3 ad=0.3p pd=2.2u as=0.3p ps=2.2u w=0.5u l=8u
X4014 spike[2] a_91762_52130# a_92142_52130# VSS nfet_03v3 ad=0.3p pd=2.2u as=0.3p ps=2.2u w=0.5u l=0.64u
X4030 DAC_3__Isum_i s[4] a_18158_81394# VSS nfet_03v3 ad=0.3p pd=2.2u as=0.3p ps=2.2u w=0.5u l=0.64u
X4038 a_21514_125736# DAC_7__Vb VSS VSS nfet_03v3 ad=0.6p pd=3.2u as=0.6p ps=3.2u w=1u l=8u
X4061 a_17910_111598# w[24] a_36214_111548# VSS nfet_03v3 ad=0.3p pd=2.2u as=0.3p ps=2.2u w=0.5u l=0.64u
X4065 w_151668_188170# a_8522_190701# a_21494_196237# VSS nfet_03v3 ad=0.28p pd=1.56u as=0.28p ps=1.56u w=1u l=6u
X4071 a_21514_81344# DAC_7__Vb VSS VSS nfet_03v3 ad=0.6p pd=3.2u as=0.6p ps=3.2u w=1u l=8u
X4074 a_17910_125786# w[31] a_21514_125736# VSS nfet_03v3 ad=0.14p pd=1.06u as=0.14p ps=1.06u w=0.5u l=0.64u
X4077 w_151668_188170# a_8522_190701# a_21494_196237# VSS nfet_03v3 ad=0.28p pd=1.56u as=0.28p ps=1.56u w=1u l=6u
X4079 a_21494_196237# a_8522_190701# w_151668_188170# VSS nfet_03v3 ad=0.28p pd=1.56u as=0.28p ps=1.56u w=1u l=6u
X4092 a_8522_190701# a_8522_190701# VSS VSS nfet_03v3 ad=0.6p pd=3.2u as=0.6p ps=3.2u w=1u l=6u
X4097 a_21514_95532# DAC_7__Vb VSS VSS nfet_03v3 ad=0.6p pd=3.2u as=0.6p ps=3.2u w=1u l=8u
X4100 a_21494_196237# a_8522_190701# w_151668_188170# VSS nfet_03v3 ad=0.28p pd=1.56u as=0.28p ps=1.56u w=1u l=6u
X4104 w_148268_198022# w_148948_188170# VSS nwell r_width=2u r_length=48.78u
X4107 a_17910_51190# w[10] a_23614_51140# VSS nfet_03v3 ad=0.14p pd=1.06u as=0.3p ps=2.2u w=0.5u l=0.64u
X4113 a_21514_14188# DAC_7__Vb VSS VSS nfet_03v3 ad=0.6p pd=3.2u as=0.6p ps=3.2u w=1u l=8u
X4114 w_144188_198024# VSS VSS nwell r_width=2u r_length=48.79u
X4123 a_91514_15178# neuron_4__VIp VSS VSS nfet_03v3 ad=0.6p pd=3.2u as=0.6p ps=3.2u w=1u l=1u
X4132 a_68678_126292# a_68678_126292# DAC_1__Isum_i DAC_1__Isum_i nfet_03v3 ad=2.4p pd=9.2u as=2.4p ps=9.2u w=4u l=5.12u
X4137 VDD w_87818_180350# a_39323_180030# VDD pfet_03v3 ad=0.28p pd=1.56u as=0.28p ps=1.56u w=1u l=6u
X4144 a_23614_32664# DAC_7__Vb VSS VSS nfet_03v3 ad=0.6p pd=3.2u as=0.6p ps=3.2u w=1u l=8u
X4146 DAC_1__Isum_e a_18658_111390# a_18158_111598# VSS nfet_03v3 ad=0.3p pd=2.2u as=0.3p ps=2.2u w=0.5u l=0.64u
X4147 a_17910_51190# w[11] a_21514_51140# VSS nfet_03v3 ad=0.14p pd=1.06u as=0.14p ps=1.06u w=0.5u l=0.64u
X4155 VSS neuron_4__Vlk neuron_4__Vlk VSS nfet_03v3 ad=0.28p pd=1.56u as=0.28p ps=1.56u w=1u l=1u
X4167 a_21494_196237# a_8522_190701# w_151668_188170# VSS nfet_03v3 ad=0.28p pd=1.56u as=0.28p ps=1.56u w=1u l=6u
X4170 DPI_4__Vthr DPI_4__Vthr VDD VDD pfet_03v3 ad=1.12p pd=4.56u as=1.12p ps=4.56u w=4u l=5.12u
X4173 a_21514_111548# DAC_7__Vb VSS VSS nfet_03v3 ad=0.6p pd=3.2u as=0.6p ps=3.2u w=1u l=8u
X4199 VDD bias_0__VT_inh bias_0__VT_inh VDD pfet_03v3 ad=0.2464p pd=1.44u as=0.2464p ps=1.44u w=0.88u l=1.12u
X4202 a_36214_95532# DAC_7__Vb VSS VSS nfet_03v3 ad=0.6p pd=3.2u as=0.6p ps=3.2u w=1u l=8u
X4207 VDD DPI_4__VT a_68678_65884# VDD pfet_03v3 ad=2.4p pd=9.2u as=2.4p ps=9.2u w=4u l=5.12u
X4208 VDD bias_0__VT_inh bias_0__VT_inh VDD pfet_03v3 ad=0.2464p pd=1.44u as=0.2464p ps=1.44u w=0.88u l=1.12u
X4222 VDD a_91134_33304# a_91762_33654# VDD pfet_03v3 ad=0.3p pd=2.2u as=0.3p ps=2.2u w=0.5u l=0.64u
X4228 a_64578_120468# a_64578_120468# VSS VSS nfet_03v3 ad=1.2p pd=5.2u as=1.2p ps=5.2u w=2u l=8u
X4235 w_144188_198024# w_144868_188170# VSS nwell r_width=2u r_length=48.79u
X4236 VDD neuron_4__VNA a_95576_58446# VDD pfet_03v3 ad=0.6p pd=3.2u as=0.6p ps=3.2u w=1u l=1u
X4247 a_17910_51190# w[8] a_36214_51140# VSS nfet_03v3 ad=0.3p pd=2.2u as=0.3p ps=2.2u w=0.5u l=0.64u
X4249 VDD s[5] a_18658_95374# VDD pfet_03v3 ad=0.3p pd=2.2u as=0.3p ps=2.2u w=0.5u l=0.32u
X4251 DAC_3__Isum_i s[5] a_18158_95582# VSS nfet_03v3 ad=0.3p pd=2.2u as=0.3p ps=2.2u w=0.5u l=0.64u
X4254 spike[4] VSS cap_mim_2f0_m4m5_noshield c_width=10u c_length=10u
X4257 w_151668_188170# a_8522_190701# a_21494_196237# VSS nfet_03v3 ad=0.28p pd=1.56u as=0.28p ps=1.56u w=1u l=6u
X4279 a_33687_180030# a_42250_171366# a_38750_170674# VSS nfet_03v3 ad=0.6p pd=3.2u as=0.6p ps=3.2u w=1u l=0.5u
X4286 a_17910_125786# w[28] a_36214_125736# VSS nfet_03v3 ad=0.3p pd=2.2u as=0.3p ps=2.2u w=0.5u l=0.64u
X4288 a_17910_51190# w[11] a_21514_51140# VSS nfet_03v3 ad=0.14p pd=1.06u as=0.14p ps=1.06u w=0.5u l=0.64u
X4293 a_21514_111548# DAC_7__Vb VSS VSS nfet_03v3 ad=0.6p pd=3.2u as=0.6p ps=3.2u w=1u l=8u
X4295 a_21514_95532# DAC_7__Vb VSS VSS nfet_03v3 ad=0.6p pd=3.2u as=0.6p ps=3.2u w=1u l=8u
X4302 VDD DPI_4__VT DPI_4__VT VDD pfet_03v3 ad=1.12p pd=4.56u as=1.12p ps=4.56u w=4u l=5.12u
X4307 a_23614_81344# w[18] a_17910_81394# VSS nfet_03v3 ad=0.3p pd=2.2u as=0.14p ps=1.06u w=0.5u l=0.64u
X4308 a_33687_180030# w_87818_180350# VDD VDD pfet_03v3 ad=0.28p pd=1.56u as=0.6p ps=3.2u w=1u l=6u
X4310 a_95576_58446# a_91762_52130# VMEM_2 VDD pfet_03v3 ad=0.3p pd=2.2u as=0.3p ps=2.2u w=0.5u l=0.64u
X4328 a_9722_190909# a_8522_190701# VSS VSS nfet_03v3 ad=0.6p pd=3.2u as=0.6p ps=3.2u w=1u l=6u
X4329 a_21494_196237# a_8522_190701# w_151668_188170# VSS nfet_03v3 ad=0.28p pd=1.56u as=0.28p ps=1.56u w=1u l=6u
X4338 a_91762_82334# a_91134_81984# a_91514_82334# VSS nfet_03v3 ad=0.3p pd=2.2u as=0.3p ps=2.2u w=0.5u l=0.64u
X4343 a_90186_196335# VSS a_99776_196335# VDD pfet_03v3 ad=0.3p pd=2.2u as=0.3p ps=2.2u w=0.5u l=45.45u
X4345 a_21514_81344# w[19] a_17910_81394# VSS nfet_03v3 ad=0.14p pd=1.06u as=0.14p ps=1.06u w=0.5u l=0.64u
X4353 trim_steer_0__Iref a_8522_190701# VSS VSS nfet_03v3 ad=0.6p pd=3.2u as=0.6p ps=3.2u w=1u l=6u
X4370 VDD a_89872_58446# a_91134_51780# VDD pfet_03v3 ad=0.3p pd=2.2u as=0.3p ps=2.2u w=0.5u l=8u
X4372 DAC_1__Isum_e a_18658_125578# a_18158_125786# VSS nfet_03v3 ad=0.3p pd=2.2u as=0.3p ps=2.2u w=0.5u l=0.64u
X4385 neuron_4__VIp neuron_4__VIp VSS VSS nfet_03v3 ad=0.6p pd=3.2u as=0.6p ps=3.2u w=1u l=1u
X4398 VDD DPI_4__Vthr DPI_4__Vthr VDD pfet_03v3 ad=1.12p pd=4.56u as=1.12p ps=4.56u w=4u l=5.12u
X4401 VDD DPI_4__VT DPI_4__VT VDD pfet_03v3 ad=1.12p pd=4.56u as=1.12p ps=4.56u w=4u l=5.12u
X4402 a_91134_112188# VT a_89334_112538# VSS nfet_03v3 ad=2.4p pd=9.2u as=2.4p ps=9.2u w=4u l=2u
X4406 a_21514_125736# DAC_7__Vb VSS VSS nfet_03v3 ad=0.6p pd=3.2u as=0.6p ps=3.2u w=1u l=8u
X4411 a_21514_51140# DAC_7__Vb VSS VSS nfet_03v3 ad=0.6p pd=3.2u as=0.6p ps=3.2u w=1u l=8u
X4432 DAC_6__Isum_e a_18658_32506# a_18158_32714# VSS nfet_03v3 ad=0.3p pd=2.2u as=0.3p ps=2.2u w=0.5u l=0.64u
X4440 w_151668_188170# a_8522_190701# a_21494_196237# VSS nfet_03v3 ad=0.28p pd=1.56u as=0.28p ps=1.56u w=1u l=6u
X4444 a_17910_111598# w[25] a_27814_111548# VSS nfet_03v3 ad=0.14p pd=1.06u as=0.3p ps=2.2u w=0.5u l=0.64u
X4457 VDD w_87818_180350# VDD VDD pfet_03v3 ad=6p pd=21.2u as=0 ps=0 w=10u l=10u
X4462 a_21514_111548# DAC_7__Vb VSS VSS nfet_03v3 ad=0.6p pd=3.2u as=0.6p ps=3.2u w=1u l=8u
X4473 VDD bias_0__VT_inh bias_0__VT_inh VDD pfet_03v3 ad=0.528p pd=2.96u as=0.2464p ps=1.44u w=0.88u l=1.12u
X4484 a_21514_81344# w[19] a_17910_81394# VSS nfet_03v3 ad=0.3p pd=2.2u as=0.14p ps=1.06u w=0.5u l=0.64u
X4485 VDD bias_0__VT_inh bias_0__VT_inh VDD pfet_03v3 ad=0.2464p pd=1.44u as=0.2464p ps=1.44u w=0.88u l=1.12u
X4495 a_94948_21494# a_91762_15178# spike[0] VDD pfet_03v3 ad=0.3p pd=2.2u as=0.3p ps=2.2u w=0.5u l=0.64u
X4498 a_21494_196237# a_8522_190701# w_151668_188170# VSS nfet_03v3 ad=0.28p pd=1.56u as=0.28p ps=1.56u w=1u l=6u
X4501 VDD DPI_4__Vthr DAC_3__Isum_i DAC_3__Isum_i nfet_03v3 ad=2.4p pd=9.2u as=2.4p ps=9.2u w=4u l=5.12u
X4504 a_21514_65328# DAC_7__Vb VSS VSS nfet_03v3 ad=0.6p pd=3.2u as=0.6p ps=3.2u w=1u l=8u
X4516 a_23614_51140# DAC_7__Vb VSS VSS nfet_03v3 ad=0.6p pd=3.2u as=0.6p ps=3.2u w=1u l=8u
X4523 a_21514_125736# DAC_7__Vb VSS VSS nfet_03v3 ad=0.6p pd=3.2u as=0.6p ps=3.2u w=1u l=8u
X4532 a_23614_95532# w[22] a_17910_95582# VSS nfet_03v3 ad=0.3p pd=2.2u as=0.14p ps=1.06u w=0.5u l=0.64u
X4536 a_17910_51190# w[11] a_21514_51140# VSS nfet_03v3 ad=0.14p pd=1.06u as=0.3p ps=2.2u w=0.5u l=0.64u
X4537 a_27814_81344# DAC_7__Vb VSS VSS nfet_03v3 ad=0.6p pd=3.2u as=0.6p ps=3.2u w=1u l=8u
X4545 w_150988_198022# w_151668_188170# VSS nwell r_width=2u r_length=48.78u
X4547 spike[4] a_91762_112538# a_92142_112538# VSS nfet_03v3 ad=0.3p pd=2.2u as=0.3p ps=2.2u w=0.5u l=0.64u
X4553 a_23614_111548# DAC_7__Vb VSS VSS nfet_03v3 ad=0.6p pd=3.2u as=0.6p ps=3.2u w=1u l=8u
X4557 a_23614_14188# DAC_7__Vb VSS VSS nfet_03v3 ad=0.6p pd=3.2u as=0.6p ps=3.2u w=1u l=8u
X4560 a_21514_95532# w[23] a_17910_95582# VSS nfet_03v3 ad=0.14p pd=1.06u as=0.14p ps=1.06u w=0.5u l=0.64u
X4565 a_18658_81186# s[4] VSS VSS nfet_03v3 ad=0.3p pd=2.2u as=0.3p ps=2.2u w=0.5u l=0.64u
X4569 a_68678_65884# a_68678_65884# DAC_5__Isum_i DAC_5__Isum_i nfet_03v3 ad=2.4p pd=9.2u as=2.4p ps=9.2u w=4u l=5.12u
X4584 DPI_4__Vthr DPI_4__Vthr VDD VDD pfet_03v3 ad=1.12p pd=4.56u as=1.12p ps=4.56u w=4u l=5.12u
X4594 a_92770_82334# neuron_4__VK VSS VSS nfet_03v3 ad=0.6p pd=3.2u as=0.6p ps=3.2u w=1u l=1u
X4598 a_17910_65378# w[13] a_27814_65328# VSS nfet_03v3 ad=0.14p pd=1.06u as=0.3p ps=2.2u w=0.5u l=0.64u
X4618 a_27814_32664# w[5] a_17910_32714# VSS nfet_03v3 ad=0.3p pd=2.2u as=0.14p ps=1.06u w=0.5u l=0.64u
X4619 a_21514_81344# DAC_7__Vb VSS VSS nfet_03v3 ad=0.6p pd=3.2u as=0.6p ps=3.2u w=1u l=8u
X4622 trim_steer_0__Iref a_8522_190701# VSS VSS nfet_03v3 ad=0.6p pd=3.2u as=0.6p ps=3.2u w=1u l=6u
X4648 VMEM_1 spike[1] a_92770_33654# VSS nfet_03v3 ad=0.3p pd=2.2u as=0.3p ps=2.2u w=0.5u l=11.36u
X4649 a_9722_190909# a_8522_190701# VSS VSS nfet_03v3 ad=0.6p pd=3.2u as=0.6p ps=3.2u w=1u l=6u
X4650 a_21494_196237# a_8522_190701# w_151668_188170# VSS nfet_03v3 ad=0.28p pd=1.56u as=0.28p ps=1.56u w=1u l=6u
X4655 a_17910_125786# w[29] a_27814_125736# VSS nfet_03v3 ad=0.14p pd=1.06u as=0.3p ps=2.2u w=0.5u l=0.64u
X4665 DPI_4__Vthr DPI_4__Vthr VDD VDD pfet_03v3 ad=1.12p pd=4.56u as=2.4p ps=9.2u w=4u l=5.12u
X4667 a_21514_125736# DAC_7__Vb VSS VSS nfet_03v3 ad=0.6p pd=3.2u as=0.6p ps=3.2u w=1u l=8u
X4681 a_23614_81344# w[18] a_17910_81394# VSS nfet_03v3 ad=0.14p pd=1.06u as=0.14p ps=1.06u w=0.5u l=0.64u
X4692 neuron_4__Vamp_bias neuron_4__Vamp_bias VSS VSS nfet_03v3 ad=0.3p pd=2.2u as=0.3p ps=2.2u w=0.5u l=0.64u
X4693 a_21514_95532# w[23] a_17910_95582# VSS nfet_03v3 ad=0.3p pd=2.2u as=0.14p ps=1.06u w=0.5u l=0.64u
X4702 DAC_7__Vb DAC_7__Vb VSS VSS nfet_03v3 ad=0.6p pd=3.2u as=0.6p ps=3.2u w=1u l=8u
X4705 VDD s[3] a_18658_65170# VDD pfet_03v3 ad=0.3p pd=2.2u as=0.3p ps=2.2u w=0.5u l=0.32u
X4718 a_94948_118854# a_91762_112538# spike[4] VDD pfet_03v3 ad=0.3p pd=2.2u as=0.3p ps=2.2u w=0.5u l=0.64u
X4725 a_89872_88650# VMEM_3 a_89334_82334# VSS nfet_03v3 ad=2.4p pd=9.2u as=2.4p ps=9.2u w=4u l=2u
X4737 spike[1] VSS cap_mim_2f0_m4m5_noshield c_width=10u c_length=10u
X4738 a_27814_95532# DAC_7__Vb VSS VSS nfet_03v3 ad=0.6p pd=3.2u as=0.6p ps=3.2u w=1u l=8u
X4739 VDD VSS a_32646_196335# VDD pfet_03v3 ad=0.3p pd=2.2u as=0.3p ps=2.2u w=0.5u l=45.45u
X4745 VDD s[0] a_18158_14238# VSS nfet_03v3 ad=0.3p pd=2.2u as=0.3p ps=2.2u w=0.5u l=0.64u
X4749 a_27814_14188# DAC_7__Vb VSS VSS nfet_03v3 ad=0.6p pd=3.2u as=0.6p ps=3.2u w=1u l=8u
X4757 a_23614_125736# DAC_7__Vb VSS VSS nfet_03v3 ad=0.6p pd=3.2u as=0.6p ps=3.2u w=1u l=8u
X4764 a_51826_196335# VSS a_61416_196335# VDD pfet_03v3 ad=0.3p pd=2.2u as=0.3p ps=2.2u w=0.5u l=45.45u
X4767 a_18658_95374# s[5] VSS VSS nfet_03v3 ad=0.3p pd=2.2u as=0.3p ps=2.2u w=0.5u l=0.64u
X4768 a_21514_32664# DAC_7__Vb VSS VSS nfet_03v3 ad=0.6p pd=3.2u as=0.6p ps=3.2u w=1u l=8u
X4776 a_91514_33654# neuron_4__VIp VSS VSS nfet_03v3 ad=0.6p pd=3.2u as=0.6p ps=3.2u w=1u l=1u
X4785 a_80596_196335# VSS a_90186_196335# VDD pfet_03v3 ad=0.3p pd=2.2u as=0.3p ps=2.2u w=0.5u l=45.45u
X4791 a_39250_171366# trim[0] VSS VSS nfet_03v3 ad=0.375p pd=2.5u as=0.375p ps=2.5u w=0.5u l=0.28u
X4792 VDD DPI_4__Vthr DPI_4__Vthr VDD pfet_03v3 ad=1.12p pd=4.56u as=1.12p ps=4.56u w=4u l=5.12u
X4795 a_95576_39970# a_91762_33654# VMEM_1 VDD pfet_03v3 ad=0.3p pd=2.2u as=0.3p ps=2.2u w=0.5u l=0.64u
X4811 a_27655_180030# trim[0] bias_0__Iref VSS nfet_03v3 ad=0.6p pd=3.2u as=0.6p ps=3.2u w=1u l=0.5u
X4814 a_94948_88650# a_91762_82334# spike[3] VDD pfet_03v3 ad=0.3p pd=2.2u as=0.3p ps=2.2u w=0.5u l=0.64u
X4820 VDD DPI_4__VT a_64128_83960# VDD pfet_03v3 ad=2.4p pd=9.2u as=2.4p ps=9.2u w=4u l=5.12u
X4821 a_21514_95532# DAC_7__Vb VSS VSS nfet_03v3 ad=0.6p pd=3.2u as=0.6p ps=3.2u w=1u l=8u
X4831 a_89334_82334# neuron_4__Vamp_bias VSS VSS nfet_03v3 ad=0.3p pd=2.2u as=0.3p ps=2.2u w=0.5u l=0.64u
C0 a_46000_171624# a_33687_180030# 0.06278f
C1 a_17910_81394# DAC_3__Isum_i 1.77847f
C2 pulse[1] w[2] 0.67187f
C3 a_27655_180030# trim[0] 0.02417f
C4 pulse[1] w[25] 0.13844f
C5 a_64128_114164# a_68678_126292# 0.15017f
C6 w[8] w[1] 1.19746f
C7 w[12] a_17910_65378# 0.01848f
C8 w[29] s[5] 0.38731f
C9 w[24] spike[2] 0.11972f
C10 a_92142_112538# a_92770_112538# 1.47502f
C11 w[24] w[14] 0.30921f
C12 trim[2] trim[0] 0.44932f
C13 VDD Imon 0.17779f
C14 trim[1] trim[2] 60.7415f
C15 DAC_1__Isum_e a_18158_111598# 2.10366f
C16 a_42250_171366# a_39850_171366# 37.3453f
C17 a_92142_33654# spike[1] 1.35619f
C18 neuron_4__VK neuron_4__VNA 2.4779f
C19 s[2] s[0] 0.02641f
C20 VDD a_72340_144600# 0.32513f
C21 w[3] s[0] 0.38695f
C22 w[10] w[7] 0.36579f
C23 w[4] w[2] 1.50148f
C24 a_89334_112538# neuron_4__Vamp_bias 0.05117f
C25 neuron_4__VK a_92770_112538# 0.04013f
C26 w[11] s[6] 0.09497f
C27 w[4] w[25] 5.15778f
C28 VMEM_4 neuron_4__VKdn 0.6726f
C29 spike[0] spike[1] 21.032f
C30 a_64128_114164# DPI_4__Vthr 1.25274f
C31 DAC_1__Isum_i a_18158_125786# 1.32914f
C32 trim[3] cal 29.4145f
C33 spike[0] DAC_7__Vb 0.54414f
C34 s[2] w[31] 0.23439f
C35 s[6] w[6] 0.04513f
C36 a_36214_14188# a_27814_14188# 7.01128f
C37 VDD trim[3] 1.39157f
C38 w[13] w[24] 3.88127f
C39 a_36214_65328# DAC_7__Vb 0.093f
C40 w[20] a_36214_95532# 0.04246f
C41 w[11] w[5] 0.10269f
C42 DAC_7__Vb a_27814_125736# 0.18591f
C43 w[15] cal 0.16226f
C44 w[12] w[28] 0.1168f
C45 VDD w[15] 0.71153f
C46 w[5] w[6] 10.9218f
C47 a_37150_170466# trim[0] 0.48451f
C48 a_38750_170674# a_39323_180030# 1.63848f
C49 trim[1] a_37150_170466# 0.23368f
C50 a_89334_82334# VT 0.26497f
C51 s[7] w[26] 44.2598f
C52 w[20] w[25] 0.1498f
C53 spike[2] spike[4] 2.22178f
C54 DAC_5__Isum_i a_18658_65170# 0.05814f
C55 a_33687_180030# VDD 5.28051f
C56 neuron_4__VK neuron_4__Vamp_bias 21.6136f
C57 a_91134_33304# a_91514_33654# 0.60758f
C58 a_91514_82334# neuron_4__VIp 0.04013f
C59 w[19] a_17910_81394# 0.364f
C60 a_27814_95532# a_21514_95532# 0.27118f
C61 trim[1] w[21] 0.14442f
C62 w[31] w[14] 6.1891f
C63 w[24] s[3] 0.10805f
C64 a_21514_14188# DAC_7__Vb 0.74342f
C65 w[21] trim[0] 0.12516f
C66 VDD VT 4.14789f
C67 w[3] pulse[0] 0.07426f
C68 s[2] w[29] 0.26577f
C69 neuron_4__Vlk trim[0] 0.19781f
C70 pulse[1] w[5] 2.56272f
C71 w[13] s[0] 0.02452f
C72 trim[1] neuron_4__Vlk 0.03469f
C73 a_8859_157048# neuron_4__VIp 0.35235f
C74 w[15] w[27] 0.14487f
C75 a_36214_14188# a_23614_14188# 0.11882f
C76 w[30] a_23614_125736# 0.25032f
C77 w[4] s[6] 0.04727f
C78 w[11] w[28] 6.79287f
C79 a_9722_190909# a_8522_190701# 43.3654f
C80 a_17910_111598# DAC_1__Isum_e 0.07931f
C81 DPI_4__VT neuron_4__VNA 43.4376f
C82 trim[3] s[5] 0.16426f
C83 w[13] w[31] 0.12878f
C84 a_33687_180030# a_39850_171366# 0.06314f
C85 w[28] w[6] 0.12539f
C86 w[22] w[2] 0.28537f
C87 w[4] w[5] 7.453f
C88 w[12] cal 0.14049f
C89 w[15] s[5] 0.05686f
C90 a_17910_111598# a_23614_111548# 15.0391f
C91 a_38750_170674# a_27655_180030# 2.44912f
C92 VDD w[12] 0.14874f
C93 a_91134_33304# a_89334_33654# 0.9311f
C94 w[17] w[22] 0.12288f
C95 trim[2] w[26] 0.15031f
C96 s[4] w[25] 0.24164f
C97 w[14] w[29] 2.08016f
C98 s[4] w[2] 0.0412f
C99 VDD a_92770_52130# 0.17724f
C100 w[20] s[6] 38.2302f
C101 VDD a_89872_118854# 10.7102f
C102 a_23614_95532# a_21514_95532# 0.57119f
C103 a_46000_171624# a_10219_180030# 0.06259f
C104 spike[2] DPI_4__Vthr 0.1846f
C105 VMEM_1 neuron_4__VKup 0.07415f
C106 s[3] s[0] 0.17976f
C107 VMEM_1 a_89872_39970# 1.71072f
C108 a_21514_51140# DAC_7__Vb 0.74342f
C109 VMEM_3 neuron_4__VNA 0.51029f
C110 pulse[1] w[28] 0.86889f
C111 VDD neuron_4__VIp 33.4005f
C112 DAC_5__Isum_e spike[1] 0.06456f
C113 w[17] s[4] 3.70397f
C114 neuron_4__Vamp_bias DPI_4__VT 0.23798f
C115 DAC_7__Vb DAC_1__Isum_i 0.07446f
C116 w[24] s[7] 0.04984f
C117 w[13] w[29] 0.15164f
C118 a_89334_15178# VT 0.26497f
C119 a_39323_180030# a_42850_171366# 1.04612f
C120 w[31] w[30] 23.1985f
C121 spike[3] spike[2] 12.3136f
C122 w[31] s[3] 0.10291f
C123 a_23614_95532# a_27814_95532# 0.29412f
C124 a_91514_15178# neuron_4__VIp 0.04013f
C125 w[8] DAC_7__Vb 7.72509f
C126 DAC_3__Isum_i DPI_4__Vthr 2.8953f
C127 neuron_4__VNA spike[1] 0.0487f
C128 a_18658_111390# a_18158_111598# 0.11824f
C129 w[12] w[27] 0.0993f
C130 a_38750_170674# a_37150_170466# 2.5098f
C131 DAC_7__Vb neuron_4__VNA 0.17425f
C132 a_21514_65328# a_36214_65328# 0.16484f
C133 VDD w[11] 0.47281f
C134 a_46000_171624# w_87818_180350# 19.1899f
C135 cal w[6] 5.07929f
C136 w_146908_198022# w_145548_198022# 0.0125f
C137 w[22] s[6] 0.07587f
C138 VDD w[6] 0.44847f
C139 w[16] w[25] 0.11579f
C140 trim_steer_0__Iref trim[0] 0.17422f
C141 trim[1] trim_steer_0__Iref 0.15646f
C142 neuron_4__VK DPI_4__VT 0.2099f
C143 w[12] s[5] 0.50924f
C144 w[15] w[23] 0.15728f
C145 s[2] w[15] 3.48905f
C146 VDD a_92142_52130# 0.15438f
C147 w[15] w[3] 0.26332f
C148 a_91762_82334# neuron_4__VNA 0.40621f
C149 VMEM_3 neuron_4__Vamp_bias 1.55407f
C150 VMEM_4 DAC_1__Isum_e 0.0248f
C151 VMEM_1 a_91762_33654# 0.29575f
C152 w[17] w[16] 43.348f
C153 w[22] w[5] 0.11941f
C154 a_17910_95582# DAC_3__Isum_e 0.07931f
C155 a_94948_39970# neuron_4__VKup 0.04013f
C156 w[9] w[2] 1.33536f
C157 VDD a_10219_180030# 14.8704f
C158 w[9] w[25] 1.14417f
C159 s[3] pulse[0] 0.37945f
C160 w[20] w[28] 0.13245f
C161 w[30] w[29] 30.0151f
C162 w[21] w[26] 0.12989f
C163 s[3] w[29] 0.10805f
C164 VDD a_27814_51140# 0.26038f
C165 neuron_4__Vamp_bias spike[1] 0.15325f
C166 neuron_4__Vamp_bias DAC_7__Vb 31.778f
C167 a_95576_88650# neuron_4__VNA 0.04168f
C168 a_68678_65884# DPI_4__VT 1.91824f
C169 s[4] w[5] 0.07102f
C170 pulse[1] cal 1.67159f
C171 a_27655_180030# a_42850_171366# 0.76103f
C172 VDD pulse[1] 0.44775f
C173 w[11] w[27] 6.913f
C174 VDD a_64128_16804# 11.5871f
C175 spike[3] w[30] 0.08662f
C176 w[31] s[7] 0.42302f
C177 trim[3] w[14] 0.19191f
C178 a_21514_95532# DAC_7__Vb 0.74342f
C179 w[27] w[6] 0.16853f
C180 trim[2] a_42850_171366# 0.05969f
C181 neuron_4__VK VMEM_3 0.25719f
C182 a_17910_111598# a_36214_111548# 1.31469f
C183 w_87818_180350# cal 3.72848f
C184 neuron_4__Vlk bias_0__VT_inh 0.16189f
C185 s[1] a_18158_32714# 0.04246f
C186 w[15] w[14] 9.18819f
C187 VDD w_87818_180350# 78.26939f
C188 a_91762_82334# neuron_4__Vamp_bias 0.10343f
C189 w[11] s[5] 0.055f
C190 DAC_7__Vb w[1] 1.40818f
C191 a_42236_196335# a_9722_190909# 0.2204f
C192 VDD w[4] 0.78385f
C193 a_17910_111598# a_27814_111548# 1.78781f
C194 a_10219_180030# a_39850_171366# 0.06277f
C195 a_64128_53756# DPI_4__Vthr 1.2631f
C196 a_21514_32664# w[7] 0.56837f
C197 a_27814_95532# DAC_7__Vb 0.18591f
C198 a_32646_196335# a_21494_196237# 0.22061f
C199 a_18658_32506# a_21514_32664# 0.11443f
C200 neuron_4__VK spike[1] 0.14841f
C201 a_18658_95374# DAC_3__Isum_e 14.2174f
C202 w[13] trim[3] 9.73976f
C203 w[16] s[6] 4.84567f
C204 neuron_4__VK DAC_7__Vb 0.23342f
C205 s[5] w[6] 0.03406f
C206 a_94948_39970# a_91762_33654# 0.37248f
C207 s[4] a_18158_81394# 0.04246f
C208 a_17910_111598# a_18658_111390# 0.10497f
C209 a_46000_171624# bias_0__Iref 0.86107f
C210 s[1] w[2] 0.32032f
C211 w[12] w[23] 0.12177f
C212 s[1] w[25] 0.67013f
C213 a_89872_39970# a_91514_33654# 0.09468f
C214 w[13] w[15] 2.66067f
C215 s[2] w[12] 0.09295f
C216 VDD a_23614_51140# 0.42217f
C217 a_17910_32714# a_21514_32664# 17.2602f
C218 a_91134_81984# neuron_4__VKup 0.14179f
C219 a_8859_157048# bias_0__Iref 5.20475f
C220 w[0] s[0] 1.95564f
C221 w[27] pulse[1] 0.15465f
C222 a_37150_170466# a_42850_171366# 18.7648f
C223 w[9] s[6] 0.04444f
C224 VMEM_1 a_95576_39970# 0.93986f
C225 a_27814_32664# a_18658_32506# 0.06004f
C226 s[7] w[29] 0.43859f
C227 s[4] w[28] 0.1288f
C228 w[20] cal 0.14311f
C229 spike[2] VT 0.88316f
C230 VDD w[20] 0.15949f
C231 a_18158_95582# spike[1] 0.01869f
C232 a_68678_65884# spike[1] 0.13998f
C233 w[8] trim[0] 1.4843f
C234 a_80596_196335# VDD 5.14691f
C235 trim[1] w[8] 3.31096f
C236 a_27814_32664# a_17910_32714# 1.78781f
C237 w[9] w[5] 0.09603f
C238 w_87818_180350# a_39850_171366# 0.05906f
C239 VMEM_1 a_64128_35280# 4.23801f
C240 pulse[1] s[5] 0.06309f
C241 VDD a_91134_33304# 6.10144f
C242 w[4] w[27] 0.09239f
C243 a_42250_171366# a_39323_180030# 0.13297f
C244 a_18658_81186# DAC_7__Vb 0.02934f
C245 w[24] w[21] 0.31403f
C246 spike[3] s[7] 1.09786f
C247 trim[3] s[3] 0.10151f
C248 VMEM_1 neuron_4__VKdn 0.40598f
C249 a_23614_95532# DAC_7__Vb 0.37182f
C250 a_18658_32506# a_18158_32714# 0.11824f
C251 VDD a_21514_111548# 0.75723f
C252 DAC_5__Isum_i a_17910_65378# 1.77847f
C253 w[15] w[30] 0.14825f
C254 w[12] w[14] 1.50574f
C255 w[15] s[3] 0.35946f
C256 VMEM_3 DPI_4__VT 0.47099f
C257 w[11] w[23] 0.2829f
C258 a_91762_33654# a_91514_33654# 1.31172f
C259 w[4] s[5] 0.0532f
C260 s[2] w[11] 0.62226f
C261 bias_0__Iref cal 0.66171f
C262 w[11] w[3] 0.26727f
C263 VMEM_4 a_95576_118854# 0.93986f
C264 a_89872_88650# neuron_4__VKup 3.23913f
C265 VDD bias_0__Iref 6.28165f
C266 a_17910_32714# a_18158_32714# 1.6884f
C267 a_89872_39970# a_89334_33654# 2.33814f
C268 w[23] w[6] 0.38836f
C269 a_36214_95532# DAC_3__Isum_e 6.81042f
C270 a_92770_52130# spike[2] 1.13486f
C271 w[16] w[28] 0.11732f
C272 s[2] w[6] 1.18705f
C273 w[20] w[27] 0.12888f
C274 VDD w[22] 3.61708f
C275 DAC_7__Isum_e DPI_4__Vthr 2.8953f
C276 w[3] w[6] 0.20316f
C277 w[2] w[7] 0.10888f
C278 pulse[0] w[0] 0.25613f
C279 a_94948_39970# a_95576_39970# 0.53841f
C280 a_23614_32664# a_18658_32506# 0.05882f
C281 s[1] s[6] 0.2704f
C282 w[25] w[7] 1.80057f
C283 DPI_4__VT spike[1] 1.1468f
C284 a_17910_81394# spike[0] 0.04246f
C285 VDD a_91762_52130# 3.95892f
C286 w[19] w[15] 0.55166f
C287 w[13] w[12] 9.32974f
C288 VMEM_3 a_64578_90264# 0.20517f
C289 a_18658_81186# a_27814_81344# 0.06004f
C290 DAC_7__Vb DPI_4__VT 0.4953f
C291 neuron_4__Vamp_bias trim[0] 0.03054f
C292 spike[2] neuron_4__VIp 0.17071f
C293 VDD a_94948_118854# 2.79898f
C294 s[6] a_18158_111598# 0.04246f
C295 w_145548_198022# w_144188_198024# 0.01236f
C296 w[9] w[28] 0.78198f
C297 a_23614_65328# a_27814_65328# 0.29412f
C298 a_23614_32664# a_17910_32714# 15.0391f
C299 s[1] w[5] 3.4338f
C300 DAC_5__Isum_e a_18158_65378# 2.10366f
C301 w[20] s[5] 15.5547f
C302 w[17] w[7] 0.22142f
C303 VDD a_18658_50982# 8.84723f
C304 s[4] cal 0.1412f
C305 VMEM_3 a_94948_88650# 0.12888f
C306 VDD s[4] 1.70602f
C307 spike[4] neuron_4__Vlk 1.91288f
C308 a_36214_14188# DAC_7__Isum_e 6.81042f
C309 w[27] a_21514_111548# 0.56837f
C310 a_17910_111598# w[25] 0.10002f
C311 a_39250_171366# trim[0] 0.10914f
C312 trim[0] w[1] 0.02209f
C313 a_42250_171366# a_27655_180030# 0.06445f
C314 pulse[1] w[23] 0.14873f
C315 neuron_4__VK a_92770_82334# 0.04013f
C316 a_36214_14188# w[0] 0.04246f
C317 trim[3] a_39323_180030# 0.02417f
C318 s[2] pulse[1] 1.00781f
C319 w[11] w[14] 1.22579f
C320 bias_0__Iref a_39850_171366# 0.11794f
C321 w[18] w[25] 0.13114f
C322 w[24] spike[0] 0.15422f
C323 trim[3] s[7] 0.54145f
C324 pulse[1] w[3] 1.77693f
C325 w[31] w[21] 0.14266f
C326 a_42250_171366# trim[2] 0.09878f
C327 w[14] w[6] 0.11527f
C328 w[12] w[30] 0.12555f
C329 w[12] s[3] 25.3815f
C330 a_92142_52130# spike[2] 1.35619f
C331 w[15] s[7] 0.05447f
C332 w[17] w[18] 39.3109f
C333 w[4] w[23] 1.01655f
C334 s[2] w[4] 0.41899f
C335 w[13] w[11] 2.05807f
C336 a_33687_180030# a_39323_180030# 0.11194f
C337 w[4] w[3] 1.70694f
C338 a_36214_32664# a_21514_32664# 0.16484f
C339 w[16] cal 0.12991f
C340 a_23614_125736# a_27814_125736# 0.29412f
C341 w[22] s[5] 0.40195f
C342 a_91762_82334# a_94948_88650# 0.37248f
C343 a_18658_81186# a_23614_81344# 0.05882f
C344 s[4] w[27] 0.10896f
C345 DAC_7__Vb spike[1] 3.84872f
C346 w[13] w[6] 0.1183f
C347 VDD w[16] 0.15315f
C348 s[6] w[7] 1.16698f
C349 VMEM_3 a_91762_82334# 0.29575f
C350 VDD a_64578_60060# 4.6034f
C351 w[8] w[26] 0.25904f
C352 w[19] w[12] 1.38429f
C353 trim_steer_0__Iref a_42850_171366# 0.07041f
C354 a_91514_112538# a_91762_112538# 1.31172f
C355 w[14] pulse[1] 0.59841f
C356 a_42250_171366# a_37150_170466# 0.1723f
C357 a_27814_32664# a_36214_32664# 7.01128f
C358 w[9] VDD 0.15816f
C359 w[7] w[5] 3.30473f
C360 w[9] cal 9.47807f
C361 s[4] s[5] 0.46395f
C362 spike[0] spike[4] 2.70211f
C363 w[20] w[23] 0.22754f
C364 w[21] w[29] 0.13691f
C365 a_36214_81344# a_18658_81186# 0.75055f
C366 a_89334_52130# VT 0.26497f
C367 a_95576_88650# a_94948_88650# 0.53841f
C368 s[2] w[20] 2.19506f
C369 VDD DAC_5__Isum_i 15.1813f
C370 a_91762_112538# neuron_4__VNA 0.40566f
C371 a_8522_190701# w_151668_188170# 20.3882f
C372 VMEM_3 a_95576_88650# 0.93986f
C373 a_27814_65328# a_18658_65170# 0.06004f
C374 neuron_4__Vlk DPI_4__Vthr 0.47469f
C375 bias_0__VT_inh neuron_4__VNA 0.41082f
C376 a_17910_32714# w[5] 0.10002f
C377 w[11] s[3] 0.03061f
C378 w_150988_198022# w_149628_198022# 0.0125f
C379 w[4] w[14] 0.28181f
C380 w[15] w[0] 0.23696f
C381 w[13] pulse[1] 0.42066f
C382 w[11] w[30] 9.7137f
C383 a_8859_157048# neuron_4__VKup 0.15253f
C384 w[18] s[6] 0.10553f
C385 a_42236_196335# a_51826_196335# 4.1415f
C386 a_64578_120468# DAC_1__Isum_i 0.16419f
C387 a_27814_81344# DAC_7__Vb 0.18591f
C388 trim[3] trim[2] 60.5532f
C389 w[30] w[6] 0.11813f
C390 w[27] w[16] 0.09982f
C391 s[3] w[6] 0.05579f
C392 a_36214_125736# a_27814_125736# 7.01128f
C393 spike[3] neuron_4__Vlk 1.98652f
C394 VDD a_8522_190701# 28.7081f
C395 VMEM_2 DPI_4__Vthr 2.63596f
C396 w[15] trim[2] 10.7847f
C397 w[12] s[7] 0.06497f
C398 a_33687_180030# a_27655_180030# 0.92644f
C399 w[13] w[4] 0.53133f
C400 w[19] w[11] 0.28349f
C401 neuron_4__Vlk a_91134_112188# 0.02432f
C402 w[9] w[27] 0.79911f
C403 a_33687_180030# trim[2] 0.02417f
C404 w[22] w[23] 22.9965f
C405 w[19] w[6] 0.23734f
C406 a_18158_81394# DAC_3__Isum_e 2.10366f
C407 w[16] s[5] 0.0518f
C408 s[2] w[22] 2.97606f
C409 w[20] w[14] 0.2001f
C410 DAC_1__Isum_e a_36214_111548# 6.81042f
C411 neuron_4__Vamp_bias a_91762_112538# 0.06057f
C412 a_23614_32664# a_36214_32664# 0.11882f
C413 w[22] w[3] 0.10672f
C414 w[28] w[7] 1.9507f
C415 a_95576_88650# a_91762_82334# 0.04621f
C416 VDD s[1] 2.7842f
C417 trim[3] a_37150_170466# 21.8009f
C418 neuron_4__Vamp_bias bias_0__VT_inh 10.3612f
C419 a_38750_170674# a_39250_171366# 0.09093f
C420 a_27814_111548# DAC_1__Isum_e 2.06134f
C421 w[30] pulse[1] 1.47656f
C422 s[3] pulse[1] 0.22188f
C423 a_23614_65328# a_18658_65170# 0.05882f
C424 a_23614_111548# a_36214_111548# 0.11882f
C425 w[9] s[5] 0.03389f
C426 a_18658_111390# DAC_1__Isum_e 14.2174f
C427 VDD neuron_4__VKup 15.9262f
C428 s[2] a_18658_50982# 3.46922f
C429 VDD a_89872_39970# 10.7115f
C430 a_92142_112538# a_91762_112538# 0.67211f
C431 VMEM_3 a_92770_82334# 3.31883f
C432 VDD a_18158_111598# 0.21115f
C433 s[4] w[23] 0.12852f
C434 s[2] s[4] 0.1506f
C435 w[13] w[20] 0.15377f
C436 Imon neuron_4__Vlk 4.06653f
C437 spike[0] DPI_4__Vthr 1.76416f
C438 VMEM_0 DPI_4__Vthr 0.06828f
C439 a_23614_81344# DAC_7__Vb 0.37182f
C440 w[8] w[24] 0.25633f
C441 s[4] w[3] 1.08106f
C442 a_27814_111548# a_23614_111548# 0.29412f
C443 w[29] a_27814_125736# 0.08445f
C444 a_23614_125736# DAC_1__Isum_i 12.8867f
C445 a_33687_180030# a_37150_170466# 3.01279f
C446 a_91134_51780# VT 0.51489f
C447 w[11] s[7] 0.05288f
C448 neuron_4__VK a_91762_112538# 0.10668f
C449 a_23614_111548# a_18658_111390# 0.05882f
C450 w_148268_198022# w_149628_198022# 0.0125f
C451 w[19] pulse[1] 1.67965f
C452 w[4] s[3] 0.03975f
C453 w[18] w[28] 0.13201f
C454 s[7] w[6] 0.36509f
C455 trim[3] w[21] 0.14744f
C456 spike[3] spike[0] 0.08394f
C457 w[14] w[22] 2.41187f
C458 neuron_4__VK bias_0__VT_inh 0.15054f
C459 trim[3] neuron_4__Vlk 0.03703f
C460 DAC_7__Vb trim[0] 0.04311f
C461 a_36214_81344# DAC_7__Vb 0.093f
C462 a_91762_52130# spike[2] 9.68412f
C463 w[12] trim[2] 0.1199f
C464 s[1] w[27] 0.53692f
C465 w[19] w[4] 2.88089f
C466 a_18158_14238# s[0] 0.04246f
C467 a_21514_65328# DAC_7__Vb 0.74342f
C468 w[16] w[23] 0.12552f
C469 a_23614_81344# a_27814_81344# 0.29412f
C470 a_91514_112538# spike[4] 0.04786f
C471 s[4] w[14] 0.069f
C472 w[20] w[30] 0.24795f
C473 w[13] w[22] 0.29026f
C474 s[2] w[16] 0.09771f
C475 w[20] s[3] 0.10548f
C476 VDD a_91762_33654# 3.9586f
C477 a_17910_51190# w[11] 0.364f
C478 s[1] s[5] 0.45432f
C479 cal w[7] 0.12354f
C480 VDD w[7] 0.23921f
C481 VDD a_18658_32506# 8.90537f
C482 a_42250_171366# trim_steer_0__Iref 0.07322f
C483 VMEM_3 a_92142_82334# 0.25888f
C484 w[10] w[2] 0.1909f
C485 w[10] w[25] 0.12344f
C486 a_36214_125736# DAC_1__Isum_i 0.11679f
C487 a_18658_14030# a_17910_14238# 0.10497f
C488 s[7] pulse[1] 0.16351f
C489 w[9] w[23] 0.14105f
C490 w[9] s[2] 1.18464f
C491 a_36214_51140# a_27814_51140# 7.01128f
C492 a_92770_112538# spike[4] 1.13486f
C493 VDD DAC_3__Isum_e 21.6716f
C494 a_36214_81344# a_27814_81344# 7.01128f
C495 VDD a_17910_32714# 2.32564f
C496 w[9] w[3] 1.41217f
C497 s[4] DAC_3__Isum_i 0.01848f
C498 s[2] DAC_5__Isum_i 0.01848f
C499 w[19] w[20] 0.57755f
C500 w[11] w[0] 1.66517f
C501 w[13] s[4] 0.06658f
C502 w_87818_180350# a_39323_180030# 1.01044f
C503 VT neuron_4__Vlk 1.82782f
C504 w[8] w[31] 0.22541f
C505 a_36214_14188# a_21514_14188# 0.16484f
C506 w[0] w[6] 0.10364f
C507 a_17910_51190# a_27814_51140# 1.78781f
C508 w[24] w[1] 0.28529f
C509 w[4] s[7] 0.38815f
C510 VDD a_17910_111598# 0.54717f
C511 a_39250_171366# a_42850_171366# 0.12537f
C512 VDD a_94948_58446# 2.79898f
C513 w[18] cal 0.14459f
C514 VDD w[18] 0.15887f
C515 VMEM_2 VT 1.99848f
C516 DAC_1__Isum_i a_68678_126292# 6.16698f
C517 a_18158_65378# spike[1] 0.01869f
C518 s[3] w[22] 0.11166f
C519 w[14] w[16] 4.41802f
C520 a_18158_14238# pulse[0] 0.01869f
C521 w[27] w[7] 3.04469f
C522 w[12] w[21] 24.6891f
C523 a_17910_81394# a_18658_81186# 0.10497f
C524 a_27655_180030# a_10219_180030# 3.18109f
C525 w[15] spike[0] 0.06073f
C526 a_91762_82334# a_92142_82334# 0.67211f
C527 a_42236_196335# VDD 5.07947f
C528 spike[4] neuron_4__Vamp_bias 0.30684f
C529 a_8859_157048# neuron_4__VKdn 1.14115f
C530 DPI_4__VT bias_0__VT_inh 37.3843f
C531 a_64128_16804# DAC_7__Isum_e 7.71321f
C532 a_18658_95374# a_17910_95582# 0.10497f
C533 w[9] w[14] 0.32843f
C534 a_91762_15178# VT 0.11024f
C535 w[20] s[7] 0.0575f
C536 pulse[1] w[0] 1.16931f
C537 w[19] w[22] 5.56574f
C538 s[4] w[30] 0.13737f
C539 s[4] s[3] 0.27169f
C540 w[13] w[16] 0.31726f
C541 DAC_1__Isum_i DPI_4__Vthr 2.8953f
C542 a_27814_111548# a_36214_111548# 7.01128f
C543 trim[3] trim_steer_0__Iref 0.20613f
C544 DAC_5__Isum_e DPI_4__Vthr 2.8953f
C545 s[1] w[23] 0.13287f
C546 s[5] w[7] 3.06094f
C547 a_92142_112538# spike[4] 1.35619f
C548 VDD a_95576_39970# 2.94927f
C549 s[2] s[1] 1.90776f
C550 a_18658_111390# a_36214_111548# 0.75055f
C551 w[8] w[29] 0.24805f
C552 a_36214_51140# a_23614_51140# 0.11882f
C553 a_36214_81344# a_23614_81344# 0.11882f
C554 w[27] a_17910_111598# 0.364f
C555 s[1] w[3] 0.3025f
C556 w[10] s[6] 0.07996f
C557 a_18658_14030# w[5] 0.02165f
C558 w[9] w[13] 0.10965f
C559 neuron_4__Vlk neuron_4__VIp 28.5035f
C560 spike[3] DAC_1__Isum_i 0.5195f
C561 w[27] w[18] 0.11451f
C562 neuron_4__VNA DPI_4__Vthr 0.78717f
C563 a_17910_51190# a_23614_51140# 15.0391f
C564 a_27655_180030# w_87818_180350# 0.14968f
C565 a_27814_111548# a_18658_111390# 0.06004f
C566 VMEM_2 a_92770_52130# 3.31883f
C567 w[1] s[0] 0.28029f
C568 VDD a_64128_35280# 11.6101f
C569 spike[0] VT 0.17713f
C570 VMEM_0 VT 2.02898f
C571 neuron_4__VK spike[4] 0.1085f
C572 w[4] w[0] 0.0931f
C573 w[10] w[5] 0.10114f
C574 w[19] s[4] 0.41435f
C575 a_33687_180030# trim_steer_0__Iref 0.06263f
C576 w[26] DAC_7__Vb 1.496f
C577 trim[1] trim[0] 22.2248f
C578 trim[2] w_87818_180350# 0.50165f
C579 spike[3] neuron_4__VNA 0.06837f
C580 a_91514_112538# a_91134_112188# 0.60758f
C581 a_10219_180030# a_37150_170466# 3.88059f
C582 VMEM_2 neuron_4__VIp 0.2449f
C583 VDD neuron_4__VKdn 7.60577f
C584 bias_0__Iref a_39323_180030# 1.75963f
C585 w[31] w[1] 0.17808f
C586 a_94948_39970# VMEM_1 0.12888f
C587 w[18] s[5] 0.04643f
C588 w[30] w[16] 0.12607f
C589 s[3] w[16] 0.10457f
C590 s[7] w[22] 0.06497f
C591 neuron_4__VNA a_91134_112188# 0.16892f
C592 DAC_7__Vb bias_0__VT_inh 0.18693f
C593 s[1] w[14] 0.10708f
C594 w[12] spike[0] 0.05288f
C595 a_92142_52130# a_89872_58446# 0.01339f
C596 a_91134_14828# VT 0.54676f
C597 w[12] a_36214_65328# 0.04246f
C598 VDD VMEM_4 5.23566f
C599 neuron_4__Vamp_bias DPI_4__Vthr 0.84351f
C600 a_27814_65328# a_17910_65378# 1.78781f
C601 w[9] w[30] 6.97684f
C602 spike[2] neuron_4__VKup 2.69987f
C603 w[9] s[3] 0.03061f
C604 a_17910_95582# a_36214_95532# 1.31469f
C605 spike[2] a_18158_111598# 0.01869f
C606 a_92142_82334# a_92770_82334# 1.47502f
C607 s[4] s[7] 3.14967f
C608 s[3] DAC_5__Isum_i 0.01848f
C609 w_87818_180350# a_37150_170466# 0.2459f
C610 w[19] w[16] 0.2305f
C611 w[20] trim[2] 0.14036f
C612 w[23] w[7] 0.11268f
C613 VMEM_2 a_92142_52130# 0.25888f
C614 VDD a_36214_32664# 0.30771f
C615 w[13] s[1] 0.8206f
C616 s[2] w[7] 0.50268f
C617 w[1] pulse[0] 0.08662f
C618 spike[0] neuron_4__VIp 0.12205f
C619 spike[3] neuron_4__Vamp_bias 9.73886f
C620 Imon neuron_4__VNA 0.09134f
C621 w[10] w[28] 8.28293f
C622 w[3] w[7] 0.08767f
C623 w[29] w[1] 0.09482f
C624 a_92142_15178# neuron_4__VKdn 0.04013f
C625 VMEM_0 neuron_4__VIp 0.18369f
C626 w[9] w[19] 0.13045f
C627 a_89334_112538# a_91134_112188# 0.9311f
C628 a_36214_51140# a_18658_50982# 0.75055f
C629 VDD a_89872_21494# 10.7093f
C630 a_64128_83960# DPI_4__VT 1.39006f
C631 neuron_4__Vamp_bias a_91134_112188# 0.07771f
C632 w[8] trim[3] 0.15541f
C633 a_27814_32664# a_21514_32664# 0.27118f
C634 neuron_4__VK DPI_4__Vthr 0.32716f
C635 VMEM_1 a_91514_33654# 0.1368f
C636 a_92770_52130# a_91514_52130# 0.26264f
C637 a_27655_180030# bias_0__Iref 1.80966f
C638 a_91514_15178# a_89872_21494# 0.09468f
C639 a_17910_51190# a_18658_50982# 0.10497f
C640 w[11] spike[0] 0.13293f
C641 w[8] w[15] 3.45116f
C642 a_42250_171366# a_39250_171366# 0.10488f
C643 a_18658_125578# DAC_1__Isum_e 14.2174f
C644 trim[2] bias_0__Iref 0.27375f
C645 w[18] w[23] 0.13267f
C646 s[2] w[18] 0.10613f
C647 a_91514_52130# neuron_4__VIp 0.04013f
C648 neuron_4__VK spike[3] 0.16166f
C649 s[7] w[16] 0.05891f
C650 a_23614_65328# a_17910_65378# 15.0391f
C651 w[24] DAC_7__Vb 7.0854f
C652 s[1] s[3] 0.48541f
C653 a_18658_95374# a_36214_95532# 0.75055f
C654 a_27814_111548# w[25] 0.08445f
C655 w[14] w[7] 0.73316f
C656 s[4] w[0] 0.05532f
C657 a_17910_81394# a_27814_81344# 1.78781f
C658 Imon neuron_4__Vamp_bias 0.0897f
C659 neuron_4__VK a_91134_112188# 0.21073f
C660 a_68678_65884# DPI_4__Vthr 2.07464f
C661 VMEM_3 a_64128_83960# 4.24268f
C662 a_17910_125786# DAC_1__Isum_e 0.07931f
C663 w[9] s[7] 0.05288f
C664 a_18658_50982# a_18158_51190# 0.11824f
C665 a_23614_125736# DAC_7__Vb 0.37182f
C666 a_64128_114164# VMEM_4 5.26589f
C667 a_89872_21494# a_92142_15178# 0.01339f
C668 a_91762_52130# a_91134_51780# 14.8965f
C669 neuron_4__Vamp_bias a_72340_144600# 0.70951f
C670 s[4] trim[2] 0.12862f
C671 w[20] w[21] 7.64581f
C672 spike[3] a_18158_125786# 0.01869f
C673 w[26] trim[0] 0.14733f
C674 w[13] w[7] 0.12548f
C675 trim[1] w[26] 0.14693f
C676 w[19] s[1] 0.12033f
C677 a_95576_58446# a_91762_52130# 0.04621f
C678 VDD a_18658_14030# 8.90537f
C679 bias_0__Iref a_37150_170466# 17.8747f
C680 w[10] cal 0.1137f
C681 VT neuron_4__VNA 5.48663f
C682 spike[2] a_17910_111598# 0.04246f
C683 w[10] VDD 0.1523f
C684 a_23614_32664# a_21514_32664# 0.57119f
C685 VMEM_1 a_89334_33654# 0.27205f
C686 a_94948_58446# spike[2] 1.98323f
C687 VMEM_0 a_64128_16804# 5.02213f
C688 a_92142_52130# a_91514_52130# 1.82301f
C689 DPI_4__VT a_68678_126292# 1.69777f
C690 a_89334_15178# a_89872_21494# 2.33814f
C691 w[14] w[18] 0.1189f
C692 a_36214_51140# DAC_5__Isum_i 0.11679f
C693 DAC_3__Isum_e DAC_3__Isum_i 9.42305f
C694 neuron_4__VK Imon 0.09055f
C695 spike[4] spike[1] 0.09117f
C696 a_10219_180030# trim_steer_0__Iref 0.06252f
C697 a_27814_65328# VDD 0.26038f
C698 neuron_4__VK a_72340_144600# 6.06188f
C699 w[9] a_17910_51190# 0.10002f
C700 a_17910_51190# DAC_5__Isum_i 1.77847f
C701 DAC_7__Vb s[0] 6.33612f
C702 a_23614_32664# a_27814_32664# 0.29412f
C703 w[8] w[12] 0.08945f
C704 a_17910_81394# a_23614_81344# 15.0391f
C705 DPI_4__VT DPI_4__Vthr 41.9988f
C706 a_91514_112538# a_89872_118854# 0.09468f
C707 w[13] w[18] 0.11446f
C708 a_109366_196335# a_90186_196335# 0.05947f
C709 w[15] w[1] 0.22603f
C710 bias_0__Iref neuron_4__Vlk 7.29078f
C711 trim[2] w[16] 0.11732f
C712 a_36214_125736# DAC_7__Vb 0.093f
C713 w[21] w[22] 7.73099f
C714 w[31] DAC_7__Vb 1.37791f
C715 s[1] s[7] 0.62341f
C716 w[30] w[7] 4.90254f
C717 w[9] w[0] 1.06222f
C718 a_89334_112538# VT 0.26497f
C719 a_91762_52130# a_89872_58446# 4.40172f
C720 VDD DAC_1__Isum_e 17.9685f
C721 s[3] w[7] 0.15543f
C722 a_89872_118854# neuron_4__VNA 0.33758f
C723 VT neuron_4__Vamp_bias 11.7156f
C724 a_33687_180030# a_39250_171366# 0.06304f
C725 spike[3] DPI_4__VT 1.91857f
C726 w[10] w[27] 0.1121f
C727 a_91514_112538# neuron_4__VIp 0.04013f
C728 a_18658_65170# a_17910_65378# 0.10497f
C729 w_87818_180350# trim_steer_0__Iref 62.1846f
C730 a_18658_111390# s[6] 3.46922f
C731 a_17910_81394# a_36214_81344# 1.31469f
C732 a_18658_14030# a_27814_14188# 0.06004f
C733 a_18158_51190# DAC_5__Isum_i 1.32914f
C734 w[11] a_21514_51140# 0.56837f
C735 neuron_4__VIp neuron_4__VNA 5.8514f
C736 VDD a_23614_111548# 0.42217f
C737 VMEM_2 a_91762_52130# 0.29575f
C738 w[19] w[7] 0.10972f
C739 VDD a_95576_21494# 2.94927f
C740 VDD a_90186_196335# 5.14185f
C741 w[10] s[5] 0.04264f
C742 spike[2] neuron_4__VKdn 12.7144f
C743 DAC_7__Vb a_68678_126292# 0.16099f
C744 VMEM_3 DPI_4__Vthr 2.90921f
C745 a_23614_65328# VDD 0.42217f
C746 w[30] w[18] 0.14076f
C747 spike[3] a_94948_88650# 1.98323f
C748 s[3] w[18] 0.09255f
C749 w[25] w[2] 0.31539f
C750 neuron_4__VK VT 6.95502f
C751 w[11] w[8] 0.60634f
C752 DAC_7__Vb pulse[0] 0.11054f
C753 VMEM_3 spike[3] 2.78018f
C754 a_89334_112538# a_89872_118854# 2.33814f
C755 w[29] DAC_7__Vb 1.30647f
C756 a_27814_51140# a_21514_51140# 0.27118f
C757 spike[1] DPI_4__Vthr 6.03735f
C758 w[8] w[6] 0.95325f
C759 trim[0] a_42850_171366# 4.62463f
C760 Imon DPI_4__VT 1.34884f
C761 trim[1] a_42850_171366# 0.06515f
C762 spike[2] VMEM_4 1.12315f
C763 DAC_7__Vb DPI_4__Vthr 26.9488f
C764 a_17910_14238# w[2] 0.18228f
C765 s[1] w[0] 0.49142f
C766 DAC_5__Isum_e a_27814_51140# 2.06134f
C767 w[17] w[25] 0.11293f
C768 a_46000_171624# a_30675_180030# 0.06314f
C769 w[19] w[18] 7.17319f
C770 spike[3] spike[1] 0.08383f
C771 spike[0] w[22] 0.16144f
C772 neuron_4__Vamp_bias neuron_4__VIp 4.11301f
C773 s[7] w[7] 0.16338f
C774 a_92142_112538# a_89872_118854# 0.01339f
C775 a_27814_32664# w[5] 0.08445f
C776 spike[3] DAC_7__Vb 10.3282f
C777 a_18658_14030# a_23614_14188# 0.05882f
C778 a_89334_33654# a_91514_33654# 0.02914f
C779 a_36214_14188# DAC_7__Vb 0.093f
C780 a_64128_114164# DAC_1__Isum_e 7.70402f
C781 a_89872_88650# a_91134_81984# 0.68101f
C782 neuron_4__VK a_89872_118854# 0.0731f
C783 a_18658_50982# spike[0] 0.37995f
C784 neuron_4__VK a_92770_52130# 0.04013f
C785 s[4] spike[0] 1.39925f
C786 w[8] pulse[1] 1.26102f
C787 bias_0__Iref trim_steer_0__Iref 0.03854f
C788 spike[3] a_91762_82334# 9.68412f
C789 VMEM_2 a_64578_60060# 0.20517f
C790 a_9722_190909# a_109366_196335# 4.12144f
C791 w[10] w[23] 0.12321f
C792 a_18658_14030# w[3] 1.50762f
C793 a_91134_51780# neuron_4__VKup 0.14186f
C794 w[10] s[2] 0.51626f
C795 neuron_4__VK neuron_4__VIp 90.4451f
C796 w[10] w[3] 0.96428f
C797 a_9722_190909# w_151668_188170# 31.7569f
C798 a_23614_51140# a_21514_51140# 0.57119f
C799 s[7] w[18] 3.07008f
C800 a_91762_52130# a_91514_52130# 1.31172f
C801 VDD a_17910_95582# 0.54717f
C802 s[6] w[2] 0.05466f
C803 w[4] w[8] 0.11377f
C804 VMEM_2 DAC_5__Isum_i 0.58594f
C805 w[25] s[6] 0.45475f
C806 Imon DAC_7__Vb 0.09066f
C807 a_95576_88650# spike[3] 0.28806f
C808 VDD a_18658_65170# 8.84723f
C809 w[11] w[1] 0.19457f
C810 VDD a_30675_180030# 3.37951f
C811 VDD a_95576_118854# 2.94927f
C812 w[2] w[5] 0.12944f
C813 a_9722_190909# VDD 6.04049f
C814 w[1] w[6] 1.51612f
C815 w[0] w[7] 0.10243f
C816 w[25] w[5] 0.16395f
C817 w[17] s[6] 0.1219f
C818 VDD VMEM_1 7.09635f
C819 VDD a_36214_111548# 0.19093f
C820 spike[0] w[16] 0.08685f
C821 trim[2] w[7] 0.14321f
C822 w[15] spike[1] 0.21026f
C823 VDD a_27814_111548# 0.26038f
C824 w[8] w[20] 0.11219f
C825 a_10219_180030# a_39250_171366# 0.06266f
C826 w[10] w[14] 0.11355f
C827 w[15] DAC_7__Vb 1.7465f
C828 a_89872_58446# neuron_4__VKup 3.25624f
C829 w[9] spike[0] 0.14262f
C830 VDD a_18658_111390# 8.84723f
C831 a_36214_65328# DAC_5__Isum_i 0.11679f
C832 a_21514_111548# DAC_1__Isum_i 0.01896f
C833 neuron_4__Vlk neuron_4__VKup 44.8032f
C834 VMEM_3 VT 2.65541f
C835 w[24] w[26] 0.08349f
C836 a_91134_33304# neuron_4__VNA 0.16957f
C837 a_38750_170674# a_42850_171366# 0.04294f
C838 VDD a_18658_95374# 8.84723f
C839 w[13] a_18658_14030# 0.01973f
C840 pulse[1] w[1] 0.32078f
C841 a_91134_81984# a_91514_82334# 0.60758f
C842 a_30675_180030# a_39850_171366# 0.08862f
C843 w[10] w[13] 0.09557f
C844 trim[0] DPI_4__Vthr 0.03288f
C845 VDD a_21514_32664# 0.77619f
C846 trim[2] w[18] 0.13201f
C847 VMEM_2 neuron_4__VKup 0.0744f
C848 spike[3] a_92770_82334# 1.13486f
C849 w_87818_180350# a_39250_171366# 0.06154f
C850 VDD a_68678_96088# 11.8043f
C851 w[28] w[2] 0.10361f
C852 VT spike[1] 0.19543f
C853 DPI_4__VT neuron_4__VIp 0.22198f
C854 VDD a_94948_39970# 2.79898f
C855 a_27814_65328# w[13] 0.08445f
C856 a_18658_50982# a_21514_51140# 0.11443f
C857 w[4] w[1] 1.61237f
C858 bias_0__Iref neuron_4__VNA 0.53113f
C859 a_42250_171366# trim[1] 0.07459f
C860 a_42250_171366# trim[0] 0.10327f
C861 w[8] w[22] 0.26248f
C862 a_95576_58446# a_94948_58446# 0.53841f
C863 a_91762_15178# neuron_4__VKup 0.83561f
C864 VDD a_27814_32664# 11.1263f
C865 s[6] w[5] 0.06326f
C866 w[17] w[28] 0.11446f
C867 w[27] a_18658_111390# 1.50762f
C868 DAC_5__Isum_e a_18658_50982# 14.2174f
C869 a_91762_52130# neuron_4__VNA 0.40542f
C870 w[21] w[7] 3.67729f
C871 a_91134_33304# neuron_4__Vamp_bias 0.07771f
C872 a_92142_33654# a_89872_39970# 0.01339f
C873 a_91762_82334# VT 0.07043f
C874 w[12] spike[1] 0.26825f
C875 w[8] s[4] 0.19216f
C876 w[10] w[30] 0.09798f
C877 w[10] s[3] 0.03061f
C878 a_8522_190701# trim_steer_0__Iref 0.85829f
C879 w[12] DAC_7__Vb 7.19659f
C880 spike[0] neuron_4__VKup 0.05003f
C881 a_23614_65328# w[14] 0.25032f
C882 a_91134_81984# a_89334_82334# 0.9311f
C883 spike[4] a_91762_112538# 9.68412f
C884 a_89872_88650# a_91514_82334# 0.09468f
C885 VMEM_3 neuron_4__VIp 0.26374f
C886 spike[3] a_92142_82334# 1.35619f
C887 a_18658_95374# s[5] 3.46922f
C888 VDD a_18158_32714# 1.5403f
C889 w[31] w[26] 0.16628f
C890 neuron_4__Vamp_bias bias_0__Iref 0.34372f
C891 VDD a_36214_95532# 0.19093f
C892 w[10] w[19] 0.12705f
C893 neuron_4__VIp spike[1] 0.13636f
C894 a_17910_95582# w[23] 0.364f
C895 VDD a_91514_33654# 0.14568f
C896 DAC_7__Vb neuron_4__VIp 0.23515f
C897 VDD a_91134_81984# 6.10358f
C898 a_91762_52130# neuron_4__Vamp_bias 0.1069f
C899 cal w[2] 0.04073f
C900 VDD w[2] 0.08809f
C901 s[6] w[28] 0.15062f
C902 VDD a_23614_32664# 13.3088f
C903 a_91134_14828# neuron_4__VKup 0.14188f
C904 trim[1] trim[3] 0.60538f
C905 VDD w[25] 5.11373f
C906 trim[3] trim[0] 16.6184f
C907 bias_0__Iref a_39250_171366# 0.11749f
C908 a_64128_16804# DPI_4__VT 1.53391f
C909 a_21514_51140# DAC_5__Isum_i 0.01896f
C910 a_92142_33654# a_91762_33654# 0.67211f
C911 w[8] w[16] 3.3545f
C912 VDD a_17910_14238# 2.32564f
C913 VMEM_2 a_94948_58446# 0.12888f
C914 trim[1] w[15] 10.9117f
C915 w[17] cal 0.12705f
C916 w[28] w[5] 0.11175f
C917 w[22] w[1] 0.1152f
C918 neuron_4__VK bias_0__Iref 0.27837f
C919 DAC_5__Isum_e DAC_5__Isum_i 11.5551f
C920 w[17] VDD 0.15253f
C921 w[11] DAC_7__Vb 1.6457f
C922 a_21514_65328# w[15] 0.56837f
C923 a_89872_88650# a_89334_82334# 2.33814f
C924 w[9] w[8] 7.30146f
C925 a_94948_21494# neuron_4__VKup 0.04013f
C926 w[26] w[29] 0.15507f
C927 DAC_7__Vb w[6] 3.14557f
C928 w[10] s[7] 0.05288f
C929 s[4] w[1] 0.05815f
C930 w[27] w[2] 0.11393f
C931 w[27] w[25] 7.00577f
C932 a_18658_95374# w[23] 1.50762f
C933 VDD a_89334_33654# 0.22723f
C934 a_27814_51140# DAC_7__Vb 0.18591f
C935 VDD a_89872_88650# 10.7233f
C936 a_42250_171366# a_38750_170674# 0.04295f
C937 a_64578_120468# a_68678_126292# 9.93393f
C938 bias_0__VT_inh DPI_4__Vthr 11.3772f
C939 VDD a_51826_196335# 5.14691f
C940 spike[0] w[18] 0.08662f
C941 neuron_4__Vlk neuron_4__VKdn 3.65932f
C942 a_17910_95582# DAC_3__Isum_i 1.77847f
C943 VDD a_21514_81344# 0.75723f
C944 w[17] w[27] 0.09696f
C945 pulse[1] DAC_7__Vb 2.77691f
C946 s[5] w[2] 0.06173f
C947 w[10] a_17910_51190# 0.18228f
C948 s[6] cal 0.15445f
C949 w[25] s[5] 0.13998f
C950 VDD s[6] 1.71102f
C951 a_18658_14030# DAC_7__Isum_e 14.2174f
C952 a_17910_125786# a_18658_125578# 0.10497f
C953 a_17910_14238# a_27814_14188# 1.78781f
C954 a_21514_125736# a_18658_125578# 0.11443f
C955 a_23614_95532# w[22] 0.25032f
C956 VMEM_2 neuron_4__VKdn 8.28928f
C957 a_91762_112538# a_91134_112188# 14.8965f
C958 VMEM_4 neuron_4__Vlk 0.46946f
C959 w[12] trim[0] 0.37177f
C960 a_17910_125786# w[28] 0.01848f
C961 a_36214_125736# a_23614_125736# 0.11882f
C962 trim[1] w[12] 0.11593f
C963 w[8] s[1] 0.61766f
C964 VDD w[5] 0.13244f
C965 DAC_1__Isum_i a_18158_111598# 1.32914f
C966 cal w[5] 0.98567f
C967 spike[2] a_18658_111390# 0.37995f
C968 w[17] s[5] 0.05532f
C969 w[10] w[0] 1.05224f
C970 w[4] DAC_7__Vb 9.0535f
C971 s[4] a_18658_81186# 3.46922f
C972 a_21514_125736# a_17910_125786# 17.2602f
C973 spike[3] a_64578_120468# 0.08369f
C974 neuron_4__VNA neuron_4__VKup 62.1396f
C975 bias_0__Iref DPI_4__VT 0.14565f
C976 a_89872_39970# neuron_4__VNA 0.34116f
C977 a_42236_196335# trim_steer_0__Iref 0.01585f
C978 w[9] w[1] 0.19061f
C979 VDD a_17910_65378# 0.54717f
C980 a_23614_51140# DAC_7__Vb 0.37182f
C981 a_89334_82334# a_91514_82334# 0.02914f
C982 a_92142_33654# neuron_4__VKdn 0.04013f
C983 DAC_6__Isum_e DPI_4__Vthr 2.8953f
C984 w[20] spike[1] 0.08672f
C985 w_87818_180350# w_86458_180350# 0.02077f
C986 a_23614_14188# w[2] 0.25032f
C987 w[27] s[6] 0.42224f
C988 trim[3] w[26] 0.16804f
C989 s[3] a_18658_65170# 3.46922f
C990 VDD a_18158_81394# 0.21115f
C991 w[20] DAC_7__Vb 7.26761f
C992 Imon bias_0__VT_inh 1.79938f
C993 a_18658_95374# DAC_3__Isum_i 0.05814f
C994 spike[0] neuron_4__VKdn 0.15978f
C995 VMEM_0 neuron_4__VKdn 0.25939f
C996 a_18658_125578# VDD 8.89592f
C997 w[27] w[5] 0.36871f
C998 a_64578_60060# a_68678_65884# 9.93393f
C999 a_91134_33304# spike[1] 0.14351f
C1000 a_17910_14238# a_23614_14188# 15.0391f
C1001 VDD a_91514_82334# 0.14568f
C1002 a_68678_96088# DAC_3__Isum_i 6.12823f
C1003 w[23] w[2] 0.28383f
C1004 s[6] s[5] 1.2508f
C1005 a_33687_180030# a_38750_170674# 2.51627f
C1006 a_61416_196335# a_71006_196335# 4.14185f
C1007 s[2] w[2] 0.28999f
C1008 s[2] w[25] 0.29351f
C1009 VDD w[28] 0.23074f
C1010 a_68678_65884# DAC_5__Isum_i 6.12822f
C1011 w[3] w[2] 10.3005f
C1012 neuron_4__Vamp_bias neuron_4__VKup 6.391f
C1013 trim[1] w[6] 0.27517f
C1014 w[25] w[3] 0.73157f
C1015 a_46000_171624# cal 4.37805f
C1016 a_42250_171366# a_42850_171366# 39.2982f
C1017 DAC_7__Vb a_21514_111548# 0.74342f
C1018 w[8] w[7] 0.89765f
C1019 a_91762_33654# neuron_4__VNA 0.40655f
C1020 a_46000_171624# VDD 15.4694f
C1021 s[5] w[5] 0.06998f
C1022 w[17] w[23] 0.12321f
C1023 a_17910_125786# VDD 0.54717f
C1024 a_21514_125736# VDD 0.75723f
C1025 w[17] s[2] 0.10132f
C1026 a_17910_14238# w[3] 0.364f
C1027 a_89872_21494# a_91762_15178# 4.40172f
C1028 a_8859_157048# cal 0.01529f
C1029 a_64128_83960# DPI_4__Vthr 1.25274f
C1030 s[1] w[1] 0.13326f
C1031 DAC_7__Vb bias_0__Iref 0.87319f
C1032 a_8859_157048# VDD 37.1658f
C1033 w[22] spike[1] 5.26328f
C1034 w[22] DAC_7__Vb 4.80438f
C1035 a_17910_111598# DAC_1__Isum_i 1.77847f
C1036 pulse[0] s[0] 1.61083f
C1037 neuron_4__VK neuron_4__VKup 10.259f
C1038 VT a_91762_112538# 0.07035f
C1039 a_89872_21494# spike[0] 0.52077f
C1040 VMEM_0 a_89872_21494# 1.71072f
C1041 VDD a_109366_196335# 5.24429f
C1042 s[4] spike[1] 0.31827f
C1043 w[27] w[28] 13.0099f
C1044 a_18658_50982# DAC_7__Vb 0.01707f
C1045 spike[3] spike[4] 14.3535f
C1046 spike[2] w[25] 0.08662f
C1047 w[8] w[18] 0.22714f
C1048 w[31] w[29] 0.0901f
C1049 w[14] w[25] 0.33705f
C1050 VDD a_89334_82334# 0.22723f
C1051 s[4] DAC_7__Vb 6.64516f
C1052 VDD w_151668_188170# 0.85035f
C1053 a_36214_95532# DAC_3__Isum_i 0.11679f
C1054 a_91762_33654# neuron_4__Vamp_bias 0.06057f
C1055 w[12] w[26] 0.13048f
C1056 w_87818_180350# trim[0] 0.55578f
C1057 a_46000_171624# a_39850_171366# 0.52808f
C1058 trim[1] w_87818_180350# 0.5016f
C1059 VDD a_92770_15178# 0.17724f
C1060 spike[4] a_91134_112188# 0.14351f
C1061 w_150308_188170# w_151668_188170# 0.02081f
C1062 w[17] w[14] 0.12809f
C1063 a_8522_190701# a_32646_196335# 0.54818f
C1064 s[6] w[23] 0.07226f
C1065 w[28] s[5] 0.37977f
C1066 w[13] w[2] 0.0924f
C1067 VDD cal 3.48561f
C1068 w[31] spike[3] 0.07426f
C1069 w[13] w[25] 3.79103f
C1070 s[2] s[6] 0.26424f
C1071 a_89872_21494# a_91134_14828# 0.68101f
C1072 trim[3] a_42850_171366# 0.03377f
C1073 s[6] w[3] 0.04591f
C1074 a_8522_190701# a_21494_196237# 11.3218f
C1075 a_91514_15178# a_92770_15178# 0.26264f
C1076 w[24] w[15] 0.15718f
C1077 w[23] w[5] 0.11898f
C1078 s[2] w[5] 0.30948f
C1079 a_68678_126292# DPI_4__Vthr 1.60709f
C1080 a_95576_39970# neuron_4__VNA 0.04168f
C1081 w[17] w[13] 0.1089f
C1082 VDD a_91514_15178# 0.14568f
C1083 a_89872_118854# a_91762_112538# 4.40172f
C1084 w[1] w[7] 0.20912f
C1085 w[3] w[5] 1.40389f
C1086 a_80596_196335# a_99776_196335# 0.05947f
C1087 w[16] spike[1] 0.18247f
C1088 w[20] trim[0] 0.12481f
C1089 a_33687_180030# a_42850_171366# 0.34325f
C1090 w[16] DAC_7__Vb 7.06423f
C1091 trim[1] w[20] 0.12671f
C1092 w[10] spike[0] 0.14118f
C1093 a_64578_60060# spike[1] 0.04186f
C1094 spike[3] a_68678_126292# 0.3979f
C1095 a_27814_95532# DAC_3__Isum_e 2.06134f
C1096 a_92142_15178# a_92770_15178# 1.47502f
C1097 neuron_4__VIp bias_0__VT_inh 0.15808f
C1098 a_27655_180030# a_30675_180030# 3.34418f
C1099 w[30] w[2] 0.10317f
C1100 DAC_5__Isum_i spike[1] 1.34891f
C1101 w[9] DAC_7__Vb 1.38263f
C1102 s[3] w[2] 0.02841f
C1103 neuron_4__VNA neuron_4__VKdn 14.1327f
C1104 a_39850_171366# cal 0.12344f
C1105 spike[3] w[29] 0.08662f
C1106 spike[2] s[6] 1.29567f
C1107 s[3] w[25] 0.11166f
C1108 w[14] s[6] 5.26361f
C1109 VDD w[27] 13.2614f
C1110 a_27814_65328# a_36214_65328# 7.01128f
C1111 VDD a_39850_171366# 2.91244f
C1112 VMEM_4 DAC_1__Isum_i 0.58594f
C1113 VDD a_92142_15178# 0.15438f
C1114 a_91514_112538# VMEM_4 0.1368f
C1115 DPI_4__VT neuron_4__VKup 1.95462f
C1116 spike[3] DPI_4__Vthr 4.61133f
C1117 w[14] w[5] 0.51648f
C1118 w[17] s[3] 0.09043f
C1119 VDD a_27814_14188# 11.1263f
C1120 a_91514_15178# a_92142_15178# 1.82301f
C1121 w[17] w[30] 0.12321f
C1122 a_21514_81344# DAC_3__Isum_i 0.01896f
C1123 w[15] s[0] 0.40159f
C1124 VMEM_4 neuron_4__VNA 0.52345f
C1125 cal s[5] 0.14592f
C1126 w[19] w[2] 0.09024f
C1127 bias_0__Iref trim[0] 0.17924f
C1128 w[13] s[6] 0.0827f
C1129 s[2] w[28] 0.25747f
C1130 trim[1] bias_0__Iref 7.85959f
C1131 VDD s[5] 1.70714f
C1132 VDD a_89334_15178# 0.22723f
C1133 a_18158_95582# DAC_3__Isum_e 2.10366f
C1134 a_18658_14030# a_21514_14188# 0.11443f
C1135 a_95576_21494# a_91762_15178# 0.04621f
C1136 a_92770_112538# VMEM_4 3.31883f
C1137 w[31] w[15] 0.14453f
C1138 w[24] w[12] 0.11291f
C1139 w[14] a_17910_65378# 0.18228f
C1140 VDD a_64128_114164# 11.7911f
C1141 a_94948_88650# neuron_4__VKup 0.04013f
C1142 DAC_1__Isum_e a_27814_125736# 2.06134f
C1143 w[13] w[5] 1.12966f
C1144 a_89334_15178# a_91514_15178# 0.02914f
C1145 w[17] w[19] 0.2197f
C1146 a_18658_81186# DAC_3__Isum_e 14.2174f
C1147 neuron_4__Vamp_bias neuron_4__VKdn 25.1872f
C1148 a_37150_170466# a_30675_180030# 0.11461f
C1149 VMEM_0 a_95576_21494# 0.93986f
C1150 VMEM_3 neuron_4__VKup 0.05916f
C1151 a_95576_21494# spike[0] 0.28806f
C1152 spike[4] VT 0.07353f
C1153 s[4] trim[0] 0.12405f
C1154 a_89872_21494# neuron_4__VNA 0.3403f
C1155 trim[1] s[4] 0.12524f
C1156 Imon DPI_4__Vthr 6.359f
C1157 s[1] DAC_7__Vb 6.76055f
C1158 w[13] a_17910_65378# 0.10002f
C1159 a_23614_65328# a_36214_65328# 0.11882f
C1160 a_89334_112538# VMEM_4 0.27205f
C1161 a_17910_95582# w[21] 0.10002f
C1162 neuron_4__VKup spike[1] 0.07776f
C1163 neuron_4__Vamp_bias VMEM_4 1.29961f
C1164 a_89872_39970# spike[1] 0.52077f
C1165 a_92142_112538# neuron_4__VKdn 0.04013f
C1166 s[7] w[2] 0.10384f
C1167 DAC_7__Vb neuron_4__VKup 0.17425f
C1168 w[27] s[5] 0.11971f
C1169 w[30] s[6] 0.15062f
C1170 s[7] w[25] 0.05345f
C1171 s[3] s[6] 0.17707f
C1172 w[14] w[28] 0.30441f
C1173 a_18158_81394# DAC_3__Isum_i 1.32914f
C1174 VDD a_23614_14188# 13.3088f
C1175 w[15] pulse[0] 0.02366f
C1176 w[15] w[29] 0.157f
C1177 neuron_4__VK neuron_4__VKdn 34.5f
C1178 a_18658_14030# a_18158_14238# 0.11824f
C1179 w[30] w[5] 0.10275f
C1180 VMEM_1 a_92770_33654# 3.31883f
C1181 a_92142_112538# VMEM_4 0.25888f
C1182 s[3] w[5] 0.05535f
C1183 w[17] s[7] 0.05723f
C1184 w[19] a_21514_81344# 0.56837f
C1185 VMEM_1 neuron_4__Vlk 0.29148f
C1186 w[11] w[24] 0.4415f
C1187 a_91762_82334# neuron_4__VKup 0.83549f
C1188 w[19] s[6] 0.06351f
C1189 VDD w[23] 1.56224f
C1190 spike[4] a_89872_118854# 0.52077f
C1191 a_42236_196335# a_32646_196335# 4.14077f
C1192 w[13] w[28] 0.14304f
C1193 s[2] cal 1.31876f
C1194 w[16] trim[0] 0.11236f
C1195 VDD s[2] 2.08922f
C1196 w[24] w[6] 0.38152f
C1197 a_36214_81344# w[16] 0.04246f
C1198 VDD w[3] 0.19721f
C1199 w[20] w[26] 0.13298f
C1200 a_89872_21494# neuron_4__Vamp_bias 0.01209f
C1201 neuron_4__VK VMEM_4 0.25046f
C1202 trim[1] w[16] 0.11394f
C1203 w[31] w[12] 0.13503f
C1204 a_42236_196335# a_21494_196237# 0.34128f
C1205 a_94948_21494# a_95576_21494# 0.53841f
C1206 w[19] w[5] 0.57564f
C1207 spike[4] neuron_4__VIp 0.09186f
C1208 w[10] w[8] 0.29596f
C1209 DAC_5__Isum_e a_27814_65328# 2.06134f
C1210 a_91762_33654# spike[1] 9.68412f
C1211 a_10219_180030# a_42850_171366# 0.33891f
C1212 a_42250_171366# a_33687_180030# 0.08773f
C1213 VMEM_3 DAC_3__Isum_e 0.0248f
C1214 w[2] w[0] 0.18994f
C1215 DAC_7__Vb w[7] 1.43459f
C1216 Imon a_72340_144600# 2.92607f
C1217 a_17910_14238# DAC_7__Isum_e 0.07931f
C1218 a_23614_14188# a_27814_14188# 0.29412f
C1219 a_21514_65328# DAC_5__Isum_i 0.01896f
C1220 w[24] pulse[1] 0.14772f
C1221 a_38750_170674# bias_0__Iref 1.91925f
C1222 a_17910_14238# w[0] 0.01848f
C1223 VMEM_1 a_92142_33654# 0.25888f
C1224 w[30] w[28] 0.08348f
C1225 s[7] s[6] 0.64408f
C1226 w[14] cal 0.16439f
C1227 s[3] w[28] 0.0993f
C1228 DAC_1__Isum_e DAC_1__Isum_i 7.74219f
C1229 a_36214_65328# a_18658_65170# 0.75055f
C1230 spike[3] VT 0.27182f
C1231 w[11] s[0] 0.03504f
C1232 s[2] w[27] 0.2685f
C1233 VDD spike[2] 2.20021f
C1234 VDD w[14] 1.9271f
C1235 w[27] w[3] 1.3506f
C1236 a_64128_35280# DPI_4__VT 1.82197f
C1237 w[12] w[29] 0.1343f
C1238 a_17910_125786# w[30] 0.18228f
C1239 VMEM_1 spike[0] 0.02577f
C1240 s[7] w[5] 0.08742f
C1241 VT a_91134_112188# 0.51489f
C1242 w[17] trim[2] 0.11446f
C1243 w_87818_180350# a_42850_171366# 0.05775f
C1244 w[18] spike[1] 0.50412f
C1245 a_23614_111548# DAC_1__Isum_i 12.8867f
C1246 w[11] w[31] 9.61567f
C1247 w[4] w[24] 4.9156f
C1248 s[5] w[23] 0.40829f
C1249 w[13] cal 0.15525f
C1250 DPI_4__VT neuron_4__VKdn 0.86198f
C1251 s[2] s[5] 0.20808f
C1252 DAC_7__Vb w[18] 1.44695f
C1253 bias_0__Iref bias_0__VT_inh 0.10346f
C1254 VDD DAC_3__Isum_i 17.1439f
C1255 w[31] w[6] 2.15545f
C1256 s[5] w[3] 0.05298f
C1257 VDD w[13] 2.15485f
C1258 s[4] w[26] 16.1359f
C1259 a_91762_112538# a_94948_118854# 0.37248f
C1260 trim_steer_0__Iref a_30675_180030# 0.06278f
C1261 a_95576_21494# neuron_4__VNA 0.04168f
C1262 a_27814_81344# DAC_3__Isum_e 2.06134f
C1263 a_9722_190909# trim_steer_0__Iref 19.9466f
C1264 VMEM_4 DPI_4__VT 0.38571f
C1265 w[10] w[1] 0.18413f
C1266 neuron_4__VIp DPI_4__Vthr 0.2431f
C1267 w[27] spike[2] 0.07426f
C1268 w[27] w[14] 0.30355f
C1269 a_80596_196335# a_71006_196335# 4.14186f
C1270 w[24] w[20] 0.13998f
C1271 a_18158_65378# DAC_5__Isum_i 1.32914f
C1272 pulse[1] s[0] 1.34202f
C1273 a_95576_39970# spike[1] 0.28806f
C1274 s[6] w[0] 1.43836f
C1275 a_18658_125578# s[7] 3.46922f
C1276 a_92770_33654# a_91514_33654# 0.26264f
C1277 a_89872_118854# a_91134_112188# 0.68101f
C1278 spike[3] neuron_4__VIp 0.16399f
C1279 w[11] w[29] 0.13336f
C1280 VMEM_3 neuron_4__VKdn 0.74558f
C1281 w[31] pulse[1] 1.48319f
C1282 w[21] w[25] 0.1469f
C1283 trim[2] s[6] 0.15062f
C1284 w[0] w[5] 0.13204f
C1285 s[3] cal 0.11924f
C1286 s[7] w[28] 1.36632f
C1287 w[14] s[5] 0.08235f
C1288 VDD w[30] 0.23261f
C1289 w[29] w[6] 0.12528f
C1290 VDD s[3] 1.70784f
C1291 w[13] w[27] 0.14002f
C1292 w[26] w[16] 0.11616f
C1293 neuron_4__VIp a_91134_112188# 0.05369f
C1294 a_46000_171624# a_39323_180030# 0.19515f
C1295 spike[2] a_64128_114164# 0.27574f
C1296 neuron_4__VKdn spike[1] 0.16146f
C1297 trim[2] w[5] 0.14622f
C1298 DAC_7__Vb neuron_4__VKdn 0.34205f
C1299 DAC_3__Isum_i s[5] 0.01848f
C1300 w[13] s[5] 0.06058f
C1301 w[9] w[26] 0.09545f
C1302 s[2] w[23] 4.13425f
C1303 bias_0__Iref a_42850_171366# 0.11914f
C1304 VDD w[19] 4.22575f
C1305 w[23] w[3] 0.12006f
C1306 s[2] w[3] 0.27124f
C1307 trim[3] w[12] 0.2202f
C1308 trim[1] w[7] 0.14874f
C1309 trim[0] w[7] 0.14737f
C1310 pulse[1] pulse[0] 0.4382f
C1311 Imon neuron_4__VIp 0.08754f
C1312 VDD a_64128_53756# 11.6653f
C1313 pulse[1] w[29] 0.8487f
C1314 DAC_5__Isum_e a_18658_65170# 14.2174f
C1315 w[15] w[12] 0.3362f
C1316 a_92142_33654# a_91514_33654# 1.82301f
C1317 a_23614_81344# w[18] 0.25032f
C1318 w[24] s[4] 0.22708f
C1319 w[27] s[3] 0.09056f
C1320 a_42250_171366# a_10219_180030# 0.06298f
C1321 w[31] w[20] 0.25425f
C1322 a_36214_81344# DAC_3__Isum_e 6.81042f
C1323 a_64128_16804# DPI_4__Vthr 1.25274f
C1324 a_36214_32664# DAC_7__Vb 0.093f
C1325 DAC_1__Isum_e a_18158_125786# 2.10366f
C1326 DAC_1__Isum_i a_36214_111548# 0.11679f
C1327 a_17910_81394# w[16] 0.01848f
C1328 VDD a_39323_180030# 9.12241f
C1329 w[30] s[5] 0.14242f
C1330 s[7] cal 0.14233f
C1331 s[3] s[5] 24.7781f
C1332 w[14] w[23] 0.28436f
C1333 a_95576_118854# neuron_4__VNA 0.04168f
C1334 trim[1] w[18] 0.12863f
C1335 VDD s[7] 2.00463f
C1336 w[21] s[6] 1.56603f
C1337 a_46000_171624# a_27655_180030# 0.06291f
C1338 spike[0] w[25] 0.16466f
C1339 trim[0] w[18] 0.12724f
C1340 a_27814_111548# DAC_1__Isum_i 10.8659f
C1341 VMEM_1 neuron_4__VNA 0.06271f
C1342 s[2] w[14] 0.90172f
C1343 VDD a_89334_52130# 0.22723f
C1344 a_18658_111390# DAC_1__Isum_i 0.05814f
C1345 a_46000_171624# trim[2] 0.17601f
C1346 a_42250_171366# w_87818_180350# 0.05817f
C1347 w[17] spike[0] 0.08662f
C1348 spike[4] a_94948_118854# 1.98323f
C1349 w[13] w[23] 0.27933f
C1350 w[19] s[5] 0.04264f
C1351 VDD a_36214_51140# 0.19093f
C1352 w[24] w[16] 0.10803f
C1353 s[2] w[13] 3.43986f
C1354 w[20] w[29] 0.14064f
C1355 w[13] w[3] 0.15103f
C1356 w[11] w[15] 1.41763f
C1357 s[4] s[0] 0.16206f
C1358 w[15] w[6] 0.10337f
C1359 VDD a_17910_51190# 0.54717f
C1360 VT neuron_4__VIp 2.09466f
C1361 a_91762_112538# neuron_4__VKup 0.84653f
C1362 a_17910_95582# a_21514_95532# 17.2602f
C1363 a_39850_171366# a_39323_180030# 0.14139f
C1364 a_46000_171624# a_37150_170466# 1.16932f
C1365 VDD DAC_7__Isum_e 20.5337f
C1366 bias_0__VT_inh neuron_4__VKup 0.427f
C1367 w[9] w[24] 1.00939f
C1368 w[27] s[7] 0.04109f
C1369 VMEM_1 neuron_4__Vamp_bias 4.28647f
C1370 w[31] s[4] 0.14458f
C1371 a_80596_196335# a_61416_196335# 0.05947f
C1372 VDD w[0] 0.0835f
C1373 a_17910_14238# a_21514_14188# 17.2602f
C1374 w[10] DAC_7__Vb 1.42546f
C1375 VDD a_27655_180030# 2.75698f
C1376 a_27814_95532# a_17910_95582# 1.78781f
C1377 a_39250_171366# a_30675_180030# 0.06356f
C1378 trim[2] cal 7.48822f
C1379 w[21] w[28] 0.13702f
C1380 s[2] w[30] 0.24828f
C1381 VDD trim[2] 1.5025f
C1382 s[7] s[5] 0.14387f
C1383 s[3] w[23] 0.10805f
C1384 w_147588_188170# w_146228_188170# 0.0125f
C1385 w[13] w[14] 7.93947f
C1386 VDD a_18158_51190# 0.21115f
C1387 s[2] s[3] 0.38068f
C1388 w[15] pulse[1] 1.26534f
C1389 s[3] w[3] 0.02841f
C1390 bias_0__Iref DPI_4__Vthr 5.04969f
C1391 a_27814_65328# DAC_7__Vb 0.18591f
C1392 trim[3] w_87818_180350# 0.50172f
C1393 w[26] w[7] 0.38439f
C1394 neuron_4__VK VMEM_1 0.24306f
C1395 VDD a_91134_51780# 6.10168f
C1396 a_18658_95374# a_21514_95532# 0.11443f
C1397 a_17910_95582# a_18158_95582# 1.6884f
C1398 s[2] w[19] 1.71521f
C1399 VDD a_95576_58446# 2.94927f
C1400 w[31] w[16] 0.13329f
C1401 s[4] w[29] 0.13748f
C1402 a_8859_157048# neuron_4__Vlk 4.78213f
C1403 a_42250_171366# bias_0__Iref 0.11818f
C1404 w[4] w[15] 0.11366f
C1405 w[19] w[3] 0.09669f
C1406 w[11] w[12] 0.24439f
C1407 a_36214_65328# a_17910_65378# 1.31469f
C1408 DAC_7__Vb DAC_1__Isum_e 4.25276f
C1409 a_33687_180030# w_87818_180350# 0.53771f
C1410 w[24] s[1] 0.14151f
C1411 a_37150_170466# cal 0.29075f
C1412 w[26] a_17910_111598# 0.18228f
C1413 VDD a_37150_170466# 0.39909f
C1414 a_27655_180030# a_39850_171366# 0.06377f
C1415 a_27814_14188# DAC_7__Isum_e 2.06134f
C1416 a_92142_82334# neuron_4__VKdn 0.04013f
C1417 a_17910_14238# a_18158_14238# 1.6884f
C1418 a_18158_81394# spike[0] 0.01869f
C1419 w[9] w[31] 0.15138f
C1420 a_27814_95532# a_18658_95374# 0.06004f
C1421 a_23614_95532# a_17910_95582# 15.0391f
C1422 w[26] w[18] 0.68761f
C1423 w[30] w[14] 8.07975f
C1424 w[14] s[3] 0.70815f
C1425 trim[3] w[20] 0.16102f
C1426 a_91134_81984# neuron_4__VNA 0.16933f
C1427 w[8] w[25] 0.27942f
C1428 s[5] w[0] 0.03468f
C1429 w[8] w[2] 0.12432f
C1430 a_23614_111548# DAC_7__Vb 0.37182f
C1431 a_92142_52130# a_92770_52130# 1.47502f
C1432 a_18658_125578# a_27814_125736# 0.06004f
C1433 a_23614_65328# DAC_7__Vb 0.37182f
C1434 Imon bias_0__Iref 0.7651f
C1435 VDD w[21] 0.13132f
C1436 s[7] w[23] 0.05859f
C1437 s[2] s[7] 0.13123f
C1438 w[21] cal 0.13927f
C1439 trim[2] s[5] 0.15226f
C1440 w[13] w[30] 0.13392f
C1441 spike[0] w[28] 13.0548f
C1442 w[17] w[8] 0.22233f
C1443 w[13] s[3] 0.67367f
C1444 VDD a_92770_33654# 0.17724f
C1445 VDD a_89872_58446# 10.7128f
C1446 w[19] w[14] 5.04288f
C1447 neuron_4__Vlk cal 0.0958f
C1448 w[29] w[16] 0.12607f
C1449 s[7] w[3] 0.05437f
C1450 VDD neuron_4__Vlk 5.11937f
C1451 a_17910_81394# DAC_3__Isum_e 0.07931f
C1452 a_18658_95374# a_18158_95582# 0.11824f
C1453 a_37150_170466# a_39850_171366# 0.17019f
C1454 a_9722_190909# a_21494_196237# 1.29079f
C1455 s[1] s[0] 1.07835f
C1456 a_18658_32506# DAC_6__Isum_e 14.2174f
C1457 a_17910_125786# a_27814_125736# 1.78781f
C1458 w[11] w[6] 0.21358f
C1459 trim[3] bias_0__Iref 0.30935f
C1460 a_36214_95532# a_21514_95532# 0.16484f
C1461 a_21514_125736# a_27814_125736# 0.27118f
C1462 w[9] w[29] 7.09841f
C1463 w[13] w[19] 3.72436f
C1464 VDD VMEM_2 5.27578f
C1465 VMEM_1 DPI_4__VT 0.29129f
C1466 a_91134_81984# neuron_4__Vamp_bias 0.10742f
C1467 a_23614_95532# a_18658_95374# 0.05882f
C1468 a_17910_81394# w[18] 0.18228f
C1469 DAC_5__Isum_i DPI_4__Vthr 2.8953f
C1470 w[24] w[7] 0.1301f
C1471 w[15] w[22] 0.16176f
C1472 a_17910_32714# DAC_6__Isum_e 0.07931f
C1473 a_89872_88650# neuron_4__VNA 0.3398f
C1474 a_46000_171624# trim_steer_0__Iref 0.16776f
C1475 a_91134_33304# VT 0.54298f
C1476 DAC_1__Isum_i s[6] 0.01848f
C1477 a_33687_180030# bias_0__Iref 1.79726f
C1478 a_27814_95532# a_36214_95532# 7.01128f
C1479 w[27] w[21] 0.13371f
C1480 w[30] s[3] 0.0993f
C1481 trim[3] s[4] 0.17019f
C1482 s[7] w[14] 0.06002f
C1483 VDD a_91762_15178# 3.95804f
C1484 w[8] s[6] 3.16747f
C1485 VDD a_92142_33654# 0.15438f
C1486 s[2] w[0] 1.33886f
C1487 w[20] w[12] 0.70112f
C1488 s[4] w[15] 0.65719f
C1489 w[11] pulse[1] 0.53638f
C1490 w[24] a_17910_111598# 0.01848f
C1491 spike[0] a_92770_15178# 1.13486f
C1492 VMEM_0 a_92770_15178# 3.31883f
C1493 a_91514_15178# a_91762_15178# 1.31172f
C1494 w[3] w[0] 0.33722f
C1495 w[25] w[1] 0.11794f
C1496 w[1] w[2] 12.8098f
C1497 bias_0__VT_inh neuron_4__VKdn 0.20895f
C1498 a_17910_95582# spike[1] 0.04246f
C1499 pulse[1] w[6] 1.10652f
C1500 w[21] s[5] 4.89216f
C1501 w[8] w[5] 1.77917f
C1502 s[2] trim[2] 2.94478f
C1503 w[13] s[7] 0.04343f
C1504 w[24] w[18] 0.12392f
C1505 a_27814_65328# a_21514_65328# 0.27118f
C1506 VDD spike[0] 3.46941f
C1507 VDD VMEM_0 4.51547f
C1508 a_18658_65170# spike[1] 0.40982f
C1509 w[19] s[3] 0.12145f
C1510 s[2] a_18158_51190# 0.04246f
C1511 VDD a_36214_65328# 0.19093f
C1512 a_68678_96088# DPI_4__VT 2.15786f
C1513 a_17910_14238# w[1] 0.10002f
C1514 VMEM_4 a_91762_112538# 0.29575f
C1515 s[1] pulse[0] 0.06943f
C1516 DAC_5__Isum_e a_17910_65378# 0.07931f
C1517 a_91762_52130# VT 0.07035f
C1518 a_64128_83960# DAC_3__Isum_e 7.70749f
C1519 VDD a_27814_125736# 0.26038f
C1520 a_89334_33654# neuron_4__Vamp_bias 0.05117f
C1521 w[11] w[4] 0.30762f
C1522 a_89872_88650# neuron_4__Vamp_bias 0.04404f
C1523 VMEM_1 spike[1] 2.79261f
C1524 a_91514_15178# spike[0] 0.04786f
C1525 a_91514_15178# VMEM_0 0.1368f
C1526 w[4] w[6] 1.92706f
C1527 DAC_7__Vb a_36214_111548# 0.093f
C1528 a_68678_96088# a_64578_90264# 9.93393f
C1529 a_99776_196335# a_90186_196335# 4.1419f
C1530 trim[3] w[16] 0.14561f
C1531 a_92142_15178# a_91762_15178# 0.67211f
C1532 neuron_4__VKup DPI_4__Vthr 3.15656f
C1533 trim_steer_0__Iref cal 7.36926f
C1534 VDD trim_steer_0__Iref 0.11392p
C1535 a_23614_95532# a_36214_95532# 0.11882f
C1536 a_10219_180030# w_87818_180350# 1.7271f
C1537 w[31] w[7] 5.17386f
C1538 a_18658_125578# DAC_1__Isum_i 0.05814f
C1539 VDD a_91134_14828# 6.10103f
C1540 a_64128_35280# DAC_6__Isum_e 7.73947f
C1541 a_64578_120468# VMEM_4 0.20517f
C1542 a_27814_111548# DAC_7__Vb 0.18591f
C1543 w[15] w[16] 0.79171f
C1544 VDD a_91514_52130# 0.14568f
C1545 w[12] w[22] 0.13184f
C1546 DAC_7__Vb a_18658_111390# 0.0464f
C1547 w[27] spike[0] 13.179f
C1548 VMEM_3 a_68678_96088# 6.40836f
C1549 w[30] s[7] 0.4328f
C1550 spike[3] neuron_4__VKup 0.07363f
C1551 VMEM_0 a_92142_15178# 0.25888f
C1552 s[7] s[3] 0.09048f
C1553 VDD a_21514_14188# 0.77619f
C1554 a_91514_15178# a_91134_14828# 0.60758f
C1555 trim[2] w[14] 0.18009f
C1556 spike[0] a_92142_15178# 1.35619f
C1557 a_18658_95374# spike[1] 0.37995f
C1558 w[8] w[28] 0.2393f
C1559 w[9] w[15] 0.10262f
C1560 a_17910_125786# DAC_1__Isum_i 1.77847f
C1561 a_21514_125736# DAC_1__Isum_i 0.01896f
C1562 a_18658_95374# DAC_7__Vb 0.03588f
C1563 a_23614_51140# a_27814_51140# 0.29412f
C1564 VDD a_94948_21494# 2.79898f
C1565 a_23614_65328# a_21514_65328# 0.57119f
C1566 bias_0__Iref neuron_4__VIp 20.8695f
C1567 s[4] w[12] 0.07349f
C1568 w[4] pulse[1] 2.15566f
C1569 a_91134_112188# neuron_4__VKup 0.16649f
C1570 s[6] w[1] 0.06877f
C1571 spike[2] a_91134_51780# 0.14351f
C1572 a_21514_32664# DAC_7__Vb 0.74342f
C1573 w[31] w[18] 0.14798f
C1574 a_95576_58446# spike[2] 0.28806f
C1575 w[19] s[7] 0.06497f
C1576 a_89334_15178# VMEM_0 0.27205f
C1577 w[13] trim[2] 0.13505f
C1578 w[21] w[23] 0.50989f
C1579 a_94948_39970# spike[1] 1.98323f
C1580 w[1] w[5] 0.27654f
C1581 trim_steer_0__Iref a_39850_171366# 0.07751f
C1582 a_8859_157048# neuron_4__VNA 0.17547f
C1583 w[29] w[7] 0.24923f
C1584 w[11] w[22] 0.26672f
C1585 a_27814_32664# DAC_7__Vb 0.18591f
C1586 a_36214_32664# DAC_6__Isum_e 6.81042f
C1587 Imon neuron_4__VKup 0.08875f
C1588 w[22] w[6] 4.08713f
C1589 DAC_3__Isum_e DPI_4__Vthr 2.8953f
C1590 a_89334_15178# a_91134_14828# 0.9311f
C1591 s[3] w[0] 0.03796f
C1592 VDD a_18158_14238# 1.5403f
C1593 VDD a_21514_51140# 0.75723f
C1594 w[12] w[16] 3.44501f
C1595 a_27814_14188# a_21514_14188# 0.27118f
C1596 a_21514_81344# a_18658_81186# 0.11443f
C1597 w[11] a_18658_50982# 1.50762f
C1598 spike[4] neuron_4__VKdn 1.09349f
C1599 w[15] s[1] 3.79931f
C1600 a_92142_52130# a_91762_52130# 0.67211f
C1601 a_10219_180030# bias_0__Iref 2.50281f
C1602 w[11] s[4] 0.04109f
C1603 VMEM_3 a_91134_81984# 3.23701f
C1604 DAC_5__Isum_e VDD 25.1279f
C1605 VDD DAC_1__Isum_i 16.3832f
C1606 w[29] w[18] 0.14076f
C1607 VDD a_91514_112538# 0.14568f
C1608 trim[2] s[3] 0.10151f
C1609 spike[2] a_89872_58446# 0.52077f
C1610 w[21] w[14] 3.19326f
C1611 s[4] w[6] 0.0414f
C1612 w[8] cal 0.56395f
C1613 spike[2] neuron_4__Vlk 1.98351f
C1614 a_51826_196335# a_32646_196335# 0.05947f
C1615 VDD w[8] 1.69734f
C1616 w_144868_188170# w_146228_188170# 0.0125f
C1617 a_8859_157048# neuron_4__Vamp_bias 0.86957f
C1618 a_36214_95532# DAC_7__Vb 0.093f
C1619 a_9722_190909# a_99776_196335# 0.0602f
C1620 spike[4] VMEM_4 2.75441f
C1621 VDD neuron_4__VNA 37.4349f
C1622 trim[1] a_30675_180030# 0.02438f
C1623 a_91514_33654# spike[1] 0.04786f
C1624 w[28] w[1] 0.09493f
C1625 pulse[1] w[22] 0.24313f
C1626 a_21514_65328# a_18658_65170# 0.11443f
C1627 a_46000_171624# a_39250_171366# 36.3786f
C1628 spike[0] w[23] 0.15422f
C1629 s[2] spike[0] 1.72763f
C1630 VDD a_92770_112538# 0.17724f
C1631 a_27814_51140# a_18658_50982# 0.06004f
C1632 VMEM_2 spike[2] 2.78018f
C1633 DAC_7__Vb w[2] 1.36216f
C1634 a_23614_32664# DAC_7__Vb 0.37182f
C1635 w[26] a_23614_111548# 0.25032f
C1636 DAC_7__Vb w[25] 1.45337f
C1637 a_42236_196335# a_61416_196335# 0.05947f
C1638 a_89334_82334# neuron_4__Vamp_bias 0.05117f
C1639 w[17] spike[1] 1.06777f
C1640 w[4] w[22] 2.78639f
C1641 s[4] pulse[1] 0.70145f
C1642 a_18658_125578# a_18158_125786# 0.11824f
C1643 a_89872_39970# VT 0.05388f
C1644 neuron_4__VK a_8859_157048# 0.92881f
C1645 a_18158_81394# a_18658_81186# 0.11824f
C1646 w[17] DAC_7__Vb 1.36968f
C1647 VT neuron_4__VKup 4.53125f
C1648 a_91134_81984# a_91762_82334# 14.8965f
C1649 a_23614_14188# a_21514_14188# 0.57119f
C1650 a_64128_35280# DPI_4__Vthr 1.25838f
C1651 s[7] w[0] 0.28542f
C1652 VDD a_89334_112538# 0.22723f
C1653 w[8] w[27] 0.24956f
C1654 VMEM_3 a_89872_88650# 1.71072f
C1655 trim[3] w[7] 0.15029f
C1656 w[10] w[24] 0.11446f
C1657 w[9] w[11] 0.37818f
C1658 VDD neuron_4__Vamp_bias 8.33143f
C1659 a_36214_51140# a_17910_51190# 1.31469f
C1660 w[15] a_18658_32506# 0.0642f
C1661 VMEM_4 a_68678_126292# 6.72176f
C1662 w[4] s[4] 0.07745f
C1663 w[15] w[7] 0.109f
C1664 a_17910_125786# a_18158_125786# 1.6884f
C1665 w[9] w[6] 1.1898f
C1666 w[30] w[21] 0.13691f
C1667 s[7] trim[2] 0.12975f
C1668 neuron_4__VKdn DPI_4__Vthr 0.31226f
C1669 spike[2] spike[0] 0.07991f
C1670 VDD a_21514_95532# 0.75723f
C1671 w[21] s[3] 0.72688f
C1672 spike[0] w[14] 0.22457f
C1673 a_21514_14188# w[3] 0.56837f
C1674 w[8] s[5] 3.77684f
C1675 a_18158_65378# a_18658_65170# 0.11824f
C1676 w[20] w[22] 0.49029f
C1677 a_23614_51140# a_18658_50982# 0.05882f
C1678 a_64128_114164# DAC_1__Isum_i 0.01716f
C1679 VDD a_92142_112538# 0.15438f
C1680 a_39250_171366# cal 0.13211f
C1681 cal w[1] 1.01664f
C1682 spike[3] neuron_4__VKdn 9.72428f
C1683 VDD a_39250_171366# 2.98563f
C1684 a_89334_52130# a_91134_51780# 0.9311f
C1685 w[17] a_27814_81344# 0.08445f
C1686 VDD w[1] 0.08575f
C1687 neuron_4__VK a_92770_15178# 0.04013f
C1688 pulse[1] w[16] 0.01104f
C1689 VMEM_4 DPI_4__Vthr 3.27661f
C1690 a_89872_118854# neuron_4__VKup 3.25327f
C1691 VDD a_27814_95532# 0.26038f
C1692 w[9] a_27814_51140# 0.08445f
C1693 w[13] spike[0] 0.05515f
C1694 a_21514_81344# DAC_7__Vb 0.74342f
C1695 trim[3] w[18] 0.14974f
C1696 a_27814_51140# DAC_5__Isum_i 10.8659f
C1697 neuron_4__VK VDD 9.03041f
C1698 a_91762_33654# VT 0.10487f
C1699 DAC_7__Vb s[6] 6.96385f
C1700 a_89872_88650# a_91762_82334# 4.40172f
C1701 a_37150_170466# a_39323_180030# 2.57835f
C1702 spike[2] a_91514_52130# 0.04786f
C1703 spike[3] VMEM_4 0.21638f
C1704 neuron_4__VIp neuron_4__VKup 1.53729f
C1705 a_17910_51190# a_18158_51190# 1.6884f
C1706 a_18658_14030# s[0] 3.46922f
C1707 w[9] pulse[1] 0.23688f
C1708 DAC_7__Vb w[5] 1.6137f
C1709 w[10] s[0] 0.02871f
C1710 a_90186_196335# a_71006_196335# 0.05947f
C1711 w[11] s[1] 3.38617f
C1712 VMEM_4 a_91134_112188# 3.23701f
C1713 VDD a_18158_125786# 0.21115f
C1714 VDD a_18158_95582# 0.21115f
C1715 VDD a_68678_65884# 11.6121f
C1716 s[1] w[6] 0.28152f
C1717 a_17910_65378# spike[1] 0.04246f
C1718 a_8859_157048# DPI_4__VT 0.13964f
C1719 a_38750_170674# a_30675_180030# 1.72923f
C1720 a_89334_15178# neuron_4__Vamp_bias 0.05117f
C1721 w[9] w[4] 0.16403f
C1722 a_39250_171366# a_39850_171366# 37.1425f
C1723 w[10] w[31] 9.71159f
C1724 a_64128_53756# VMEM_2 4.24213f
C1725 a_21514_81344# a_27814_81344# 0.27118f
C1726 Imon neuron_4__VKdn 0.09015f
C1727 w[27] w[1] 0.10375f
C1728 w[12] w[7] 0.21569f
C1729 s[7] w[21] 0.05842f
C1730 VMEM_3 a_91514_82334# 0.1368f
C1731 VDD a_18658_81186# 8.84723f
C1732 spike[0] s[3] 0.06215f
C1733 a_89334_52130# a_89872_58446# 2.33814f
C1734 w[8] w[23] 0.2631f
C1735 s[4] w[22] 0.13786f
C1736 a_27814_14188# w[1] 0.08445f
C1737 VDD a_23614_95532# 0.42217f
C1738 a_21494_196237# w_151668_188170# 76.8786f
C1739 s[2] w[8] 7.79905f
C1740 a_95576_118854# a_91762_112538# 0.04621f
C1741 a_23614_51140# DAC_5__Isum_i 12.8867f
C1742 w[8] w[3] 0.13559f
C1743 s[5] w[1] 0.57057f
C1744 w[17] trim[0] 0.10957f
C1745 w[19] spike[0] 0.27806f
C1746 VDD a_32646_196335# 9.3695f
C1747 VMEM_2 a_89334_52130# 0.27205f
C1748 w[17] trim[1] 0.11108f
C1749 a_27655_180030# a_37150_170466# 0.50998f
C1750 s[1] pulse[1] 1.66288f
C1751 a_18658_14030# pulse[0] 0.37995f
C1752 a_36214_125736# DAC_1__Isum_e 6.81042f
C1753 DAC_7__Vb w[28] 6.98965f
C1754 w[12] w[18] 1.34664f
C1755 VDD a_21494_196237# 59.0596f
C1756 w[10] w[29] 8.27114f
C1757 trim[2] a_37150_170466# 0.23127f
C1758 VDD DPI_4__VT 0.14658p
C1759 a_64128_53756# spike[0] 0.10022f
C1760 a_21514_125736# DAC_7__Vb 0.74342f
C1761 a_21514_81344# a_23614_81344# 0.57119f
C1762 a_91514_82334# a_91762_82334# 1.31172f
C1763 w[11] w[7] 0.49693f
C1764 w[4] s[1] 1.18825f
C1765 a_8859_157048# DAC_7__Vb 0.48613f
C1766 w[22] w[16] 0.13551f
C1767 a_18158_95582# s[5] 0.04246f
C1768 w[7] w[6] 7.47322f
C1769 w[8] w[14] 0.84877f
C1770 VMEM_3 a_89334_82334# 0.27205f
C1771 VDD a_64578_90264# 4.65616f
C1772 spike[2] neuron_4__VNA 3.31621f
C1773 VT neuron_4__VKdn 16.7204f
C1774 a_36214_14188# a_18658_14030# 0.75055f
C1775 trim[2] w[21] 0.13544f
C1776 a_36214_81344# a_21514_81344# 0.16484f
C1777 a_21514_95532# w[23] 0.56837f
C1778 w[9] w[22] 0.13449f
C1779 a_17910_32714# w[6] 0.18228f
C1780 VDD a_94948_88650# 2.79898f
C1781 s[4] w[16] 1.33409f
C1782 VMEM_1 DAC_6__Isum_e 0.0248f
C1783 trim[2] neuron_4__Vlk 0.01971f
C1784 trim[0] s[6] 0.14034f
C1785 VDD VMEM_3 5.12132f
C1786 trim[1] s[6] 0.15959f
C1787 w[13] w[8] 5.42031f
C1788 VT VMEM_4 1.52221f
C1789 a_89872_58446# a_91134_51780# 0.68101f
C1790 w[23] w[1] 0.29267f
C1791 a_30675_180030# a_42850_171366# 3.79795f
C1792 DAC_1__Isum_e DPI_4__Vthr 2.8953f
C1793 s[2] w[1] 0.24466f
C1794 trim[1] w[5] 2.39753f
C1795 w[18] w[6] 0.0394f
C1796 w[3] w[1] 0.71407f
C1797 trim[0] w[5] 1.08554f
C1798 w_147588_188170# w_148948_188170# 0.0125f
C1799 trim_steer_0__Iref a_39323_180030# 0.05994f
C1800 a_18658_50982# DAC_5__Isum_i 0.05814f
C1801 w[9] s[4] 0.04109f
C1802 w[24] a_36214_111548# 0.04246f
C1803 VDD spike[1] 2.65813f
C1804 pulse[1] w[7] 0.38037f
C1805 a_18658_32506# pulse[1] 0.37995f
C1806 a_89872_88650# a_92142_82334# 0.01339f
C1807 spike[3] DAC_1__Isum_e 0.24584f
C1808 VDD DAC_7__Vb 25.0921f
C1809 spike[2] neuron_4__Vamp_bias 0.5752f
C1810 a_89334_52130# a_91514_52130# 0.02914f
C1811 a_91134_33304# neuron_4__VKup 0.14203f
C1812 a_17910_51190# spike[0] 0.04246f
C1813 VMEM_2 a_91134_51780# 3.23701f
C1814 a_89872_39970# a_91134_33304# 0.68101f
C1815 a_17910_32714# pulse[1] 0.04246f
C1816 VMEM_0 DAC_7__Isum_e 0.0248f
C1817 a_89872_21494# VT 0.04765f
C1818 a_95576_58446# VMEM_2 0.93986f
C1819 a_64128_114164# DPI_4__VT 1.39016f
C1820 w[4] w[7] 0.09604f
C1821 w[26] w[25] 7.51717f
C1822 a_21514_65328# a_17910_65378# 17.2602f
C1823 neuron_4__VIp neuron_4__VKdn 20.476f
C1824 w[8] w[30] 0.23055f
C1825 w[8] s[3] 0.02877f
C1826 VDD a_91762_82334# 3.9615f
C1827 s[1] w[22] 0.11498f
C1828 VMEM_4 a_89872_118854# 1.71072f
C1829 a_91514_82334# a_92770_82334# 0.26264f
C1830 w[4] a_17910_32714# 0.01848f
C1831 pulse[1] w[18] 0.03403f
C1832 spike[4] a_95576_118854# 0.28806f
C1833 w[15] a_18658_14030# 0.03158f
C1834 bias_0__Iref neuron_4__VKup 0.47351f
C1835 spike[0] a_18158_51190# 0.01869f
C1836 w[17] w[26] 0.1135f
C1837 neuron_4__VK spike[2] 0.1822f
C1838 w[10] w[15] 1.18801f
C1839 a_21514_95532# DAC_3__Isum_i 0.01896f
C1840 VDD a_27814_81344# 0.26038f
C1841 VMEM_4 neuron_4__VIp 0.34995f
C1842 a_27814_32664# DAC_6__Isum_e 2.06134f
C1843 a_91762_52130# neuron_4__VKup 0.83559f
C1844 w[27] DAC_7__Vb 1.52382f
C1845 VDD a_95576_88650# 2.94927f
C1846 w[19] w[8] 0.73882f
C1847 DAC_5__Isum_e a_64128_53756# 7.7058f
C1848 a_64578_60060# DAC_5__Isum_i 0.1543f
C1849 w[20] w[7] 0.2613f
C1850 s[4] s[1] 0.38811f
C1851 neuron_4__VKup a_94948_118854# 0.04013f
C1852 w[4] w[18] 0.03009f
C1853 a_46000_171624# trim[0] 0.18342f
C1854 w[13] w[1] 0.10166f
C1855 a_46000_171624# trim[1] 0.17618f
C1856 a_27655_180030# trim_steer_0__Iref 0.06269f
C1857 a_27814_14188# DAC_7__Vb 0.18591f
C1858 a_91134_33304# a_91762_33654# 14.8965f
C1859 VMEM_2 a_89872_58446# 1.71072f
C1860 s[5] spike[1] 1.32712f
C1861 a_27814_95532# DAC_3__Isum_i 10.8659f
C1862 a_92142_52130# neuron_4__VKdn 0.04013f
C1863 a_8859_157048# trim[0] 0.07758f
C1864 trim[2] trim_steer_0__Iref 0.1626f
C1865 VMEM_2 neuron_4__Vlk 0.27856f
C1866 DAC_7__Vb s[5] 6.58253f
C1867 a_64128_83960# a_68678_96088# 0.15017f
C1868 a_109366_196335# a_99776_196335# 4.14183f
C1869 a_18158_32714# DAC_6__Isum_e 2.10366f
C1870 a_18158_65378# a_17910_65378# 1.6884f
C1871 s[7] DAC_1__Isum_i 0.01848f
C1872 a_91514_82334# a_92142_82334# 1.82301f
C1873 a_91514_52130# a_91134_51780# 0.60758f
C1874 w[26] s[6] 1.92466f
C1875 a_92142_33654# a_92770_33654# 1.47502f
C1876 VDD a_23614_81344# 0.42217f
C1877 w[17] a_17910_81394# 0.10002f
C1878 a_36214_51140# a_21514_51140# 0.16484f
C1879 w[8] s[7] 0.17477f
C1880 w[22] w[7] 0.10691f
C1881 a_18158_95582# DAC_3__Isum_i 1.32914f
C1882 s[3] w[1] 0.02841f
C1883 w[30] w[1] 0.09482f
C1884 DAC_5__Isum_e a_36214_51140# 6.81042f
C1885 a_17910_111598# a_21514_111548# 17.2602f
C1886 trim_steer_0__Iref a_37150_170466# 0.03852f
C1887 a_17910_51190# a_21514_51140# 17.2602f
C1888 VDD a_92770_82334# 0.17724f
C1889 a_18658_81186# DAC_3__Isum_i 0.05814f
C1890 VDD a_99776_196335# 5.13931f
C1891 w[24] w[2] 0.10087f
C1892 VMEM_1 DPI_4__Vthr 0.15115f
C1893 VMEM_0 neuron_4__Vlk 0.22231f
C1894 w[24] w[25] 24.6957f
C1895 w[9] s[1] 0.39643f
C1896 trim[1] cal 13.4516f
C1897 trim[0] cal 13.0489f
C1898 spike[0] neuron_4__Vlk 1.9648f
C1899 a_36214_51140# w[8] 0.04246f
C1900 VDD a_36214_81344# 0.19093f
C1901 VDD trim[0] 7.52018f
C1902 a_23614_95532# DAC_3__Isum_i 12.8867f
C1903 a_18158_14238# DAC_7__Isum_e 2.10366f
C1904 a_23614_14188# DAC_7__Vb 0.37182f
C1905 trim[1] VDD 1.74088f
C1906 s[4] w[7] 0.18088f
C1907 DAC_5__Isum_e a_17910_51190# 0.07931f
C1908 spike[2] DPI_4__VT 0.30329f
C1909 w[19] w[1] 0.25178f
C1910 a_42250_171366# a_30675_180030# 0.06672f
C1911 VDD a_21514_65328# 0.75723f
C1912 a_17910_51190# w[8] 0.01848f
C1913 VMEM_2 spike[0] 0.01686f
C1914 w[17] w[24] 0.10571f
C1915 w[22] w[18] 0.13965f
C1916 spike[1] w[23] 5.14947f
C1917 s[2] spike[1] 0.28857f
C1918 a_91762_52130# a_94948_58446# 0.37248f
C1919 DAC_7__Vb w[23] 1.53397f
C1920 s[2] DAC_7__Vb 8.12448f
C1921 a_17910_81394# a_21514_81344# 17.2602f
C1922 DAC_7__Vb w[3] 1.76702f
C1923 a_91514_52130# a_89872_58446# 0.09468f
C1924 a_89334_52130# neuron_4__Vamp_bias 0.05117f
C1925 w[8] w[0] 0.07722f
C1926 VMEM_0 a_91762_15178# 0.29575f
C1927 DAC_5__Isum_e a_18158_51190# 2.10366f
C1928 spike[0] a_91762_15178# 9.68412f
C1929 s[4] w[18] 31.2188f
C1930 w[4] a_36214_32664# 0.04246f
C1931 w[26] w[28] 0.14632f
C1932 a_68678_96088# DPI_4__Vthr 1.72364f
C1933 a_39850_171366# trim[0] 0.08824f
C1934 VMEM_2 a_91514_52130# 0.1368f
C1935 a_39250_171366# a_39323_180030# 0.31813f
C1936 VDD a_92142_82334# 0.15438f
C1937 w[10] w[11] 10.2319f
C1938 trim[1] a_39850_171366# 0.50274f
C1939 VMEM_3 spike[2] 0.24465f
C1940 w[8] trim[2] 0.1531f
C1941 w[16] w[7] 0.24068f
C1942 a_64578_90264# DAC_3__Isum_i 0.1544f
C1943 w[10] w[6] 0.22824f
C1944 w[2] s[0] 0.28682f
C1945 a_51826_196335# a_71006_196335# 0.05947f
C1946 s[7] w[1] 0.20246f
C1947 VMEM_0 spike[0] 2.78018f
C1948 w[19] a_18658_81186# 1.50762f
C1949 a_64128_53756# a_68678_65884# 0.15017f
C1950 spike[2] spike[1] 6.83685f
C1951 w[14] spike[1] 0.28186f
C1952 w[31] w[2] 1.04037f
C1953 a_91134_51780# neuron_4__VNA 0.16874f
C1954 trim[0] s[5] 0.13167f
C1955 w[24] s[6] 1.22724f
C1956 trim[1] s[5] 0.15823f
C1957 w[9] w[7] 0.58754f
C1958 a_91134_14828# a_91762_15178# 14.8965f
C1959 VMEM_3 DAC_3__Isum_i 0.58594f
C1960 VDD a_18158_65378# 0.21115f
C1961 spike[2] DAC_7__Vb 0.28588f
C1962 w[14] DAC_7__Vb 3.839f
C1963 a_95576_58446# neuron_4__VNA 0.04168f
C1964 bias_0__Iref neuron_4__VKdn 0.22866f
C1965 w[15] a_18658_65170# 1.53153f
C1966 a_17910_81394# a_18158_81394# 1.6884f
C1967 w[17] w[31] 0.13043f
C1968 a_89872_39970# neuron_4__VKup 3.24846f
C1969 w[24] w[5] 0.11189f
C1970 w[16] w[18] 0.21817f
C1971 w[13] spike[1] 0.26503f
C1972 a_8859_157048# bias_0__VT_inh 0.15431f
C1973 s[7] a_18158_125786# 0.04246f
C1974 spike[0] a_91134_14828# 0.14351f
C1975 VMEM_0 a_91134_14828# 3.23701f
C1976 w[13] DAC_7__Vb 1.95242f
C1977 a_94948_21494# a_91762_15178# 0.37248f
C1978 w[10] pulse[1] 0.58891f
C1979 a_33687_180030# a_30675_180030# 0.54719f
C1980 w[9] w[18] 0.06636f
C1981 w[1] w[0] 6.90386f
C1982 w[2] pulse[0] 0.08662f
C1983 a_91134_51780# neuron_4__Vamp_bias 0.11043f
C1984 a_27655_180030# a_39250_171366# 0.08731f
C1985 a_64128_53756# DPI_4__VT 1.39074f
C1986 w_87138_170254# trim_steer_0__Iref 0.02077f
C1987 VMEM_4 a_94948_118854# 0.12888f
C1988 VDD a_38750_170674# 0.426f
C1989 w[29] w[2] 0.10328f
C1990 w[26] cal 0.1629f
C1991 a_38750_170674# cal 0.02438f
C1992 VDD w[26] 0.15811f
C1993 w[10] w[4] 0.07675f
C1994 a_94948_21494# spike[0] 1.98323f
C1995 a_94948_21494# VMEM_0 0.12888f
C1996 a_17910_14238# pulse[0] 0.04246f
C1997 a_89872_58446# neuron_4__VNA 0.33658f
C1998 s[1] w[7] 0.26839f
C1999 neuron_4__Vlk neuron_4__VNA 9.95597f
C2000 s[1] a_18658_32506# 3.46922f
C2001 VMEM_1 VT 1.62434f
C2002 w[17] w[29] 0.12321f
C2003 DAC_5__Isum_e VMEM_2 0.0248f
C2004 spike[3] a_91134_81984# 0.14351f
C2005 a_27814_81344# DAC_3__Isum_i 10.8659f
C2006 a_91762_33654# neuron_4__VKup 0.83583f
C2007 w[10] a_23614_51140# 0.25032f
C2008 VDD a_91762_112538# 3.95827f
C2009 a_89872_39970# a_91762_33654# 4.40172f
C2010 s[3] spike[1] 1.50855f
C2011 s[0] w[5] 0.46734f
C2012 w[31] s[6] 0.15784f
C2013 w[30] DAC_7__Vb 1.3063f
C2014 VDD bias_0__VT_inh 21.1508f
C2015 s[3] DAC_7__Vb 6.61618f
C2016 trim[1] s[2] 5.9783f
C2017 s[2] trim[0] 0.13818f
C2018 a_18658_125578# a_23614_125736# 0.05882f
C2019 VMEM_2 neuron_4__VNA 0.05607f
C2020 a_42236_196335# a_8522_190701# 0.18346f
C2021 a_46000_171624# a_42850_171366# 0.66483f
C2022 w[31] w[5] 0.69273f
C2023 a_37150_170466# a_39250_171366# 0.36746f
C2024 w[19] spike[1] 0.17315f
C2025 a_36214_14188# a_17910_14238# 1.31469f
C2026 a_38750_170674# a_39850_171366# 0.04615f
C2027 VDD a_64578_120468# 4.6034f
C2028 w[27] w[26] 9.4882f
C2029 w[19] DAC_7__Vb 6.30053f
C2030 a_21514_125736# a_23614_125736# 0.57119f
C2031 a_17910_125786# a_23614_125736# 15.0391f
C2032 a_89872_58446# neuron_4__Vamp_bias 0.04996f
C2033 a_91762_15178# neuron_4__VNA 0.40633f
C2034 a_17910_111598# a_18158_111598# 1.6884f
C2035 a_64128_53756# spike[1] 0.7572f
C2036 a_94948_58446# neuron_4__VKup 0.04013f
C2037 neuron_4__Vamp_bias neuron_4__Vlk 1.61957f
C2038 VDD a_17910_81394# 0.54717f
C2039 DAC_5__Isum_e a_36214_65328# 6.81042f
C2040 w[26] s[5] 0.12436f
C2041 DAC_1__Isum_i a_27814_125736# 10.8659f
C2042 w[29] s[6] 0.15062f
C2043 w[8] spike[0] 0.32357f
C2044 spike[3] a_89872_88650# 0.52077f
C2045 w[14] trim[0] 0.16532f
C2046 trim[1] w[14] 0.18389f
C2047 spike[0] neuron_4__VNA 0.03439f
C2048 VMEM_2 neuron_4__Vamp_bias 1.86123f
C2049 VMEM_1 neuron_4__VIp 0.25159f
C2050 a_23614_81344# DAC_3__Isum_i 12.8867f
C2051 a_36214_125736# a_18658_125578# 0.75055f
C2052 w[10] w[22] 0.11807f
C2053 a_18658_32506# w[7] 1.53009f
C2054 a_61416_196335# a_51826_196335# 4.14188f
C2055 VDD DAC_6__Isum_e 19.3403f
C2056 pulse[0] w[5] 0.81983f
C2057 a_18658_125578# w[31] 1.50762f
C2058 w[29] w[5] 0.11153f
C2059 a_27814_95532# w[21] 0.08445f
C2060 neuron_4__VK a_92770_33654# 0.04013f
C2061 a_36214_125736# w[28] 0.04246f
C2062 w_150308_188170# w_148948_188170# 0.0125f
C2063 VDD a_71006_196335# 5.14773f
C2064 spike[3] s[6] 0.26827f
C2065 w[31] w[28] 0.08777f
C2066 VDD w[24] 1.78827f
C2067 a_17910_32714# w[7] 0.364f
C2068 w[13] trim[0] 5.02998f
C2069 a_18658_32506# a_17910_32714# 0.10497f
C2070 neuron_4__VK neuron_4__Vlk 13.093f
C2071 a_36214_81344# DAC_3__Isum_i 0.11679f
C2072 s[7] DAC_7__Vb 6.61334f
C2073 trim[1] w[13] 0.13054f
C2074 cal a_42850_171366# 0.19941f
C2075 a_91762_15178# neuron_4__Vamp_bias 0.06072f
C2076 a_80596_196335# a_90186_196335# 4.1419f
C2077 a_17910_125786# a_36214_125736# 1.31469f
C2078 VDD a_42850_171366# 2.84533f
C2079 w[15] w[2] 0.09253f
C2080 w[10] s[4] 0.0484f
C2081 w[15] w[25] 0.16598f
C2082 a_21514_125736# a_36214_125736# 0.16484f
C2083 a_17910_125786# w[31] 0.364f
C2084 a_21514_125736# w[31] 0.56837f
C2085 w[17] trim[3] 0.14338f
C2086 a_91134_14828# neuron_4__VNA 0.16942f
C2087 neuron_4__VK VMEM_2 0.24026f
C2088 VDD a_23614_125736# 0.42217f
C2089 a_36214_51140# DAC_7__Vb 0.093f
C2090 w[17] w[15] 0.0298f
C2091 w[18] w[7] 0.22623f
C2092 spike[0] neuron_4__Vamp_bias 0.25305f
C2093 VMEM_0 neuron_4__Vamp_bias 1.67525f
C2094 a_23614_111548# a_21514_111548# 0.57119f
C2095 neuron_4__VKdn neuron_4__VKup 11.4413f
C2096 VDD a_64128_83960# 11.6326f
C2097 a_91134_81984# VT 0.51506f
C2098 w[29] w[28] 29.6042f
C2099 VMEM_4 neuron_4__VKup 0.07632f
C2100 w[24] w[27] 0.08777f
C2101 trim[1] s[3] 0.10688f
C2102 VDD spike[4] 1.82099f
C2103 s[2] w[26] 0.10812f
C2104 s[3] trim[0] 0.09909f
C2105 VMEM_2 a_68678_65884# 6.4108f
C2106 a_39850_171366# a_42850_171366# 0.12869f
C2107 a_95576_39970# a_91762_33654# 0.04621f
C2108 DAC_7__Vb w[0] 7.12073f
C2109 VDD s[0] 1.66971f
C2110 a_18658_125578# spike[3] 0.37995f
C2111 a_17910_125786# w[29] 0.10002f
C2112 spike[3] a_91514_82334# 0.04786f
C2113 a_91134_14828# neuron_4__Vamp_bias 0.0814f
C2114 w_87818_180350# a_30675_180030# 0.32043f
C2115 neuron_4__VK spike[0] 0.13411f
C2116 neuron_4__VK VMEM_0 0.18675f
C2117 a_36214_125736# VDD 0.19093f
C2118 w[24] s[5] 0.13093f
C2119 w[31] cal 13.7428f
C2120 spike[3] w[28] 0.08662f
C2121 trim[3] s[6] 0.16262f
C2122 VDD w[31] 0.34549f
C2123 a_8859_157048# DPI_4__Vthr 12.3204f
C2124 w[10] w[9] 20.003f
C2125 w[12] w[25] 0.13276f
C2126 w[15] s[6] 0.07762f
C2127 a_17910_125786# spike[3] 0.04246f
C2128 neuron_4__Vlk DPI_4__VT 0.2433f
C2129 trim_steer_0__Iref a_39250_171366# 0.085f
C2130 a_46000_171624# a_42250_171366# 0.73055f
C2131 trim[3] w[5] 0.71487f
C2132 a_89872_21494# neuron_4__VKup 3.24422f
C2133 w[20] a_17910_95582# 0.01848f
C2134 a_89334_33654# VT 0.26497f
C2135 spike[2] w[26] 0.08662f
C2136 w[14] w[26] 0.16621f
C2137 w[17] w[12] 0.2027f
C2138 w[15] w[5] 2.23984f
C2139 a_27814_65328# DAC_5__Isum_i 10.8659f
C2140 a_91514_33654# neuron_4__VIp 0.04013f
C2141 VMEM_2 DPI_4__VT 0.92408f
C2142 VDD a_68678_126292# 11.6889f
C2143 w_146908_198022# w_148268_198022# 0.0125f
C2144 spike[0] a_18658_81186# 0.37995f
C2145 a_92770_112538# a_91514_112538# 0.26264f
C2146 w[15] a_17910_65378# 0.364f
C2147 VDD pulse[0] 0.0889f
C2148 s[7] trim[0] 48.6006f
C2149 VDD w[29] 0.23091f
C2150 trim[1] s[7] 0.12637f
C2151 a_18158_65378# s[3] 0.04246f
C2152 VMEM_3 neuron_4__Vlk 0.29155f
C2153 VMEM_1 a_91134_33304# 3.23701f
C2154 VDD DPI_4__Vthr 0.13325p
C2155 a_18658_32506# a_36214_32664# 0.75055f
C2156 s[1] a_18658_14030# 0.09931f
C2157 w[11] w[2] 0.52062f
C2158 w[10] s[1] 0.096f
C2159 w[11] w[25] 0.46578f
C2160 a_17910_95582# w[22] 0.18228f
C2161 w[21] spike[1] 0.08662f
C2162 a_92770_33654# spike[1] 1.13486f
C2163 w[21] DAC_7__Vb 1.51352f
C2164 a_21514_111548# a_36214_111548# 0.16484f
C2165 w[31] s[5] 0.14953f
C2166 w[24] w[23] 19.3375f
C2167 a_23614_32664# w[6] 0.25032f
C2168 w[2] w[6] 1.22001f
C2169 a_61416_196335# VDD 5.14968f
C2170 a_17910_32714# a_36214_32664# 1.31469f
C2171 neuron_4__Vlk spike[1] 1.96098f
C2172 a_89334_112538# a_91514_112538# 0.02914f
C2173 w[25] w[6] 0.59308f
C2174 s[2] w[24] 2.67808f
C2175 VDD spike[3] 5.42779f
C2176 a_42250_171366# cal 0.67966f
C2177 bias_0__Iref a_30675_180030# 3.30314f
C2178 VMEM_0 DPI_4__VT 0.64172f
C2179 a_42250_171366# VDD 2.86889f
C2180 w[24] w[3] 0.11164f
C2181 DAC_7__Vb neuron_4__Vlk 23.0622f
C2182 spike[0] DPI_4__VT 2.56196f
C2183 a_46000_171624# trim[3] 0.19672f
C2184 w[12] s[6] 0.28932f
C2185 w[15] w[28] 0.14825f
C2186 a_27814_111548# a_21514_111548# 0.27118f
C2187 VDD a_36214_14188# 0.30771f
C2188 a_23614_65328# DAC_5__Isum_i 12.8867f
C2189 VDD a_91134_112188# 6.1012f
C2190 pulse[1] a_18158_32714# 0.01869f
C2191 VMEM_2 spike[1] 0.34885f
C2192 a_8859_157048# trim[3] 0.012f
C2193 a_18658_111390# a_21514_111548# 0.11443f
C2194 neuron_4__Vamp_bias neuron_4__VNA 7.10768f
C2195 w[30] w[26] 0.15859f
C2196 a_92142_112538# a_91514_112538# 1.82301f
C2197 s[3] w[26] 0.1013f
C2198 a_95576_118854# a_94948_118854# 0.53841f
C2199 trim_steer_0__Iref a_21494_196237# 19.3841f
C2200 w[3] VSS 13.9336f
C2201 w[2] VSS 8.07576f
C2202 w[1] VSS 6.84962f
C2203 w[0] VSS 5.0775f
C2204 pulse[0] VSS 6.72922f
C2205 s[0] VSS 22.1874f
C2206 w[7] VSS 19.9215f
C2207 w[6] VSS 9.60774f
C2208 w[5] VSS 10.7317f
C2209 w[4] VSS 7.10725f
C2210 pulse[1] VSS 8.13968f
C2211 s[1] VSS 29.1228f
C2212 w[11] VSS 17.1323f
C2213 w[10] VSS 8.4669f
C2214 w[9] VSS 8.67552f
C2215 w[8] VSS 13.5343f
C2216 s[2] VSS 28.9291f
C2217 w[15] VSS 24.7287f
C2218 w[14] VSS 14.9526f
C2219 w[13] VSS 12.8879f
C2220 w[12] VSS 8.98547f
C2221 s[3] VSS 29.3082f
C2222 w[19] VSS 20.6281f
C2223 w[18] VSS 10.6617f
C2224 w[17] VSS 8.15284f
C2225 w[16] VSS 9.707f
C2226 spike[0] VSS 58.2755f
C2227 s[4] VSS 25.8263f
C2228 w[23] VSS 17.286f
C2229 w[22] VSS 12.8961f
C2230 w[21] VSS 22.5211f
C2231 w[20] VSS 11.0859f
C2232 spike[1] VSS 61.3569f
C2233 s[5] VSS 28.7372f
C2234 VT VSS 32.8054f
C2235 w[27] VSS 18.7944f
C2236 w[26] VSS 14.5606f
C2237 w[25] VSS 13.7107f
C2238 w[24] VSS 12.13f
C2239 spike[2] VSS 63.2875f
C2240 spike[4] VSS 32.6308f
C2241 s[6] VSS 32.0003f
C2242 w[31] VSS 19.6664f
C2243 w[30] VSS 11.5713f
C2244 w[29] VSS 10.6158f
C2245 w[28] VSS 11.2635f
C2246 spike[3] VSS 51.0164f
C2247 s[7] VSS 28.2034f
C2248 Imon VSS 58.8398f
C2249 cal VSS 24.5938f
C2250 trim[3] VSS 20.1621f
C2251 trim[2] VSS 17.7815f
C2252 trim[1] VSS 20.4489f
C2253 trim[0] VSS 32.7285f
C2254 VDD VSS 7.18546p
C2255 a_92770_15178# VSS 4.53886f $ **FLOATING
C2256 a_92142_15178# VSS 3.65994f $ **FLOATING
C2257 a_91514_15178# VSS 5.91238f $ **FLOATING
C2258 a_89334_15178# VSS 5.03265f $ **FLOATING
C2259 a_64128_16804# VSS 10.0384f $ **FLOATING
C2260 a_36214_14188# VSS 5.10168f $ **FLOATING
C2261 a_27814_14188# VSS 9.33535f $ **FLOATING
C2262 a_23614_14188# VSS 16.5225f $ **FLOATING
C2263 a_21514_14188# VSS 43.9107f $ **FLOATING
C2264 a_18158_14238# VSS 2.88389f $ **FLOATING
C2265 a_17910_14238# VSS 9.72397f $ **FLOATING
C2266 a_95576_21494# VSS 0.1558f $ **FLOATING
C2267 VMEM_0 VSS 26.8453f $ **FLOATING
C2268 a_94948_21494# VSS 0.36469f $ **FLOATING
C2269 a_91762_15178# VSS 4.58991f $ **FLOATING
C2270 a_91134_14828# VSS 7.32214f $ **FLOATING
C2271 a_89872_21494# VSS 4.47027f $ **FLOATING
C2272 a_18658_14030# VSS 9.759f $ **FLOATING
C2273 a_92770_33654# VSS 4.53886f $ **FLOATING
C2274 a_92142_33654# VSS 3.65994f $ **FLOATING
C2275 a_91514_33654# VSS 5.91238f $ **FLOATING
C2276 a_89334_33654# VSS 5.03265f $ **FLOATING
C2277 a_64128_35280# VSS 10.0299f $ **FLOATING
C2278 a_36214_32664# VSS 5.10168f $ **FLOATING
C2279 a_27814_32664# VSS 9.33535f $ **FLOATING
C2280 a_23614_32664# VSS 16.5225f $ **FLOATING
C2281 a_21514_32664# VSS 43.9107f $ **FLOATING
C2282 a_18158_32714# VSS 2.88389f $ **FLOATING
C2283 a_17910_32714# VSS 9.72397f $ **FLOATING
C2284 a_95576_39970# VSS 0.1558f $ **FLOATING
C2285 VMEM_1 VSS 26.0351f $ **FLOATING
C2286 a_94948_39970# VSS 0.36469f $ **FLOATING
C2287 a_91762_33654# VSS 4.5942f $ **FLOATING
C2288 a_91134_33304# VSS 7.32943f $ **FLOATING
C2289 a_89872_39970# VSS 4.47244f $ **FLOATING
C2290 a_18658_32506# VSS 9.82566f $ **FLOATING
C2291 a_92770_52130# VSS 4.53886f $ **FLOATING
C2292 a_92142_52130# VSS 3.65994f $ **FLOATING
C2293 a_91514_52130# VSS 5.91238f $ **FLOATING
C2294 a_89334_52130# VSS 5.03265f $ **FLOATING
C2295 a_64128_53756# VSS 9.65104f $ **FLOATING
C2296 a_36214_51140# VSS 5.10168f $ **FLOATING
C2297 a_27814_51140# VSS 9.33535f $ **FLOATING
C2298 a_23614_51140# VSS 16.5225f $ **FLOATING
C2299 a_21514_51140# VSS 43.9107f $ **FLOATING
C2300 a_18158_51190# VSS 2.88389f $ **FLOATING
C2301 a_17910_51190# VSS 9.72397f $ **FLOATING
C2302 a_95576_58446# VSS 0.1558f $ **FLOATING
C2303 a_94948_58446# VSS 0.36469f $ **FLOATING
C2304 a_91762_52130# VSS 4.58414f $ **FLOATING
C2305 a_91134_51780# VSS 7.32662f $ **FLOATING
C2306 a_89872_58446# VSS 4.47298f $ **FLOATING
C2307 VMEM_2 VSS 34.5813f $ **FLOATING
C2308 a_18658_50982# VSS 9.86915f $ **FLOATING
C2309 a_64578_60060# VSS 16.6474f $ **FLOATING
C2310 a_68678_65884# VSS 13.0328f $ **FLOATING
C2311 a_36214_65328# VSS 5.10168f $ **FLOATING
C2312 a_27814_65328# VSS 9.33535f $ **FLOATING
C2313 a_23614_65328# VSS 16.5225f $ **FLOATING
C2314 a_21514_65328# VSS 43.9107f $ **FLOATING
C2315 a_18158_65378# VSS 2.88389f $ **FLOATING
C2316 a_17910_65378# VSS 9.72397f $ **FLOATING
C2317 a_18658_65170# VSS 9.83189f $ **FLOATING
C2318 a_92770_82334# VSS 4.53886f $ **FLOATING
C2319 a_92142_82334# VSS 3.65994f $ **FLOATING
C2320 a_91514_82334# VSS 5.91238f $ **FLOATING
C2321 a_89334_82334# VSS 5.03265f $ **FLOATING
C2322 a_64128_83960# VSS 10.3126f $ **FLOATING
C2323 a_36214_81344# VSS 5.10168f $ **FLOATING
C2324 a_27814_81344# VSS 9.33535f $ **FLOATING
C2325 a_23614_81344# VSS 16.5225f $ **FLOATING
C2326 a_21514_81344# VSS 43.9107f $ **FLOATING
C2327 a_18158_81394# VSS 2.88389f $ **FLOATING
C2328 a_17910_81394# VSS 9.72397f $ **FLOATING
C2329 a_95576_88650# VSS 0.1558f $ **FLOATING
C2330 a_94948_88650# VSS 0.36469f $ **FLOATING
C2331 a_91762_82334# VSS 4.58317f $ **FLOATING
C2332 a_91134_81984# VSS 7.32659f $ **FLOATING
C2333 a_89872_88650# VSS 4.47326f $ **FLOATING
C2334 VMEM_3 VSS 40.0317f $ **FLOATING
C2335 a_18658_81186# VSS 9.83774f $ **FLOATING
C2336 a_64578_90264# VSS 16.6474f $ **FLOATING
C2337 a_68678_96088# VSS 13.0606f $ **FLOATING
C2338 a_36214_95532# VSS 5.10168f $ **FLOATING
C2339 a_27814_95532# VSS 9.33535f $ **FLOATING
C2340 a_23614_95532# VSS 16.5225f $ **FLOATING
C2341 a_21514_95532# VSS 43.9107f $ **FLOATING
C2342 a_18158_95582# VSS 2.88389f $ **FLOATING
C2343 a_17910_95582# VSS 9.72397f $ **FLOATING
C2344 a_18658_95374# VSS 9.83776f $ **FLOATING
C2345 a_92770_112538# VSS 4.53886f $ **FLOATING
C2346 a_92142_112538# VSS 3.65994f $ **FLOATING
C2347 a_91514_112538# VSS 5.91238f $ **FLOATING
C2348 a_89334_112538# VSS 5.03265f $ **FLOATING
C2349 a_64128_114164# VSS 9.57255f $ **FLOATING
C2350 a_36214_111548# VSS 5.10168f $ **FLOATING
C2351 a_27814_111548# VSS 9.33535f $ **FLOATING
C2352 a_23614_111548# VSS 16.5225f $ **FLOATING
C2353 a_21514_111548# VSS 43.9107f $ **FLOATING
C2354 a_18158_111598# VSS 2.88389f $ **FLOATING
C2355 a_17910_111598# VSS 9.72397f $ **FLOATING
C2356 a_95576_118854# VSS 0.1558f $ **FLOATING
C2357 a_94948_118854# VSS 0.36469f $ **FLOATING
C2358 a_91762_112538# VSS 4.54974f $ **FLOATING
C2359 a_91134_112188# VSS 7.15486f $ **FLOATING
C2360 a_89872_118854# VSS 4.4492f $ **FLOATING
C2361 VMEM_4 VSS 36.4585f $ **FLOATING
C2362 a_18658_111390# VSS 9.83382f $ **FLOATING
C2363 a_64578_120468# VSS 16.6336f $ **FLOATING
C2364 a_68678_126292# VSS 12.9227f $ **FLOATING
C2365 a_36214_125736# VSS 5.10168f $ **FLOATING
C2366 a_27814_125736# VSS 9.33535f $ **FLOATING
C2367 a_23614_125736# VSS 16.5225f $ **FLOATING
C2368 a_21514_125736# VSS 43.9107f $ **FLOATING
C2369 a_18158_125786# VSS 2.88389f $ **FLOATING
C2370 a_17910_125786# VSS 9.72397f $ **FLOATING
C2371 a_18658_125578# VSS 9.8272f $ **FLOATING
C2372 a_72340_144600# VSS 16.4811f $ **FLOATING
C2373 bias_0__VT_inh VSS 36.9411f $ **FLOATING
C2374 neuron_4__Vlk VSS 87.2596f $ **FLOATING
C2375 neuron_4__VNA VSS 46.1015f $ **FLOATING
C2376 neuron_4__VKup VSS 44.603f $ **FLOATING
C2377 DPI_4__VT VSS 0.11708p $ **FLOATING
C2378 DPI_4__Vthr VSS 0.10456p $ **FLOATING
C2379 neuron_4__VIp VSS 41.8009f $ **FLOATING
C2380 neuron_4__Vamp_bias VSS 64.237f $ **FLOATING
C2381 neuron_4__VK VSS 83.02921f $ **FLOATING
C2382 DAC_7__Vb VSS 0.71991p $ **FLOATING
C2383 neuron_4__VKdn VSS 66.9746f $ **FLOATING
C2384 a_8859_157048# VSS 14.8111f $ **FLOATING
C2385 a_38750_170674# VSS 9.92743f $ **FLOATING
C2386 bias_0__Iref VSS 0.14941p $ **FLOATING
C2387 a_37150_170466# VSS 28.5125f $ **FLOATING
C2388 a_46000_171624# VSS 26.2609f $ **FLOATING
C2389 a_42850_171366# VSS 8.43238f $ **FLOATING
C2390 a_42250_171366# VSS 7.38079f $ **FLOATING
C2391 a_39850_171366# VSS 7.21812f $ **FLOATING
C2392 a_39250_171366# VSS 7.37694f $ **FLOATING
C2393 a_39323_180030# VSS 4.44534f $ **FLOATING
C2394 a_33687_180030# VSS 2.89076f $ **FLOATING
C2395 a_30675_180030# VSS 2.99155f $ **FLOATING
C2396 a_27655_180030# VSS 3.76101f $ **FLOATING
C2397 a_10219_180030# VSS 2.16055f $ **FLOATING
C2398 a_9722_190909# VSS 0.14209p $ **FLOATING
C2399 a_109366_196335# VSS 2.25635f $ **FLOATING
C2400 a_99776_196335# VSS 2.25669f $ **FLOATING
C2401 a_90186_196335# VSS 2.25669f $ **FLOATING
C2402 a_80596_196335# VSS 2.25669f $ **FLOATING
C2403 a_71006_196335# VSS 2.25669f $ **FLOATING
C2404 a_61416_196335# VSS 2.25669f $ **FLOATING
C2405 a_51826_196335# VSS 2.25669f $ **FLOATING
C2406 a_42236_196335# VSS 2.48214f $ **FLOATING
C2407 a_32646_196335# VSS 2.34173f $ **FLOATING
C2408 a_8522_190701# VSS 0.31151p $ **FLOATING
C2409 a_21494_196237# VSS 65.2067f $ **FLOATING
C2410 DAC_7__Isum_e VSS 17.2482f $ **FLOATING
C2411 DAC_6__Isum_e VSS 17.3512f $ **FLOATING
C2412 DAC_5__Isum_e VSS 21.8068f $ **FLOATING
C2413 DAC_5__Isum_i VSS 28.703f $ **FLOATING
C2414 DAC_3__Isum_e VSS 24.685f $ **FLOATING
C2415 DAC_3__Isum_i VSS 31.2965f $ **FLOATING
C2416 DAC_1__Isum_e VSS 23.6823f $ **FLOATING
C2417 DAC_1__Isum_i VSS 29.6521f $ **FLOATING
C2418 w_87818_180350# VSS 31.3809f $ **FLOATING
C2419 w_87138_170254# VSS 0.67747f $ **FLOATING
C2420 trim_steer_0__Iref VSS 34.2974f $ **FLOATING
C2421 w_86458_180350# VSS 0.6716f $ **FLOATING
C2422 w_151668_188170# VSS 22.0936f $ **FLOATING
C2423 w_150988_198022# VSS 0.67747f $ **FLOATING
C2424 w_150308_188170# VSS 0.66779f $ **FLOATING
C2425 w_149628_198022# VSS 0.66779f $ **FLOATING
C2426 w_148948_188170# VSS 0.66779f $ **FLOATING
C2427 w_148268_198022# VSS 0.66779f $ **FLOATING
C2428 w_147588_188170# VSS 0.66779f $ **FLOATING
C2429 w_146908_198022# VSS 0.66779f $ **FLOATING
C2430 w_146228_188170# VSS 0.66779f $ **FLOATING
C2431 w_145548_198022# VSS 0.668f $ **FLOATING
C2432 w_144868_188170# VSS 0.68859f $ **FLOATING
C2433 w_144188_198024# VSS 0.67755f $ **FLOATING
.ends
