* NGSPICE file created from SNN_signed_flat__ext - technology: gf180mcuD

.subckt SNN_signed_flat w[31] w[30] w[29] w[28] w[27] w[26] w[25] w[24] w[23] w[22]  w[21] w[20] w[19] w[18] w[17] w[16] w[15] w[14] w[13] w[12] w[11] w[10] w[9] w[8]  w[7] w[6] w[5] w[4] w[3] w[2] w[1] w[0] s[7] s[6] s[5] s[4] s[3] s[2] s[1] s[0]  pulse[1] pulse[0] VDD VSS Iref VT spike[4] spike[3] spike[2] spike[1] spike[0]
X8 a_89378_81648# neuron_4__VK VSS VSS nfet_03v3 ad=0.6p pd=3.2u as=0.6p ps=3.2u w=1u l=1u
X12 a_16310_94896# w[22] a_22014_94846# VSS nfet_03v3 ad=0.14p pd=1.06u as=0.3p ps=2.2u w=0.5u l=0.64u
X20 VDD s[1] a_16558_32028# VSS nfet_03v3 ad=0.3p pd=2.2u as=0.3p ps=2.2u w=0.5u l=0.64u
X24 VDD DPI_4__Vthr DPI_4__Vthr VDD pfet_03v3 ad=0.14p pd=1.06u as=0.14p ps=1.06u w=0.5u l=0.64u
X27 a_16310_94896# w[23] a_19914_94846# VSS nfet_03v3 ad=0.14p pd=1.06u as=0.14p ps=1.06u w=0.5u l=0.64u
X32 VDD bias_0__VT_inh bias_0__VT_inh VDD pfet_03v3 ad=0.528p pd=2.96u as=0.2464p ps=1.44u w=0.88u l=1.12u
X39 a_19914_50454# DAC_7__Vb VSS VSS nfet_03v3 ad=0.6p pd=3.2u as=0.6p ps=3.2u w=1u l=8u
X44 neuron_4__VIp neuron_4__VIp VSS VSS nfet_03v3 ad=0.6p pd=3.2u as=0.6p ps=3.2u w=1u l=1u
X46 a_67078_123924# a_67078_123924# DAC_1__Isum_i DAC_1__Isum_i nfet_03v3 ad=0.3p pd=2.2u as=0.3p ps=2.2u w=0.5u l=0.64u
X52 VDD DPI_4__Vthr DPI_4__Vthr VDD pfet_03v3 ad=0.14p pd=1.06u as=0.14p ps=1.06u w=0.5u l=0.64u
X53 bias_0__VT_inh bias_0__VT_inh VDD VDD pfet_03v3 ad=0.2464p pd=1.44u as=0.2464p ps=1.44u w=0.88u l=1.12u
X57 a_19914_80658# DAC_7__Vb VSS VSS nfet_03v3 ad=0.6p pd=3.2u as=0.6p ps=3.2u w=1u l=8u
X62 VDD a_86480_39284# a_87742_32618# VDD pfet_03v3 ad=0.3p pd=2.2u as=0.3p ps=2.2u w=0.5u l=8u
X88 a_19914_110862# w[27] a_16310_110912# VSS nfet_03v3 ad=0.14p pd=1.06u as=0.14p ps=1.06u w=0.5u l=0.64u
X93 a_22014_31978# DAC_7__Vb VSS VSS nfet_03v3 ad=0.6p pd=3.2u as=0.6p ps=3.2u w=1u l=8u
X99 a_16310_94896# w[20] a_34614_94846# VSS nfet_03v3 ad=0.3p pd=2.2u as=0.3p ps=2.2u w=0.5u l=0.64u
X100 a_19914_125050# DAC_7__Vb VSS VSS nfet_03v3 ad=0.6p pd=3.2u as=0.6p ps=3.2u w=1u l=8u
X101 a_22014_31978# w[6] a_16310_32028# VSS nfet_03v3 ad=0.14p pd=1.06u as=0.14p ps=1.06u w=0.5u l=0.64u
X106 DPI_4__Vthr DPI_4__Vthr VDD VDD pfet_03v3 ad=0.14p pd=1.06u as=0.14p ps=1.06u w=0.5u l=0.64u
X108 a_87742_81298# VT a_85942_81648# VSS nfet_03v3 ad=2.4p pd=9.2u as=2.4p ps=9.2u w=4u l=2u
X111 a_16310_125100# w[31] a_19914_125050# VSS nfet_03v3 ad=0.14p pd=1.06u as=0.14p ps=1.06u w=0.5u l=0.64u
X117 VDD DPI_4__VT DPI_4__VT VDD pfet_03v3 ad=0.14p pd=1.06u as=0.14p ps=1.06u w=0.5u l=0.64u
X122 a_22014_64642# DAC_7__Vb VSS VSS nfet_03v3 ad=0.6p pd=3.2u as=0.6p ps=3.2u w=1u l=8u
X124 VSS neuron_4__Vlk neuron_4__Vlk VSS nfet_03v3 ad=0.28p pd=1.56u as=0.28p ps=1.56u w=1u l=1u
X125 VDD DPI_4__Vthr DAC_3__Isum_i DAC_3__Isum_i nfet_03v3 ad=0.3p pd=2.2u as=0.3p ps=2.2u w=0.5u l=0.64u
X127 a_22014_80658# DAC_7__Vb VSS VSS nfet_03v3 ad=0.6p pd=3.2u as=0.6p ps=3.2u w=1u l=8u
X132 a_88122_32968# neuron_4__VIp VSS VSS nfet_03v3 ad=0.6p pd=3.2u as=0.6p ps=3.2u w=1u l=1u
X140 VDD a_62266_112816# cap_mim_2f0_m4m5_noshield c_width=22.18u c_length=22.18u
X163 a_85942_81648# neuron_4__Vamp_bias VSS VSS nfet_03v3 ad=0.3p pd=2.2u as=0.3p ps=2.2u w=0.5u l=0.64u
X166 a_16310_110912# w[25] a_26214_110862# VSS nfet_03v3 ad=0.14p pd=1.06u as=0.3p ps=2.2u w=0.5u l=0.64u
X167 DPI_4__VT DPI_4__VT VDD VDD pfet_03v3 ad=0.14p pd=1.06u as=0.14p ps=1.06u w=0.5u l=0.64u
X175 a_19914_64642# DAC_7__Vb VSS VSS nfet_03v3 ad=0.6p pd=3.2u as=0.6p ps=3.2u w=1u l=8u
X187 a_22014_31978# w[6] a_16310_32028# VSS nfet_03v3 ad=0.3p pd=2.2u as=0.14p ps=1.06u w=0.5u l=0.64u
X190 a_19914_94846# DAC_7__Vb VSS VSS nfet_03v3 ad=0.6p pd=3.2u as=0.6p ps=3.2u w=1u l=8u
X191 DPI_4__VT DPI_4__VT VDD VDD pfet_03v3 ad=0.14p pd=1.06u as=0.14p ps=1.06u w=0.5u l=0.64u
X202 a_19914_110862# DAC_7__Vb VSS VSS nfet_03v3 ad=0.6p pd=3.2u as=0.6p ps=3.2u w=1u l=8u
X206 a_19914_31978# w[7] a_16310_32028# VSS nfet_03v3 ad=0.14p pd=1.06u as=0.14p ps=1.06u w=0.5u l=0.64u
X209 VDD a_62266_15456# cap_mim_2f0_m4m5_noshield c_width=22.18u c_length=22.18u
X217 DAC_1__Isum_i s[6] a_16558_110912# VSS nfet_03v3 ad=0.3p pd=2.2u as=0.3p ps=2.2u w=0.5u l=0.64u
X219 a_34614_31978# DAC_7__Vb VSS VSS nfet_03v3 ad=0.6p pd=3.2u as=0.6p ps=3.2u w=1u l=8u
X230 VDD DPI_4__Vthr DPI_4__Vthr VDD pfet_03v3 ad=0.14p pd=1.06u as=0.14p ps=1.06u w=0.5u l=0.64u
X239 a_19914_94846# w[23] a_16310_94896# VSS nfet_03v3 ad=0.14p pd=1.06u as=0.14p ps=1.06u w=0.5u l=0.64u
X243 a_19914_13502# DAC_7__Vb VSS VSS nfet_03v3 ad=0.6p pd=3.2u as=0.6p ps=3.2u w=1u l=8u
X248 VDD neuron_4__VKup neuron_4__VKup VDD pfet_03v3 ad=0.6p pd=3.2u as=0.6p ps=3.2u w=1u l=8u
X258 a_26214_125050# DAC_7__Vb VSS VSS nfet_03v3 ad=0.6p pd=3.2u as=0.6p ps=3.2u w=1u l=8u
X259 a_22014_94846# DAC_7__Vb VSS VSS nfet_03v3 ad=0.6p pd=3.2u as=0.6p ps=3.2u w=1u l=8u
X262 a_92184_20808# a_88370_14492# VMEM_0 VDD pfet_03v3 ad=0.3p pd=2.2u as=0.3p ps=2.2u w=0.5u l=0.64u
X269 DAC_1__Isum_e a_17058_124892# a_16558_125100# VSS nfet_03v3 ad=0.3p pd=2.2u as=0.3p ps=2.2u w=0.5u l=0.64u
X272 VDD neuron_4__VKup a_91556_39284# VDD pfet_03v3 ad=0.6p pd=3.2u as=0.6p ps=3.2u w=1u l=1u
X276 a_88370_14492# a_87742_14142# a_88122_14492# VSS nfet_03v3 ad=0.3p pd=2.2u as=0.3p ps=2.2u w=0.5u l=0.64u
X277 VDD s[1] a_17058_31820# VDD pfet_03v3 ad=0.3p pd=2.2u as=0.3p ps=2.2u w=0.5u l=0.32u
X291 a_19914_110862# w[27] a_16310_110912# VSS nfet_03v3 ad=0.3p pd=2.2u as=0.14p ps=1.06u w=0.5u l=0.64u
X298 DAC_3__Isum_e a_17058_80500# a_16558_80708# VSS nfet_03v3 ad=0.3p pd=2.2u as=0.3p ps=2.2u w=0.5u l=0.64u
X302 a_19914_31978# w[7] a_16310_32028# VSS nfet_03v3 ad=0.3p pd=2.2u as=0.14p ps=1.06u w=0.5u l=0.64u
X306 VDD neuron_4__VKup a_91556_118168# VDD pfet_03v3 ad=0.6p pd=3.2u as=0.6p ps=3.2u w=1u l=1u
X310 DPI_4__Vthr DPI_4__Vthr VDD VDD pfet_03v3 ad=0.14p pd=1.06u as=0.14p ps=1.06u w=0.5u l=0.64u
X313 a_62266_82612# a_62266_82612# DAC_3__Isum_e DAC_3__Isum_e nfet_03v3 ad=0.3p pd=2.2u as=0.3p ps=2.2u w=0.5u l=0.64u
X320 a_17058_80500# s[4] VSS VSS nfet_03v3 ad=0.3p pd=2.2u as=0.3p ps=2.2u w=0.5u l=0.64u
X325 a_88750_51444# neuron_4__VKdn VSS VSS nfet_03v3 ad=0.6p pd=3.2u as=0.6p ps=3.2u w=1u l=1u
X327 DAC_5__Isum_e a_17058_64484# a_16558_64692# VSS nfet_03v3 ad=0.3p pd=2.2u as=0.3p ps=2.2u w=0.5u l=0.64u
X338 VDD s[0] a_16558_13552# VSS nfet_03v3 ad=0.3p pd=2.2u as=0.3p ps=2.2u w=0.5u l=0.64u
X348 a_17058_64484# s[3] VSS VSS nfet_03v3 ad=0.3p pd=2.2u as=0.3p ps=2.2u w=0.5u l=0.64u
X352 VDD DPI_4__Vthr DAC_7__Isum_e DAC_7__Isum_e nfet_03v3 ad=0.3p pd=2.2u as=0.3p ps=2.2u w=0.5u l=0.64u
X365 VDD a_86480_20808# a_87742_14142# VDD pfet_03v3 ad=0.3p pd=2.2u as=0.3p ps=2.2u w=0.5u l=8u
X369 a_92184_57760# a_88370_51444# VMEM_2 VDD pfet_03v3 ad=0.3p pd=2.2u as=0.3p ps=2.2u w=0.5u l=0.64u
X370 a_19914_125050# w[31] a_16310_125100# VSS nfet_03v3 ad=0.14p pd=1.06u as=0.14p ps=1.06u w=0.5u l=0.64u
X375 a_88370_51444# a_87742_51094# a_88122_51444# VSS nfet_03v3 ad=0.3p pd=2.2u as=0.3p ps=2.2u w=0.5u l=0.64u
X376 a_19914_50454# DAC_7__Vb VSS VSS nfet_03v3 ad=0.6p pd=3.2u as=0.6p ps=3.2u w=1u l=8u
X386 a_19914_80658# DAC_7__Vb VSS VSS nfet_03v3 ad=0.6p pd=3.2u as=0.6p ps=3.2u w=1u l=8u
X395 a_22014_13502# w[2] a_16310_13552# VSS nfet_03v3 ad=0.14p pd=1.06u as=0.14p ps=1.06u w=0.5u l=0.64u
X396 VDD DPI_4__VT a_62266_15456# VDD pfet_03v3 ad=0.3p pd=2.2u as=0.3p ps=2.2u w=0.5u l=0.64u
X407 a_26214_80658# w[17] a_16310_80708# VSS nfet_03v3 ad=0.3p pd=2.2u as=0.14p ps=1.06u w=0.5u l=0.64u
X415 VSS neuron_4__VKdn neuron_4__VKdn VSS nfet_03v3 ad=0.28p pd=1.56u as=0.28p ps=1.56u w=1u l=1u
X425 DAC_5__Isum_i s[2] a_16558_50504# VSS nfet_03v3 ad=0.3p pd=2.2u as=0.3p ps=2.2u w=0.5u l=0.64u
X428 a_26214_50454# DAC_7__Vb VSS VSS nfet_03v3 ad=0.6p pd=3.2u as=0.6p ps=3.2u w=1u l=8u
X436 a_26214_64642# w[13] a_16310_64692# VSS nfet_03v3 ad=0.3p pd=2.2u as=0.14p ps=1.06u w=0.5u l=0.64u
X437 DPI_4__VT DPI_4__VT VDD VDD pfet_03v3 ad=0.14p pd=1.06u as=0.14p ps=1.06u w=0.5u l=0.64u
X439 a_22014_80658# DAC_7__Vb VSS VSS nfet_03v3 ad=0.6p pd=3.2u as=0.6p ps=3.2u w=1u l=8u
X440 VDD DPI_4__VT DPI_4__VT VDD pfet_03v3 ad=0.14p pd=1.06u as=0.14p ps=1.06u w=0.5u l=0.64u
X441 a_16310_125100# w[29] a_26214_125050# VSS nfet_03v3 ad=0.14p pd=1.06u as=0.3p ps=2.2u w=0.5u l=0.64u
X450 VDD a_86480_39284# a_86480_39284# VDD pfet_03v3 ad=0.3p pd=2.2u as=0.3p ps=2.2u w=0.5u l=8u
X460 VDD a_86480_57760# a_87742_51094# VDD pfet_03v3 ad=0.3p pd=2.2u as=0.3p ps=2.2u w=0.5u l=8u
X462 a_88370_111852# a_87742_111502# a_88122_111852# VSS nfet_03v3 ad=0.3p pd=2.2u as=0.3p ps=2.2u w=0.5u l=0.64u
X463 a_88122_111852# neuron_4__VIp VSS VSS nfet_03v3 ad=0.6p pd=3.2u as=0.6p ps=3.2u w=1u l=1u
X474 a_19914_94846# w[23] a_16310_94896# VSS nfet_03v3 ad=0.14p pd=1.06u as=0.14p ps=1.06u w=0.5u l=0.64u
X479 a_19914_31978# DAC_7__Vb VSS VSS nfet_03v3 ad=0.6p pd=3.2u as=0.6p ps=3.2u w=1u l=8u
X482 a_19914_125050# DAC_7__Vb VSS VSS nfet_03v3 ad=0.6p pd=3.2u as=0.6p ps=3.2u w=1u l=8u
X488 a_86480_118168# VMEM_4 a_85942_111852# VSS nfet_03v3 ad=2.4p pd=9.2u as=2.4p ps=9.2u w=4u l=2u
X491 DAC_1__Isum_i s[7] a_16558_125100# VSS nfet_03v3 ad=0.3p pd=2.2u as=0.3p ps=2.2u w=0.5u l=0.64u
X493 DPI_4__Vthr DPI_4__Vthr VDD VDD pfet_03v3 ad=0.14p pd=1.06u as=0.14p ps=1.06u w=0.5u l=0.64u
X498 a_22014_13502# w[2] a_16310_13552# VSS nfet_03v3 ad=0.3p pd=2.2u as=0.14p ps=1.06u w=0.5u l=0.64u
X503 VDD DPI_4__VT a_62266_52408# VDD pfet_03v3 ad=0.3p pd=2.2u as=0.3p ps=2.2u w=0.5u l=0.64u
X504 a_22014_50454# w[10] a_16310_50504# VSS nfet_03v3 ad=0.14p pd=1.06u as=0.14p ps=1.06u w=0.5u l=0.64u
X508 a_19914_64642# DAC_7__Vb VSS VSS nfet_03v3 ad=0.6p pd=3.2u as=0.6p ps=3.2u w=1u l=8u
X515 a_19914_13502# w[3] a_16310_13552# VSS nfet_03v3 ad=0.14p pd=1.06u as=0.14p ps=1.06u w=0.5u l=0.64u
X520 a_19914_94846# DAC_7__Vb VSS VSS nfet_03v3 ad=0.6p pd=3.2u as=0.6p ps=3.2u w=1u l=8u
X528 VDD a_86480_118168# a_86480_118168# VDD pfet_03v3 ad=0.3p pd=2.2u as=0.3p ps=2.2u w=0.5u l=8u
X537 VDD neuron_4__VNA a_92184_20808# VDD pfet_03v3 ad=0.6p pd=3.2u as=0.6p ps=3.2u w=1u l=1u
X552 VMEM_3 spike[3] a_89378_81648# VSS nfet_03v3 ad=0.3p pd=2.2u as=0.3p ps=2.2u w=0.5u l=11.36u
X553 a_91556_87964# a_88370_81648# spike[3] VDD pfet_03v3 ad=0.3p pd=2.2u as=0.3p ps=2.2u w=0.5u l=0.64u
X566 VDD DPI_4__Vthr DPI_4__Vthr VDD pfet_03v3 ad=0.14p pd=1.06u as=0.14p ps=1.06u w=0.5u l=0.64u
X567 a_26214_64642# DAC_7__Vb VSS VSS nfet_03v3 ad=0.6p pd=3.2u as=0.6p ps=3.2u w=1u l=8u
X570 a_19914_125050# w[31] a_16310_125100# VSS nfet_03v3 ad=0.3p pd=2.2u as=0.14p ps=1.06u w=0.5u l=0.64u
X572 VDD DPI_4__Vthr DPI_4__Vthr VDD pfet_03v3 ad=0.14p pd=1.06u as=0.14p ps=1.06u w=0.5u l=0.64u
X579 VDD a_67078_123924# a_62978_118260# VDD pfet_03v3 ad=0.3p pd=2.2u as=0.3p ps=2.2u w=0.5u l=0.64u
X583 a_19914_13502# DAC_7__Vb VSS VSS nfet_03v3 ad=0.6p pd=3.2u as=0.6p ps=3.2u w=1u l=8u
X585 DAC_7__Vb DAC_7__Vb VSS VSS nfet_03v3 ad=0.6p pd=3.2u as=0.6p ps=3.2u w=1u l=8u
X587 a_88122_14492# neuron_4__VIp VSS VSS nfet_03v3 ad=0.6p pd=3.2u as=0.6p ps=3.2u w=1u l=1u
X589 a_22014_94846# DAC_7__Vb VSS VSS nfet_03v3 ad=0.6p pd=3.2u as=0.6p ps=3.2u w=1u l=8u
X590 spike[1] VSS cap_mim_2f0_m4m5_noshield c_width=10u c_length=10u
X593 a_85942_111852# neuron_4__Vamp_bias VSS VSS nfet_03v3 ad=0.3p pd=2.2u as=0.3p ps=2.2u w=0.5u l=0.64u
X603 a_22014_50454# w[10] a_16310_50504# VSS nfet_03v3 ad=0.3p pd=2.2u as=0.14p ps=1.06u w=0.5u l=0.64u
X615 a_19914_13502# w[3] a_16310_13552# VSS nfet_03v3 ad=0.3p pd=2.2u as=0.14p ps=1.06u w=0.5u l=0.64u
X622 a_19914_50454# w[11] a_16310_50504# VSS nfet_03v3 ad=0.14p pd=1.06u as=0.14p ps=1.06u w=0.5u l=0.64u
X624 spike[0] VSS cap_mim_2f0_m4m5_noshield c_width=10u c_length=10u
X643 VDD bias_0__VT_inh bias_0__VT_inh VDD pfet_03v3 ad=0.2464p pd=1.44u as=0.2464p ps=1.44u w=0.88u l=1.12u
X645 a_16310_32028# w[6] a_22014_31978# VSS nfet_03v3 ad=0.14p pd=1.06u as=0.14p ps=1.06u w=0.5u l=0.64u
X648 a_26214_13502# DAC_7__Vb VSS VSS nfet_03v3 ad=0.6p pd=3.2u as=0.6p ps=3.2u w=1u l=8u
X655 a_22014_110862# DAC_7__Vb VSS VSS nfet_03v3 ad=0.6p pd=3.2u as=0.6p ps=3.2u w=1u l=8u
X657 a_22014_50454# DAC_7__Vb VSS VSS nfet_03v3 ad=0.6p pd=3.2u as=0.6p ps=3.2u w=1u l=8u
X659 a_92184_118168# a_88370_111852# VMEM_4 VDD pfet_03v3 ad=0.3p pd=2.2u as=0.3p ps=2.2u w=0.5u l=0.64u
X662 a_16558_32028# pulse[1] a_16310_32028# VSS nfet_03v3 ad=0.3p pd=2.2u as=0.3p ps=2.2u w=0.5u l=0.64u
X663 DPI_4__VT DPI_4__VT VDD VDD pfet_03v3 ad=0.14p pd=1.06u as=0.14p ps=1.06u w=0.5u l=0.64u
X666 VDD DPI_4__VT DPI_4__VT VDD pfet_03v3 ad=0.14p pd=1.06u as=0.14p ps=1.06u w=0.5u l=0.64u
X668 a_16310_32028# w[7] a_19914_31978# VSS nfet_03v3 ad=0.14p pd=1.06u as=0.14p ps=1.06u w=0.5u l=0.64u
X694 VDD DPI_4__VT a_67078_123924# VDD pfet_03v3 ad=0.3p pd=2.2u as=0.3p ps=2.2u w=0.5u l=0.64u
X699 VDD neuron_4__VKup a_91556_57760# VDD pfet_03v3 ad=0.6p pd=3.2u as=0.6p ps=3.2u w=1u l=1u
X714 a_19914_13502# DAC_7__Vb VSS VSS nfet_03v3 ad=0.6p pd=3.2u as=0.6p ps=3.2u w=1u l=8u
X716 spike[4] a_88370_111852# a_88750_111852# VSS nfet_03v3 ad=0.3p pd=2.2u as=0.3p ps=2.2u w=0.5u l=0.64u
X717 VDD a_21486_142736# neuron_4__VK VDD pfet_03v3 ad=6.27p pd=22.1u as=6.27p ps=22.1u w=10.45u l=8u
X721 Iref Iref VSS VSS nfet_03v3 ad=6p pd=21.2u as=6p ps=21.2u w=10u l=8u
X722 a_19914_110862# DAC_7__Vb VSS VSS nfet_03v3 ad=0.6p pd=3.2u as=0.6p ps=3.2u w=1u l=8u
X727 a_19914_50454# w[11] a_16310_50504# VSS nfet_03v3 ad=0.3p pd=2.2u as=0.14p ps=1.06u w=0.5u l=0.64u
X730 DPI_4__VT DPI_4__VT VDD VDD pfet_03v3 ad=0.14p pd=1.06u as=0.14p ps=1.06u w=0.5u l=0.64u
X733 a_16310_94896# w[21] a_26214_94846# VSS nfet_03v3 ad=0.14p pd=1.06u as=0.3p ps=2.2u w=0.5u l=0.64u
X742 VDD a_21486_142736# DAC_7__Vb VDD pfet_03v3 ad=0.864p pd=4.08u as=0.864p ps=4.08u w=1.44u l=8u
X754 VDD DPI_4__VT a_67078_63516# VDD pfet_03v3 ad=0.3p pd=2.2u as=0.3p ps=2.2u w=0.5u l=0.64u
X757 a_67078_93720# a_67078_93720# DAC_3__Isum_i DAC_3__Isum_i nfet_03v3 ad=0.3p pd=2.2u as=0.3p ps=2.2u w=0.5u l=0.64u
X758 VMEM_3 neuron_4__Vlk VSS VSS nfet_03v3 ad=0.6p pd=3.2u as=0.6p ps=3.2u w=1u l=1u
X771 neuron_4__VKup Iref VSS VSS nfet_03v3 ad=3.606p pd=13.22u as=3.606p ps=13.22u w=6.01u l=8u
X778 a_16310_32028# w[7] a_19914_31978# VSS nfet_03v3 ad=0.14p pd=1.06u as=0.14p ps=1.06u w=0.5u l=0.64u
X784 VDD neuron_4__VNA a_92184_87964# VDD pfet_03v3 ad=0.6p pd=3.2u as=0.6p ps=3.2u w=1u l=1u
X785 VDD a_86480_20808# a_86480_20808# VDD pfet_03v3 ad=0.3p pd=2.2u as=0.3p ps=2.2u w=0.5u l=8u
X788 a_86480_39284# VMEM_1 a_85942_32968# VSS nfet_03v3 ad=2.4p pd=9.2u as=2.4p ps=9.2u w=4u l=2u
X791 a_21486_142736# Iref VSS VSS nfet_03v3 ad=6p pd=21.2u as=6p ps=21.2u w=10u l=8u
X792 spike[1] a_88370_32968# a_88750_32968# VSS nfet_03v3 ad=0.3p pd=2.2u as=0.3p ps=2.2u w=0.5u l=0.64u
X799 VDD DPI_4__Vthr DPI_4__Vthr VDD pfet_03v3 ad=0.14p pd=1.06u as=0.14p ps=1.06u w=0.5u l=0.64u
X800 a_34614_50454# DAC_7__Vb VSS VSS nfet_03v3 ad=0.6p pd=3.2u as=0.6p ps=3.2u w=1u l=8u
X809 VDD DPI_4__Vthr DPI_4__Vthr VDD pfet_03v3 ad=0.14p pd=1.06u as=0.14p ps=1.06u w=0.5u l=0.64u
X813 a_22014_64642# DAC_7__Vb VSS VSS nfet_03v3 ad=0.6p pd=3.2u as=0.6p ps=3.2u w=1u l=8u
X814 VDD bias_0__VT_inh bias_0__VT_inh VDD pfet_03v3 ad=0.2464p pd=1.44u as=0.2464p ps=1.44u w=0.88u l=1.12u
X816 a_22014_80658# DAC_7__Vb VSS VSS nfet_03v3 ad=0.6p pd=3.2u as=0.6p ps=3.2u w=1u l=8u
X834 a_16310_32028# w[7] a_19914_31978# VSS nfet_03v3 ad=0.14p pd=1.06u as=0.3p ps=2.2u w=0.5u l=0.64u
X836 a_16310_110912# w[26] a_22014_110862# VSS nfet_03v3 ad=0.14p pd=1.06u as=0.3p ps=2.2u w=0.5u l=0.64u
X852 VDD DPI_4__VT a_62266_33932# VDD pfet_03v3 ad=0.3p pd=2.2u as=0.3p ps=2.2u w=0.5u l=0.64u
X855 a_19914_31978# DAC_7__Vb VSS VSS nfet_03v3 ad=0.6p pd=3.2u as=0.6p ps=3.2u w=1u l=8u
X868 VDD s[2] a_17058_50296# VDD pfet_03v3 ad=0.3p pd=2.2u as=0.3p ps=2.2u w=0.5u l=0.32u
X870 VDD s[6] a_17058_110704# VDD pfet_03v3 ad=0.3p pd=2.2u as=0.3p ps=2.2u w=0.5u l=0.32u
X878 a_19914_80658# DAC_7__Vb VSS VSS nfet_03v3 ad=0.6p pd=3.2u as=0.6p ps=3.2u w=1u l=8u
X880 DPI_4__Vthr DPI_4__Vthr VDD VDD pfet_03v3 ad=0.14p pd=1.06u as=0.3p ps=2.2u w=0.5u l=0.64u
X886 VDD a_62266_112816# VMEM_4 VDD pfet_03v3 ad=0.3p pd=2.2u as=0.3p ps=2.2u w=0.5u l=0.64u
X888 a_89378_32968# neuron_4__VK VSS VSS nfet_03v3 ad=0.6p pd=3.2u as=0.6p ps=3.2u w=1u l=1u
X894 a_22014_110862# w[26] a_16310_110912# VSS nfet_03v3 ad=0.14p pd=1.06u as=0.14p ps=1.06u w=0.5u l=0.64u
X900 VDD a_86480_57760# a_86480_57760# VDD pfet_03v3 ad=0.3p pd=2.2u as=0.3p ps=2.2u w=0.5u l=8u
X906 VDD a_62266_82612# VMEM_3 VDD pfet_03v3 ad=0.3p pd=2.2u as=0.3p ps=2.2u w=0.5u l=0.64u
X910 a_16310_32028# w[6] a_22014_31978# VSS nfet_03v3 ad=0.14p pd=1.06u as=0.3p ps=2.2u w=0.5u l=0.64u
X914 VDD a_21486_142736# a_21486_142736# VDD pfet_03v3 ad=6p pd=21.2u as=6p ps=21.2u w=10u l=8u
X919 a_26214_31978# DAC_7__Vb VSS VSS nfet_03v3 ad=0.6p pd=3.2u as=0.6p ps=3.2u w=1u l=8u
X926 a_16310_32028# w[7] a_19914_31978# VSS nfet_03v3 ad=0.14p pd=1.06u as=0.14p ps=1.06u w=0.5u l=0.64u
X935 a_34614_64642# DAC_7__Vb VSS VSS nfet_03v3 ad=0.6p pd=3.2u as=0.6p ps=3.2u w=1u l=8u
X938 VDD a_87742_32618# a_88370_32968# VDD pfet_03v3 ad=0.3p pd=2.2u as=0.3p ps=2.2u w=0.5u l=0.64u
X939 DPI_4__VT DPI_4__VT VDD VDD pfet_03v3 ad=0.14p pd=1.06u as=0.14p ps=1.06u w=0.5u l=0.64u
X950 DPI_4__VT DPI_4__VT VDD VDD pfet_03v3 ad=0.14p pd=1.06u as=0.14p ps=1.06u w=0.5u l=0.64u
X951 a_22014_94846# DAC_7__Vb VSS VSS nfet_03v3 ad=0.6p pd=3.2u as=0.6p ps=3.2u w=1u l=8u
X958 a_22014_125050# DAC_7__Vb VSS VSS nfet_03v3 ad=0.6p pd=3.2u as=0.6p ps=3.2u w=1u l=8u
X959 a_88750_111852# neuron_4__VKdn VSS VSS nfet_03v3 ad=0.6p pd=3.2u as=0.6p ps=3.2u w=1u l=1u
X966 a_22014_110862# DAC_7__Vb VSS VSS nfet_03v3 ad=0.6p pd=3.2u as=0.6p ps=3.2u w=1u l=8u
X973 a_19914_31978# DAC_7__Vb VSS VSS nfet_03v3 ad=0.6p pd=3.2u as=0.6p ps=3.2u w=1u l=8u
X986 a_16310_13552# w[2] a_22014_13502# VSS nfet_03v3 ad=0.14p pd=1.06u as=0.14p ps=1.06u w=0.5u l=0.64u
X995 VSS neuron_4__Vlk neuron_4__Vlk VSS nfet_03v3 ad=0.28p pd=1.56u as=0.28p ps=1.56u w=1u l=1u
X998 VDD DPI_4__Vthr DPI_4__Vthr VDD pfet_03v3 ad=0.14p pd=1.06u as=0.14p ps=1.06u w=0.5u l=0.64u
X999 a_16558_13552# pulse[0] a_16310_13552# VSS nfet_03v3 ad=0.3p pd=2.2u as=0.3p ps=2.2u w=0.5u l=0.64u
X1000 a_87742_32618# VT a_85942_32968# VSS nfet_03v3 ad=2.4p pd=9.2u as=2.4p ps=9.2u w=4u l=2u
X1001 a_16310_32028# w[4] a_34614_31978# VSS nfet_03v3 ad=0.3p pd=2.2u as=0.3p ps=2.2u w=0.5u l=0.64u
X1004 a_62266_15456# a_62266_15456# DAC_7__Isum_e DAC_7__Isum_e nfet_03v3 ad=0.3p pd=2.2u as=0.3p ps=2.2u w=0.5u l=0.64u
X1007 a_16310_13552# w[3] a_19914_13502# VSS nfet_03v3 ad=0.14p pd=1.06u as=0.14p ps=1.06u w=0.5u l=0.64u
X1023 a_19914_94846# DAC_7__Vb VSS VSS nfet_03v3 ad=0.6p pd=3.2u as=0.6p ps=3.2u w=1u l=8u
X1030 a_19914_125050# DAC_7__Vb VSS VSS nfet_03v3 ad=0.6p pd=3.2u as=0.6p ps=3.2u w=1u l=8u
X1061 a_19914_110862# w[27] a_16310_110912# VSS nfet_03v3 ad=0.14p pd=1.06u as=0.14p ps=1.06u w=0.5u l=0.64u
X1073 DPI_4__Vthr DPI_4__Vthr VDD VDD pfet_03v3 ad=0.14p pd=1.06u as=0.14p ps=1.06u w=0.5u l=0.64u
X1077 a_19914_13502# DAC_7__Vb VSS VSS nfet_03v3 ad=0.6p pd=3.2u as=0.6p ps=3.2u w=1u l=8u
X1079 DPI_4__Vthr DPI_4__Vthr VDD VDD pfet_03v3 ad=0.14p pd=1.06u as=0.14p ps=1.06u w=0.5u l=0.64u
X1082 a_19914_50454# DAC_7__Vb VSS VSS nfet_03v3 ad=0.6p pd=3.2u as=0.6p ps=3.2u w=1u l=8u
X1087 a_16310_50504# w[10] a_22014_50454# VSS nfet_03v3 ad=0.14p pd=1.06u as=0.14p ps=1.06u w=0.5u l=0.64u
X1088 VDD bias_0__VT_inh bias_0__VT_inh VDD pfet_03v3 ad=0.2464p pd=1.44u as=0.2464p ps=1.44u w=0.88u l=1.12u
X1093 neuron_4__VKdn neuron_4__VKdn VSS VSS nfet_03v3 ad=0.28p pd=1.56u as=0.6p ps=3.2u w=1u l=1u
X1097 a_16310_13552# w[3] a_19914_13502# VSS nfet_03v3 ad=0.14p pd=1.06u as=0.14p ps=1.06u w=0.5u l=0.64u
X1098 a_16558_50504# spike[0] a_16310_50504# VSS nfet_03v3 ad=0.3p pd=2.2u as=0.3p ps=2.2u w=0.5u l=0.64u
X1104 a_22014_110862# w[26] a_16310_110912# VSS nfet_03v3 ad=0.3p pd=2.2u as=0.14p ps=1.06u w=0.5u l=0.64u
X1106 a_16310_50504# w[11] a_19914_50454# VSS nfet_03v3 ad=0.14p pd=1.06u as=0.14p ps=1.06u w=0.5u l=0.64u
X1122 a_16310_125100# w[30] a_22014_125050# VSS nfet_03v3 ad=0.14p pd=1.06u as=0.3p ps=2.2u w=0.5u l=0.64u
X1132 a_19914_110862# DAC_7__Vb VSS VSS nfet_03v3 ad=0.6p pd=3.2u as=0.6p ps=3.2u w=1u l=8u
X1141 DPI_4__VT DPI_4__VT VDD VDD pfet_03v3 ad=0.14p pd=1.06u as=0.14p ps=1.06u w=0.5u l=0.64u
X1144 a_19914_31978# w[7] a_16310_32028# VSS nfet_03v3 ad=0.14p pd=1.06u as=0.14p ps=1.06u w=0.5u l=0.64u
X1153 a_16310_13552# w[3] a_19914_13502# VSS nfet_03v3 ad=0.14p pd=1.06u as=0.3p ps=2.2u w=0.5u l=0.64u
X1168 a_88750_81648# neuron_4__VKdn VSS VSS nfet_03v3 ad=0.6p pd=3.2u as=0.6p ps=3.2u w=1u l=1u
X1169 DAC_3__Isum_e a_17058_94688# a_16558_94896# VSS nfet_03v3 ad=0.3p pd=2.2u as=0.3p ps=2.2u w=0.5u l=0.64u
X1178 a_22014_125050# w[30] a_16310_125100# VSS nfet_03v3 ad=0.14p pd=1.06u as=0.14p ps=1.06u w=0.5u l=0.64u
X1181 VDD bias_0__VT_inh bias_0__VT_inh VDD pfet_03v3 ad=0.2464p pd=1.44u as=0.2464p ps=1.44u w=0.88u l=1.12u
X1192 a_17058_94688# s[5] VSS VSS nfet_03v3 ad=0.3p pd=2.2u as=0.3p ps=2.2u w=0.5u l=0.64u
X1195 a_87742_111502# VT a_85942_111852# VSS nfet_03v3 ad=2.4p pd=9.2u as=2.4p ps=9.2u w=4u l=2u
X1198 neuron_4__Vlk neuron_4__Vlk VSS VSS nfet_03v3 ad=0.28p pd=1.56u as=0.28p ps=1.56u w=1u l=1u
X1200 a_16310_50504# w[11] a_19914_50454# VSS nfet_03v3 ad=0.14p pd=1.06u as=0.14p ps=1.06u w=0.5u l=0.64u
X1208 a_92184_87964# a_88370_81648# VMEM_3 VDD pfet_03v3 ad=0.3p pd=2.2u as=0.3p ps=2.2u w=0.5u l=0.64u
X1210 VDD DPI_4__VT DPI_4__VT VDD pfet_03v3 ad=0.14p pd=1.06u as=0.14p ps=1.06u w=0.5u l=0.64u
X1218 a_19914_64642# DAC_7__Vb VSS VSS nfet_03v3 ad=0.6p pd=3.2u as=0.6p ps=3.2u w=1u l=8u
X1219 VDD DPI_4__VT DPI_4__VT VDD pfet_03v3 ad=0.14p pd=1.06u as=0.14p ps=1.06u w=0.5u l=0.64u
X1222 a_88370_81648# a_87742_81298# a_88122_81648# VSS nfet_03v3 ad=0.3p pd=2.2u as=0.3p ps=2.2u w=0.5u l=0.64u
X1223 a_19914_80658# DAC_7__Vb VSS VSS nfet_03v3 ad=0.6p pd=3.2u as=0.6p ps=3.2u w=1u l=8u
X1230 a_16310_13552# w[2] a_22014_13502# VSS nfet_03v3 ad=0.14p pd=1.06u as=0.3p ps=2.2u w=0.5u l=0.64u
X1231 DPI_4__VT Iref VSS VSS nfet_03v3 ad=0.702p pd=3.54u as=0.702p ps=3.54u w=1.17u l=32u
X1232 VMEM_4 spike[4] a_89378_111852# VSS nfet_03v3 ad=0.3p pd=2.2u as=0.3p ps=2.2u w=0.5u l=11.36u
X1244 bias_0__VT_inh bias_0__VT_inh VDD VDD pfet_03v3 ad=0.2464p pd=1.44u as=0.2464p ps=1.44u w=0.88u l=1.12u
X1247 a_16310_13552# w[3] a_19914_13502# VSS nfet_03v3 ad=0.14p pd=1.06u as=0.14p ps=1.06u w=0.5u l=0.64u
X1252 VDD a_87742_14142# a_88370_14492# VDD pfet_03v3 ad=0.3p pd=2.2u as=0.3p ps=2.2u w=0.5u l=0.64u
X1255 a_16310_50504# w[11] a_19914_50454# VSS nfet_03v3 ad=0.14p pd=1.06u as=0.3p ps=2.2u w=0.5u l=0.64u
X1258 a_22014_125050# DAC_7__Vb VSS VSS nfet_03v3 ad=0.6p pd=3.2u as=0.6p ps=3.2u w=1u l=8u
X1260 a_86480_20808# VMEM_0 a_85942_14492# VSS nfet_03v3 ad=2.4p pd=9.2u as=2.4p ps=9.2u w=4u l=2u
X1262 DPI_4__Vthr DPI_4__Vthr VDD VDD pfet_03v3 ad=0.14p pd=1.06u as=0.14p ps=1.06u w=0.5u l=0.64u
X1263 VDD bias_0__VT_inh bias_0__VT_inh VDD pfet_03v3 ad=0.2464p pd=1.44u as=0.2464p ps=1.44u w=0.88u l=1.12u
X1265 spike[0] a_88370_14492# a_88750_14492# VSS nfet_03v3 ad=0.3p pd=2.2u as=0.3p ps=2.2u w=0.5u l=0.64u
X1282 DAC_3__Isum_i s[4] a_16558_80708# VSS nfet_03v3 ad=0.3p pd=2.2u as=0.3p ps=2.2u w=0.5u l=0.64u
X1285 DPI_4__Vthr DPI_4__Vthr VDD VDD pfet_03v3 ad=0.14p pd=1.06u as=0.14p ps=1.06u w=0.5u l=0.64u
X1287 a_26214_80658# DAC_7__Vb VSS VSS nfet_03v3 ad=0.6p pd=3.2u as=0.6p ps=3.2u w=1u l=8u
X1293 a_62266_112816# a_62266_112816# DAC_1__Isum_e DAC_1__Isum_e nfet_03v3 ad=0.3p pd=2.2u as=0.3p ps=2.2u w=0.5u l=0.64u
X1294 a_26214_94846# w[21] a_16310_94896# VSS nfet_03v3 ad=0.3p pd=2.2u as=0.14p ps=1.06u w=0.5u l=0.64u
X1296 a_89378_111852# neuron_4__VK VSS VSS nfet_03v3 ad=0.6p pd=3.2u as=0.6p ps=3.2u w=1u l=1u
X1305 DAC_5__Isum_i s[3] a_16558_64692# VSS nfet_03v3 ad=0.3p pd=2.2u as=0.3p ps=2.2u w=0.5u l=0.64u
X1307 a_16310_13552# w[0] a_34614_13502# VSS nfet_03v3 ad=0.3p pd=2.2u as=0.3p ps=2.2u w=0.5u l=0.64u
X1313 VDD neuron_4__VKup a_91556_20808# VDD pfet_03v3 ad=0.6p pd=3.2u as=0.6p ps=3.2u w=1u l=1u
X1315 VDD a_86480_87964# a_87742_81298# VDD pfet_03v3 ad=0.3p pd=2.2u as=0.3p ps=2.2u w=0.5u l=8u
X1319 a_16310_110912# w[27] a_19914_110862# VSS nfet_03v3 ad=0.14p pd=1.06u as=0.14p ps=1.06u w=0.5u l=0.64u
X1321 a_19914_31978# DAC_7__Vb VSS VSS nfet_03v3 ad=0.6p pd=3.2u as=0.6p ps=3.2u w=1u l=8u
X1331 a_16310_50504# w[10] a_22014_50454# VSS nfet_03v3 ad=0.14p pd=1.06u as=0.3p ps=2.2u w=0.5u l=0.64u
X1345 a_19914_125050# w[31] a_16310_125100# VSS nfet_03v3 ad=0.14p pd=1.06u as=0.14p ps=1.06u w=0.5u l=0.64u
X1347 a_16310_50504# w[11] a_19914_50454# VSS nfet_03v3 ad=0.14p pd=1.06u as=0.14p ps=1.06u w=0.5u l=0.64u
X1355 VDD DPI_4__Vthr DPI_4__Vthr VDD pfet_03v3 ad=0.14p pd=1.06u as=0.14p ps=1.06u w=0.5u l=0.64u
X1356 a_17058_110704# s[6] VSS VSS nfet_03v3 ad=0.3p pd=2.2u as=0.3p ps=2.2u w=0.5u l=0.64u
X1358 a_22014_80658# w[18] a_16310_80708# VSS nfet_03v3 ad=0.14p pd=1.06u as=0.14p ps=1.06u w=0.5u l=0.64u
X1362 a_89378_14492# neuron_4__VK VSS VSS nfet_03v3 ad=0.6p pd=3.2u as=0.6p ps=3.2u w=1u l=1u
X1367 a_19914_94846# DAC_7__Vb VSS VSS nfet_03v3 ad=0.6p pd=3.2u as=0.6p ps=3.2u w=1u l=8u
X1369 spike[2] a_88370_51444# a_88750_51444# VSS nfet_03v3 ad=0.3p pd=2.2u as=0.3p ps=2.2u w=0.5u l=0.64u
X1371 VDD a_87742_51094# a_88370_51444# VDD pfet_03v3 ad=0.3p pd=2.2u as=0.3p ps=2.2u w=0.5u l=0.64u
X1378 a_22014_110862# DAC_7__Vb VSS VSS nfet_03v3 ad=0.6p pd=3.2u as=0.6p ps=3.2u w=1u l=8u
X1390 a_19914_31978# w[7] a_16310_32028# VSS nfet_03v3 ad=0.14p pd=1.06u as=0.14p ps=1.06u w=0.5u l=0.64u
X1392 a_22014_64642# w[14] a_16310_64692# VSS nfet_03v3 ad=0.14p pd=1.06u as=0.14p ps=1.06u w=0.5u l=0.64u
X1393 a_22014_125050# w[30] a_16310_125100# VSS nfet_03v3 ad=0.3p pd=2.2u as=0.14p ps=1.06u w=0.5u l=0.64u
X1412 spike[3] VSS cap_mim_2f0_m4m5_noshield c_width=10u c_length=10u
X1419 a_19914_13502# DAC_7__Vb VSS VSS nfet_03v3 ad=0.6p pd=3.2u as=0.6p ps=3.2u w=1u l=8u
X1427 a_16310_50504# w[8] a_34614_50454# VSS nfet_03v3 ad=0.3p pd=2.2u as=0.3p ps=2.2u w=0.5u l=0.64u
X1429 bias_0__VT_inh bias_0__VT_inh VDD VDD pfet_03v3 ad=0.2464p pd=1.44u as=0.2464p ps=1.44u w=0.88u l=1.12u
X1434 VDD DPI_4__VT DPI_4__VT VDD pfet_03v3 ad=0.14p pd=1.06u as=0.14p ps=1.06u w=0.5u l=0.64u
X1435 a_19914_125050# DAC_7__Vb VSS VSS nfet_03v3 ad=0.6p pd=3.2u as=0.6p ps=3.2u w=1u l=8u
X1438 a_26214_94846# DAC_7__Vb VSS VSS nfet_03v3 ad=0.6p pd=3.2u as=0.6p ps=3.2u w=1u l=8u
X1440 a_19914_50454# DAC_7__Vb VSS VSS nfet_03v3 ad=0.6p pd=3.2u as=0.6p ps=3.2u w=1u l=8u
X1445 a_88122_51444# neuron_4__VIp VSS VSS nfet_03v3 ad=0.6p pd=3.2u as=0.6p ps=3.2u w=1u l=1u
X1447 VDD DPI_4__VT DPI_4__VT VDD pfet_03v3 ad=0.14p pd=1.06u as=0.14p ps=1.06u w=0.5u l=0.64u
X1458 VDD DPI_4__Vthr DAC_6__Isum_e DAC_6__Isum_e nfet_03v3 ad=0.3p pd=2.2u as=0.3p ps=2.2u w=0.5u l=0.64u
X1467 a_22014_80658# w[18] a_16310_80708# VSS nfet_03v3 ad=0.3p pd=2.2u as=0.14p ps=1.06u w=0.5u l=0.64u
X1481 a_19914_13502# w[3] a_16310_13552# VSS nfet_03v3 ad=0.14p pd=1.06u as=0.14p ps=1.06u w=0.5u l=0.64u
X1486 a_87742_14142# VT a_85942_14492# VSS nfet_03v3 ad=2.4p pd=9.2u as=2.4p ps=9.2u w=4u l=2u
X1489 VDD a_67078_93720# a_62978_88056# VDD pfet_03v3 ad=0.3p pd=2.2u as=0.3p ps=2.2u w=0.5u l=0.64u
X1491 DPI_4__Vthr DPI_4__Vthr VDD VDD pfet_03v3 ad=0.14p pd=1.06u as=0.14p ps=1.06u w=0.5u l=0.64u
X1492 a_19914_80658# w[19] a_16310_80708# VSS nfet_03v3 ad=0.14p pd=1.06u as=0.14p ps=1.06u w=0.5u l=0.64u
X1493 VDD a_62266_82612# cap_mim_2f0_m4m5_noshield c_width=22.18u c_length=22.18u
X1498 a_22014_13502# DAC_7__Vb VSS VSS nfet_03v3 ad=0.6p pd=3.2u as=0.6p ps=3.2u w=1u l=8u
X1502 a_22014_64642# w[14] a_16310_64692# VSS nfet_03v3 ad=0.3p pd=2.2u as=0.14p ps=1.06u w=0.5u l=0.64u
X1505 a_26214_50454# DAC_7__Vb VSS VSS nfet_03v3 ad=0.6p pd=3.2u as=0.6p ps=3.2u w=1u l=8u
X1514 VDD a_21486_142736# neuron_4__Vlk VDD pfet_03v3 ad=0.504p pd=2.88u as=0.504p ps=2.88u w=0.84u l=16u
X1520 a_22014_80658# DAC_7__Vb VSS VSS nfet_03v3 ad=0.6p pd=3.2u as=0.6p ps=3.2u w=1u l=8u
X1522 DPI_4__VT DPI_4__VT VDD VDD pfet_03v3 ad=0.14p pd=1.06u as=0.14p ps=1.06u w=0.5u l=0.64u
X1524 a_19914_64642# w[15] a_16310_64692# VSS nfet_03v3 ad=0.14p pd=1.06u as=0.14p ps=1.06u w=0.5u l=0.64u
X1530 neuron_4__VKdn neuron_4__VKdn VSS VSS nfet_03v3 ad=0.28p pd=1.56u as=0.28p ps=1.56u w=1u l=1u
X1546 a_62978_118260# a_62978_118260# VSS VSS nfet_03v3 ad=1.2p pd=5.2u as=1.2p ps=5.2u w=2u l=8u
X1548 a_16310_110912# w[27] a_19914_110862# VSS nfet_03v3 ad=0.14p pd=1.06u as=0.14p ps=1.06u w=0.5u l=0.64u
X1551 VDD DPI_4__Vthr DAC_1__Isum_i DAC_1__Isum_i nfet_03v3 ad=0.3p pd=2.2u as=0.3p ps=2.2u w=0.5u l=0.64u
X1556 VDD neuron_4__VKup a_91556_87964# VDD pfet_03v3 ad=0.6p pd=3.2u as=0.6p ps=3.2u w=1u l=1u
X1562 VDD DPI_4__Vthr DPI_4__Vthr VDD pfet_03v3 ad=0.14p pd=1.06u as=0.14p ps=1.06u w=0.5u l=0.64u
X1569 a_19914_50454# DAC_7__Vb VSS VSS nfet_03v3 ad=0.6p pd=3.2u as=0.6p ps=3.2u w=1u l=8u
X1577 VDD DPI_4__Vthr DPI_4__Vthr VDD pfet_03v3 ad=0.14p pd=1.06u as=0.14p ps=1.06u w=0.5u l=0.64u
X1598 VSS neuron_4__Vlk neuron_4__Vlk VSS nfet_03v3 ad=0.6p pd=3.2u as=0.28p ps=1.56u w=1u l=1u
X1600 a_19914_80658# w[19] a_16310_80708# VSS nfet_03v3 ad=0.3p pd=2.2u as=0.14p ps=1.06u w=0.5u l=0.64u
X1604 a_19914_50454# w[11] a_16310_50504# VSS nfet_03v3 ad=0.14p pd=1.06u as=0.14p ps=1.06u w=0.5u l=0.64u
X1605 a_19914_64642# DAC_7__Vb VSS VSS nfet_03v3 ad=0.6p pd=3.2u as=0.6p ps=3.2u w=1u l=8u
X1632 a_19914_64642# w[15] a_16310_64692# VSS nfet_03v3 ad=0.3p pd=2.2u as=0.14p ps=1.06u w=0.5u l=0.64u
X1639 spike[2] VSS cap_mim_2f0_m4m5_noshield c_width=10u c_length=10u
X1644 a_16310_125100# w[31] a_19914_125050# VSS nfet_03v3 ad=0.14p pd=1.06u as=0.14p ps=1.06u w=0.5u l=0.64u
X1646 a_26214_110862# w[25] a_16310_110912# VSS nfet_03v3 ad=0.3p pd=2.2u as=0.14p ps=1.06u w=0.5u l=0.64u
X1648 VDD DPI_4__VT DPI_4__VT VDD pfet_03v3 ad=0.3p pd=2.2u as=0.14p ps=1.06u w=0.5u l=0.64u
X1656 a_26214_64642# DAC_7__Vb VSS VSS nfet_03v3 ad=0.6p pd=3.2u as=0.6p ps=3.2u w=1u l=8u
X1659 a_16310_32028# w[5] a_26214_31978# VSS nfet_03v3 ad=0.14p pd=1.06u as=0.3p ps=2.2u w=0.5u l=0.64u
X1666 a_34614_80658# DAC_7__Vb VSS VSS nfet_03v3 ad=0.6p pd=3.2u as=0.6p ps=3.2u w=1u l=8u
X1672 VMEM_1 neuron_4__Vlk VSS VSS nfet_03v3 ad=0.6p pd=3.2u as=0.6p ps=3.2u w=1u l=1u
X1677 a_22014_94846# DAC_7__Vb VSS VSS nfet_03v3 ad=0.6p pd=3.2u as=0.6p ps=3.2u w=1u l=8u
X1682 neuron_4__Vlk neuron_4__Vlk VSS VSS nfet_03v3 ad=0.28p pd=1.56u as=0.28p ps=1.56u w=1u l=1u
X1688 a_17058_124892# s[7] VSS VSS nfet_03v3 ad=0.3p pd=2.2u as=0.3p ps=2.2u w=0.5u l=0.64u
X1689 VMEM_4 a_62978_118260# VSS VSS nfet_03v3 ad=1.44p pd=6u as=1.44p ps=6u w=2.4u l=8u
X1697 VDD a_87742_111502# a_88370_111852# VDD pfet_03v3 ad=0.3p pd=2.2u as=0.3p ps=2.2u w=0.5u l=0.64u
X1704 a_19914_31978# DAC_7__Vb VSS VSS nfet_03v3 ad=0.6p pd=3.2u as=0.6p ps=3.2u w=1u l=8u
X1705 a_22014_125050# DAC_7__Vb VSS VSS nfet_03v3 ad=0.6p pd=3.2u as=0.6p ps=3.2u w=1u l=8u
X1706 a_16310_110912# w[24] a_34614_110862# VSS nfet_03v3 ad=0.3p pd=2.2u as=0.3p ps=2.2u w=0.5u l=0.64u
X1708 a_34614_110862# DAC_7__Vb VSS VSS nfet_03v3 ad=0.6p pd=3.2u as=0.6p ps=3.2u w=1u l=8u
X1725 a_19914_64642# DAC_7__Vb VSS VSS nfet_03v3 ad=0.6p pd=3.2u as=0.6p ps=3.2u w=1u l=8u
X1730 DPI_4__VT DPI_4__VT VDD VDD pfet_03v3 ad=0.14p pd=1.06u as=0.14p ps=1.06u w=0.5u l=0.64u
X1734 VDD DPI_4__VT DPI_4__VT VDD pfet_03v3 ad=0.14p pd=1.06u as=0.14p ps=1.06u w=0.5u l=0.64u
X1735 VDD s[4] a_17058_80500# VDD pfet_03v3 ad=0.3p pd=2.2u as=0.3p ps=2.2u w=0.5u l=0.32u
X1739 DPI_4__VT DPI_4__VT VDD VDD pfet_03v3 ad=0.14p pd=1.06u as=0.14p ps=1.06u w=0.5u l=0.64u
X1751 a_19914_13502# w[3] a_16310_13552# VSS nfet_03v3 ad=0.14p pd=1.06u as=0.14p ps=1.06u w=0.5u l=0.64u
X1755 VDD a_86480_118168# a_87742_111502# VDD pfet_03v3 ad=0.3p pd=2.2u as=0.3p ps=2.2u w=0.5u l=8u
X1766 VDD a_86480_87964# a_86480_87964# VDD pfet_03v3 ad=0.3p pd=2.2u as=0.3p ps=2.2u w=0.5u l=8u
X1773 a_22014_31978# DAC_7__Vb VSS VSS nfet_03v3 ad=0.6p pd=3.2u as=0.6p ps=3.2u w=1u l=8u
X1780 VDD DPI_4__Vthr DPI_4__Vthr VDD pfet_03v3 ad=0.3p pd=2.2u as=0.14p ps=1.06u w=0.5u l=0.64u
X1794 a_19914_13502# DAC_7__Vb VSS VSS nfet_03v3 ad=0.6p pd=3.2u as=0.6p ps=3.2u w=1u l=8u
X1796 VDD DPI_4__Vthr DPI_4__Vthr VDD pfet_03v3 ad=0.14p pd=1.06u as=0.14p ps=1.06u w=0.5u l=0.64u
X1808 a_34614_94846# DAC_7__Vb VSS VSS nfet_03v3 ad=0.6p pd=3.2u as=0.6p ps=3.2u w=1u l=8u
X1812 VDD bias_0__VT_inh bias_0__VT_inh VDD pfet_03v3 ad=0.2464p pd=1.44u as=0.2464p ps=1.44u w=0.88u l=1.12u
X1817 a_85942_32968# neuron_4__Vamp_bias VSS VSS nfet_03v3 ad=0.3p pd=2.2u as=0.3p ps=2.2u w=0.5u l=0.64u
X1820 VDD s[5] a_17058_94688# VDD pfet_03v3 ad=0.3p pd=2.2u as=0.3p ps=2.2u w=0.5u l=0.32u
X1845 a_19914_50454# w[11] a_16310_50504# VSS nfet_03v3 ad=0.14p pd=1.06u as=0.14p ps=1.06u w=0.5u l=0.64u
X1849 DPI_4__Vthr DPI_4__Vthr VDD VDD pfet_03v3 ad=0.14p pd=1.06u as=0.14p ps=1.06u w=0.5u l=0.64u
X1851 a_22014_13502# DAC_7__Vb VSS VSS nfet_03v3 ad=0.6p pd=3.2u as=0.6p ps=3.2u w=1u l=8u
X1854 a_16310_125100# w[31] a_19914_125050# VSS nfet_03v3 ad=0.14p pd=1.06u as=0.14p ps=1.06u w=0.5u l=0.64u
X1857 a_19914_110862# DAC_7__Vb VSS VSS nfet_03v3 ad=0.6p pd=3.2u as=0.6p ps=3.2u w=1u l=8u
X1862 neuron_4__Vlk neuron_4__Vlk VSS VSS nfet_03v3 ad=0.28p pd=1.56u as=0.6p ps=3.2u w=1u l=1u
X1894 VDD DPI_4__Vthr DAC_5__Isum_e DAC_5__Isum_e nfet_03v3 ad=0.3p pd=2.2u as=0.3p ps=2.2u w=0.5u l=0.64u
X1896 bias_0__VT_inh bias_0__VT_inh VDD VDD pfet_03v3 ad=0.2464p pd=1.44u as=0.2464p ps=1.44u w=0.88u l=1.12u
X1917 a_19914_50454# DAC_7__Vb VSS VSS nfet_03v3 ad=0.6p pd=3.2u as=0.6p ps=3.2u w=1u l=8u
X1919 VMEM_0 VSS cap_mim_2f0_m4m5_noshield c_width=22.18u c_length=22.18u
X1925 DPI_4__VT DPI_4__VT VDD VDD pfet_03v3 ad=0.14p pd=1.06u as=0.14p ps=1.06u w=0.5u l=0.64u
X1926 a_26214_125050# w[29] a_16310_125100# VSS nfet_03v3 ad=0.3p pd=2.2u as=0.14p ps=1.06u w=0.5u l=0.64u
X1928 a_19914_80658# DAC_7__Vb VSS VSS nfet_03v3 ad=0.6p pd=3.2u as=0.6p ps=3.2u w=1u l=8u
X1933 a_16310_80708# w[18] a_22014_80658# VSS nfet_03v3 ad=0.14p pd=1.06u as=0.14p ps=1.06u w=0.5u l=0.64u
X1937 VMEM_4 VSS cap_mim_2f0_m4m5_noshield c_width=22.18u c_length=22.18u
X1941 a_16558_80708# spike[0] a_16310_80708# VSS nfet_03v3 ad=0.3p pd=2.2u as=0.3p ps=2.2u w=0.5u l=0.64u
X1952 a_16310_80708# w[19] a_19914_80658# VSS nfet_03v3 ad=0.14p pd=1.06u as=0.14p ps=1.06u w=0.5u l=0.64u
X1962 a_16310_64692# w[14] a_22014_64642# VSS nfet_03v3 ad=0.14p pd=1.06u as=0.14p ps=1.06u w=0.5u l=0.64u
X1966 a_16310_13552# w[1] a_26214_13502# VSS nfet_03v3 ad=0.14p pd=1.06u as=0.3p ps=2.2u w=0.5u l=0.64u
X1969 a_16310_125100# w[28] a_34614_125050# VSS nfet_03v3 ad=0.3p pd=2.2u as=0.3p ps=2.2u w=0.5u l=0.64u
X1971 a_34614_125050# DAC_7__Vb VSS VSS nfet_03v3 ad=0.6p pd=3.2u as=0.6p ps=3.2u w=1u l=8u
X1973 a_16558_64692# spike[1] a_16310_64692# VSS nfet_03v3 ad=0.3p pd=2.2u as=0.3p ps=2.2u w=0.5u l=0.64u
X1982 a_16310_64692# w[15] a_19914_64642# VSS nfet_03v3 ad=0.14p pd=1.06u as=0.14p ps=1.06u w=0.5u l=0.64u
X1994 DPI_4__VT DPI_4__VT VDD VDD pfet_03v3 ad=0.14p pd=1.06u as=0.3p ps=2.2u w=0.5u l=0.64u
X1998 VDD DPI_4__VT DPI_4__VT VDD pfet_03v3 ad=0.14p pd=1.06u as=0.14p ps=1.06u w=0.5u l=0.64u
X2015 VDD a_67078_93720# cap_mim_2f0_m4m5_noshield c_width=22.18u c_length=22.18u
X2023 a_19914_31978# DAC_7__Vb VSS VSS nfet_03v3 ad=0.6p pd=3.2u as=0.6p ps=3.2u w=1u l=8u
X2032 DPI_4__Vthr DPI_4__Vthr VDD VDD pfet_03v3 ad=0.14p pd=1.06u as=0.14p ps=1.06u w=0.5u l=0.64u
X2041 DPI_4__Vthr DPI_4__Vthr VDD VDD pfet_03v3 ad=0.14p pd=1.06u as=0.14p ps=1.06u w=0.5u l=0.64u
X2042 a_16310_80708# w[19] a_19914_80658# VSS nfet_03v3 ad=0.14p pd=1.06u as=0.14p ps=1.06u w=0.5u l=0.64u
X2049 a_19914_64642# DAC_7__Vb VSS VSS nfet_03v3 ad=0.6p pd=3.2u as=0.6p ps=3.2u w=1u l=8u
X2056 a_88750_32968# neuron_4__VKdn VSS VSS nfet_03v3 ad=0.6p pd=3.2u as=0.6p ps=3.2u w=1u l=1u
X2057 a_19914_94846# DAC_7__Vb VSS VSS nfet_03v3 ad=0.6p pd=3.2u as=0.6p ps=3.2u w=1u l=8u
X2060 a_16310_50504# w[9] a_26214_50454# VSS nfet_03v3 ad=0.14p pd=1.06u as=0.3p ps=2.2u w=0.5u l=0.64u
X2065 VMEM_3 VSS cap_mim_2f0_m4m5_noshield c_width=22.18u c_length=22.18u
X2066 a_16310_64692# w[15] a_19914_64642# VSS nfet_03v3 ad=0.14p pd=1.06u as=0.14p ps=1.06u w=0.5u l=0.64u
X2069 DAC_6__Isum_e a_17058_31820# a_16558_32028# VSS nfet_03v3 ad=0.3p pd=2.2u as=0.3p ps=2.2u w=0.5u l=0.64u
X2071 neuron_4__Vlk neuron_4__Vlk VSS VSS nfet_03v3 ad=0.28p pd=1.56u as=0.28p ps=1.56u w=1u l=1u
X2074 a_26214_110862# DAC_7__Vb VSS VSS nfet_03v3 ad=0.6p pd=3.2u as=0.6p ps=3.2u w=1u l=8u
X2075 spike[4] VSS cap_mim_2f0_m4m5_noshield c_width=10u c_length=10u
X2078 a_22014_31978# DAC_7__Vb VSS VSS nfet_03v3 ad=0.6p pd=3.2u as=0.6p ps=3.2u w=1u l=8u
X2079 VMEM_2 a_62978_57852# VSS VSS nfet_03v3 ad=1.44p pd=6u as=1.44p ps=6u w=2.4u l=8u
X2086 a_62266_33932# a_62266_33932# DAC_6__Isum_e DAC_6__Isum_e nfet_03v3 ad=0.3p pd=2.2u as=0.3p ps=2.2u w=0.5u l=0.64u
X2089 VDD a_62266_15456# VMEM_0 VDD pfet_03v3 ad=0.3p pd=2.2u as=0.3p ps=2.2u w=0.5u l=0.64u
X2093 a_17058_31820# s[1] VSS VSS nfet_03v3 ad=0.3p pd=2.2u as=0.3p ps=2.2u w=0.5u l=0.64u
X2097 a_86480_57760# VMEM_2 a_85942_51444# VSS nfet_03v3 ad=2.4p pd=9.2u as=2.4p ps=9.2u w=4u l=2u
X2100 a_16310_80708# w[19] a_19914_80658# VSS nfet_03v3 ad=0.14p pd=1.06u as=0.3p ps=2.2u w=0.5u l=0.64u
X2120 VMEM_0 neuron_4__Vlk VSS VSS nfet_03v3 ad=0.6p pd=3.2u as=0.6p ps=3.2u w=1u l=1u
X2125 a_19914_125050# DAC_7__Vb VSS VSS nfet_03v3 ad=0.6p pd=3.2u as=0.6p ps=3.2u w=1u l=8u
X2127 VMEM_4 neuron_4__Vlk VSS VSS nfet_03v3 ad=0.6p pd=3.2u as=0.6p ps=3.2u w=1u l=1u
X2129 a_16310_64692# w[15] a_19914_64642# VSS nfet_03v3 ad=0.14p pd=1.06u as=0.3p ps=2.2u w=0.5u l=0.64u
X2143 a_19914_110862# DAC_7__Vb VSS VSS nfet_03v3 ad=0.6p pd=3.2u as=0.6p ps=3.2u w=1u l=8u
X2151 a_62978_57852# a_62978_57852# VSS VSS nfet_03v3 ad=1.2p pd=5.2u as=1.2p ps=5.2u w=2u l=8u
X2158 DAC_3__Isum_i s[5] a_16558_94896# VSS nfet_03v3 ad=0.3p pd=2.2u as=0.3p ps=2.2u w=0.5u l=0.64u
X2166 a_91556_118168# a_88370_111852# spike[4] VDD pfet_03v3 ad=0.3p pd=2.2u as=0.3p ps=2.2u w=0.5u l=0.64u
X2172 a_16310_80708# w[18] a_22014_80658# VSS nfet_03v3 ad=0.14p pd=1.06u as=0.3p ps=2.2u w=0.5u l=0.64u
X2177 a_22014_13502# DAC_7__Vb VSS VSS nfet_03v3 ad=0.6p pd=3.2u as=0.6p ps=3.2u w=1u l=8u
X2183 VDD DPI_4__VT DPI_4__VT VDD pfet_03v3 ad=0.14p pd=1.06u as=0.14p ps=1.06u w=0.5u l=0.64u
X2189 VMEM_1 spike[1] a_89378_32968# VSS nfet_03v3 ad=0.3p pd=2.2u as=0.3p ps=2.2u w=0.5u l=11.36u
X2190 a_16310_80708# w[19] a_19914_80658# VSS nfet_03v3 ad=0.14p pd=1.06u as=0.14p ps=1.06u w=0.5u l=0.64u
X2191 VDD a_62266_52408# VMEM_2 VDD pfet_03v3 ad=0.3p pd=2.2u as=0.3p ps=2.2u w=0.5u l=0.64u
X2193 a_89378_51444# neuron_4__VK VSS VSS nfet_03v3 ad=0.6p pd=3.2u as=0.6p ps=3.2u w=1u l=1u
X2195 a_26214_31978# w[5] a_16310_32028# VSS nfet_03v3 ad=0.3p pd=2.2u as=0.14p ps=1.06u w=0.5u l=0.64u
X2199 a_16310_64692# w[14] a_22014_64642# VSS nfet_03v3 ad=0.14p pd=1.06u as=0.3p ps=2.2u w=0.5u l=0.64u
X2201 spike[3] a_88370_81648# a_88750_81648# VSS nfet_03v3 ad=0.3p pd=2.2u as=0.3p ps=2.2u w=0.5u l=0.64u
X2203 VDD a_87742_81298# a_88370_81648# VDD pfet_03v3 ad=0.3p pd=2.2u as=0.3p ps=2.2u w=0.5u l=0.64u
X2204 VDD a_67078_63516# cap_mim_2f0_m4m5_noshield c_width=22.18u c_length=22.18u
X2223 a_16310_64692# w[15] a_19914_64642# VSS nfet_03v3 ad=0.14p pd=1.06u as=0.14p ps=1.06u w=0.5u l=0.64u
X2229 a_22014_94846# w[22] a_16310_94896# VSS nfet_03v3 ad=0.14p pd=1.06u as=0.14p ps=1.06u w=0.5u l=0.64u
X2235 a_19914_110862# DAC_7__Vb VSS VSS nfet_03v3 ad=0.6p pd=3.2u as=0.6p ps=3.2u w=1u l=8u
X2237 a_19914_13502# DAC_7__Vb VSS VSS nfet_03v3 ad=0.6p pd=3.2u as=0.6p ps=3.2u w=1u l=8u
X2241 a_19914_50454# DAC_7__Vb VSS VSS nfet_03v3 ad=0.6p pd=3.2u as=0.6p ps=3.2u w=1u l=8u
X2245 VSS neuron_4__VKdn neuron_4__VKdn VSS nfet_03v3 ad=0.6p pd=3.2u as=0.28p ps=1.56u w=1u l=1u
X2248 VDD DPI_4__VT DPI_4__VT VDD pfet_03v3 ad=0.14p pd=1.06u as=0.14p ps=1.06u w=0.5u l=0.64u
X2255 a_16310_80708# w[16] a_34614_80658# VSS nfet_03v3 ad=0.3p pd=2.2u as=0.3p ps=2.2u w=0.5u l=0.64u
X2257 a_85942_14492# neuron_4__Vamp_bias VSS VSS nfet_03v3 ad=0.3p pd=2.2u as=0.3p ps=2.2u w=0.5u l=0.64u
X2263 VDD DPI_4__VT a_62266_82612# VDD pfet_03v3 ad=0.3p pd=2.2u as=0.3p ps=2.2u w=0.5u l=0.64u
X2264 a_19914_80658# DAC_7__Vb VSS VSS nfet_03v3 ad=0.6p pd=3.2u as=0.6p ps=3.2u w=1u l=8u
X2265 VDD a_21486_142736# neuron_4__VKdn VDD pfet_03v3 ad=7.764p pd=27.08u as=7.764p ps=27.08u w=12.94u l=8u
X2272 a_88122_81648# neuron_4__VIp VSS VSS nfet_03v3 ad=0.6p pd=3.2u as=0.6p ps=3.2u w=1u l=1u
X2274 neuron_4__Vamp_bias neuron_4__Vamp_bias VSS VSS nfet_03v3 ad=0.3p pd=2.2u as=0.3p ps=2.2u w=0.5u l=0.64u
X2290 VDD a_62266_33932# cap_mim_2f0_m4m5_noshield c_width=22.18u c_length=22.18u
X2292 a_16310_64692# w[12] a_34614_64642# VSS nfet_03v3 ad=0.3p pd=2.2u as=0.3p ps=2.2u w=0.5u l=0.64u
X2298 a_22014_110862# DAC_7__Vb VSS VSS nfet_03v3 ad=0.6p pd=3.2u as=0.6p ps=3.2u w=1u l=8u
X2300 a_87742_51094# VT a_85942_51444# VSS nfet_03v3 ad=2.4p pd=9.2u as=2.4p ps=9.2u w=4u l=2u
X2310 VDD DPI_4__Vthr DPI_4__Vthr VDD pfet_03v3 ad=0.14p pd=1.06u as=0.14p ps=1.06u w=0.5u l=0.64u
X2311 bias_0__VT_inh bias_0__VT_inh VDD VDD pfet_03v3 ad=0.2464p pd=1.44u as=0.528p ps=2.96u w=0.88u l=1.12u
X2317 a_22014_50454# DAC_7__Vb VSS VSS nfet_03v3 ad=0.6p pd=3.2u as=0.6p ps=3.2u w=1u l=8u
X2318 VDD DPI_4__Vthr DAC_5__Isum_i DAC_5__Isum_i nfet_03v3 ad=0.3p pd=2.2u as=0.3p ps=2.2u w=0.5u l=0.64u
X2325 a_22014_94846# w[22] a_16310_94896# VSS nfet_03v3 ad=0.3p pd=2.2u as=0.14p ps=1.06u w=0.5u l=0.64u
X2329 a_26214_80658# DAC_7__Vb VSS VSS nfet_03v3 ad=0.6p pd=3.2u as=0.6p ps=3.2u w=1u l=8u
X2338 a_16310_110912# w[26] a_22014_110862# VSS nfet_03v3 ad=0.14p pd=1.06u as=0.14p ps=1.06u w=0.5u l=0.64u
X2343 a_91556_39284# a_88370_32968# spike[1] VDD pfet_03v3 ad=0.3p pd=2.2u as=0.3p ps=2.2u w=0.5u l=0.64u
X2344 a_19914_94846# w[23] a_16310_94896# VSS nfet_03v3 ad=0.14p pd=1.06u as=0.14p ps=1.06u w=0.5u l=0.64u
X2364 a_85942_51444# neuron_4__Vamp_bias VSS VSS nfet_03v3 ad=0.3p pd=2.2u as=0.3p ps=2.2u w=0.5u l=0.64u
X2368 bias_0__VT_inh bias_0__VT_inh VDD VDD pfet_03v3 ad=0.2464p pd=1.44u as=0.2464p ps=1.44u w=0.88u l=1.12u
X2370 a_26214_125050# DAC_7__Vb VSS VSS nfet_03v3 ad=0.6p pd=3.2u as=0.6p ps=3.2u w=1u l=8u
X2384 DPI_4__Vthr DPI_4__Vthr VDD VDD pfet_03v3 ad=0.14p pd=1.06u as=0.14p ps=1.06u w=0.5u l=0.64u
X2387 a_19914_64642# DAC_7__Vb VSS VSS nfet_03v3 ad=0.6p pd=3.2u as=0.6p ps=3.2u w=1u l=8u
X2389 DPI_4__Vthr Iref VSS VSS nfet_03v3 ad=0.546p pd=3.02u as=0.546p ps=3.02u w=0.91u l=32u
X2392 a_19914_80658# DAC_7__Vb VSS VSS nfet_03v3 ad=0.6p pd=3.2u as=0.6p ps=3.2u w=1u l=8u
X2396 DAC_7__Isum_e a_17058_13344# a_16558_13552# VSS nfet_03v3 ad=0.3p pd=2.2u as=0.3p ps=2.2u w=0.5u l=0.64u
X2398 VDD DPI_4__VT DPI_4__VT VDD pfet_03v3 ad=0.14p pd=1.06u as=0.14p ps=1.06u w=0.5u l=0.64u
X2412 VDD a_62266_52408# cap_mim_2f0_m4m5_noshield c_width=22.18u c_length=22.18u
X2415 a_19914_94846# DAC_7__Vb VSS VSS nfet_03v3 ad=0.6p pd=3.2u as=0.6p ps=3.2u w=1u l=8u
X2416 a_19914_80658# w[19] a_16310_80708# VSS nfet_03v3 ad=0.14p pd=1.06u as=0.14p ps=1.06u w=0.5u l=0.64u
X2423 a_17058_13344# s[0] VSS VSS nfet_03v3 ad=0.3p pd=2.2u as=0.3p ps=2.2u w=0.5u l=0.64u
X2439 a_19914_125050# DAC_7__Vb VSS VSS nfet_03v3 ad=0.6p pd=3.2u as=0.6p ps=3.2u w=1u l=8u
X2440 a_22014_31978# DAC_7__Vb VSS VSS nfet_03v3 ad=0.6p pd=3.2u as=0.6p ps=3.2u w=1u l=8u
X2450 a_19914_94846# w[23] a_16310_94896# VSS nfet_03v3 ad=0.3p pd=2.2u as=0.14p ps=1.06u w=0.5u l=0.64u
X2453 a_19914_64642# w[15] a_16310_64692# VSS nfet_03v3 ad=0.14p pd=1.06u as=0.14p ps=1.06u w=0.5u l=0.64u
X2463 VDD s[3] a_17058_64484# VDD pfet_03v3 ad=0.3p pd=2.2u as=0.3p ps=2.2u w=0.5u l=0.32u
X2465 DPI_4__VT DPI_4__VT VDD VDD pfet_03v3 ad=0.14p pd=1.06u as=0.14p ps=1.06u w=0.5u l=0.64u
X2470 a_22014_64642# DAC_7__Vb VSS VSS nfet_03v3 ad=0.6p pd=3.2u as=0.6p ps=3.2u w=1u l=8u
X2477 VDD neuron_4__VNA neuron_4__VNA VDD pfet_03v3 ad=0.3p pd=2.2u as=0.3p ps=2.2u w=0.5u l=45.45u
X2479 a_26214_94846# DAC_7__Vb VSS VSS nfet_03v3 ad=0.6p pd=3.2u as=0.6p ps=3.2u w=1u l=8u
X2483 VDD a_67078_123924# cap_mim_2f0_m4m5_noshield c_width=22.18u c_length=22.18u
X2486 bias_0__VT_inh bias_0__VT_inh VDD VDD pfet_03v3 ad=0.2464p pd=1.44u as=0.2464p ps=1.44u w=0.88u l=1.12u
X2494 a_19914_31978# DAC_7__Vb VSS VSS nfet_03v3 ad=0.6p pd=3.2u as=0.6p ps=3.2u w=1u l=8u
X2503 VDD DPI_4__VT a_67078_93720# VDD pfet_03v3 ad=0.3p pd=2.2u as=0.3p ps=2.2u w=0.5u l=0.64u
X2506 DAC_5__Isum_e a_17058_50296# a_16558_50504# VSS nfet_03v3 ad=0.3p pd=2.2u as=0.3p ps=2.2u w=0.5u l=0.64u
X2508 a_16558_110912# spike[2] a_16310_110912# VSS nfet_03v3 ad=0.3p pd=2.2u as=0.3p ps=2.2u w=0.5u l=0.64u
X2511 VDD a_21486_142736# neuron_4__VIp VDD pfet_03v3 ad=1.404p pd=5.88u as=1.404p ps=5.88u w=2.34u l=8u
X2513_0 neuron_4__VK neuron_4__VK X2513_s1 VSS nfet_03v3 ad=0.3p pd=2.2u as=0.3p ps=2.2u w=0.5u l=45.4550u
X2513_1 X2513_s1 neuron_4__VK VSS VSS nfet_03v3 ad=0.3p pd=2.2u as=0.3p ps=2.2u w=0.5u l=45.4550u
X2515 a_62266_52408# a_62266_52408# DAC_5__Isum_e DAC_5__Isum_e nfet_03v3 ad=0.3p pd=2.2u as=0.3p ps=2.2u w=0.5u l=0.64u
X2516 VDD a_62266_33932# VMEM_1 VDD pfet_03v3 ad=0.3p pd=2.2u as=0.3p ps=2.2u w=0.5u l=0.64u
X2518 a_17058_50296# s[2] VSS VSS nfet_03v3 ad=0.3p pd=2.2u as=0.3p ps=2.2u w=0.5u l=0.64u
X2519 VDD DPI_4__Vthr DPI_4__Vthr VDD pfet_03v3 ad=0.14p pd=1.06u as=0.14p ps=1.06u w=0.5u l=0.64u
X2523 a_26214_13502# w[1] a_16310_13552# VSS nfet_03v3 ad=0.3p pd=2.2u as=0.14p ps=1.06u w=0.5u l=0.64u
X2526 VDD neuron_4__VNA a_92184_118168# VDD pfet_03v3 ad=0.6p pd=3.2u as=0.6p ps=3.2u w=1u l=1u
X2532 a_19914_125050# DAC_7__Vb VSS VSS nfet_03v3 ad=0.6p pd=3.2u as=0.6p ps=3.2u w=1u l=8u
X2533 a_19914_94846# DAC_7__Vb VSS VSS nfet_03v3 ad=0.6p pd=3.2u as=0.6p ps=3.2u w=1u l=8u
X2540 a_88750_14492# neuron_4__VKdn VSS VSS nfet_03v3 ad=0.6p pd=3.2u as=0.6p ps=3.2u w=1u l=1u
X2541 VDD DPI_4__VT DPI_4__VT VDD pfet_03v3 ad=0.14p pd=1.06u as=0.14p ps=1.06u w=0.5u l=0.64u
X2548 a_19914_110862# DAC_7__Vb VSS VSS nfet_03v3 ad=0.6p pd=3.2u as=0.6p ps=3.2u w=1u l=8u
X2557 VDD neuron_4__VNA a_92184_39284# VDD pfet_03v3 ad=0.6p pd=3.2u as=0.6p ps=3.2u w=1u l=1u
X2571 a_19914_110862# w[27] a_16310_110912# VSS nfet_03v3 ad=0.14p pd=1.06u as=0.14p ps=1.06u w=0.5u l=0.64u
X2581 DPI_4__Vthr DPI_4__Vthr VDD VDD pfet_03v3 ad=0.14p pd=1.06u as=0.14p ps=1.06u w=0.5u l=0.64u
X2591 a_19914_13502# DAC_7__Vb VSS VSS nfet_03v3 ad=0.6p pd=3.2u as=0.6p ps=3.2u w=1u l=8u
X2599 a_22014_125050# DAC_7__Vb VSS VSS nfet_03v3 ad=0.6p pd=3.2u as=0.6p ps=3.2u w=1u l=8u
X2600 a_19914_50454# DAC_7__Vb VSS VSS nfet_03v3 ad=0.6p pd=3.2u as=0.6p ps=3.2u w=1u l=8u
X2602 DPI_4__Vthr DPI_4__Vthr VDD VDD pfet_03v3 ad=0.14p pd=1.06u as=0.14p ps=1.06u w=0.5u l=0.64u
X2622 a_26214_50454# w[9] a_16310_50504# VSS nfet_03v3 ad=0.3p pd=2.2u as=0.14p ps=1.06u w=0.5u l=0.64u
X2626 VDD s[7] a_17058_124892# VDD pfet_03v3 ad=0.3p pd=2.2u as=0.3p ps=2.2u w=0.5u l=0.32u
X2632 a_16310_125100# w[30] a_22014_125050# VSS nfet_03v3 ad=0.14p pd=1.06u as=0.14p ps=1.06u w=0.5u l=0.64u
X2636 a_16310_110912# w[27] a_19914_110862# VSS nfet_03v3 ad=0.14p pd=1.06u as=0.3p ps=2.2u w=0.5u l=0.64u
X2638 VDD bias_0__VT_inh bias_0__VT_inh VDD pfet_03v3 ad=0.2464p pd=1.44u as=0.2464p ps=1.44u w=0.88u l=1.12u
X2646 a_26214_13502# DAC_7__Vb VSS VSS nfet_03v3 ad=0.6p pd=3.2u as=0.6p ps=3.2u w=1u l=8u
X2653 a_19914_80658# w[19] a_16310_80708# VSS nfet_03v3 ad=0.14p pd=1.06u as=0.14p ps=1.06u w=0.5u l=0.64u
X2654 a_91556_20808# a_88370_14492# spike[0] VDD pfet_03v3 ad=0.3p pd=2.2u as=0.3p ps=2.2u w=0.5u l=0.64u
X2655 a_22014_50454# DAC_7__Vb VSS VSS nfet_03v3 ad=0.6p pd=3.2u as=0.6p ps=3.2u w=1u l=8u
X2664 DPI_4__VT DPI_4__VT VDD VDD pfet_03v3 ad=0.14p pd=1.06u as=0.14p ps=1.06u w=0.5u l=0.64u
X2666 VMEM_0 spike[0] a_89378_14492# VSS nfet_03v3 ad=0.3p pd=2.2u as=0.3p ps=2.2u w=0.5u l=11.36u
X2684 a_19914_64642# w[15] a_16310_64692# VSS nfet_03v3 ad=0.14p pd=1.06u as=0.14p ps=1.06u w=0.5u l=0.64u
X2699 VDD DPI_4__Vthr DAC_3__Isum_e DAC_3__Isum_e nfet_03v3 ad=0.3p pd=2.2u as=0.3p ps=2.2u w=0.5u l=0.64u
X2706 VDD DPI_4__VT a_62266_112816# VDD pfet_03v3 ad=0.3p pd=2.2u as=0.3p ps=2.2u w=0.5u l=0.64u
X2717 a_19914_64642# DAC_7__Vb VSS VSS nfet_03v3 ad=0.6p pd=3.2u as=0.6p ps=3.2u w=1u l=8u
X2722 a_19914_80658# DAC_7__Vb VSS VSS nfet_03v3 ad=0.6p pd=3.2u as=0.6p ps=3.2u w=1u l=8u
X2728 VDD DPI_4__VT DPI_4__VT VDD pfet_03v3 ad=0.14p pd=1.06u as=0.14p ps=1.06u w=0.5u l=0.64u
X2744 neuron_4__VNA Iref VSS VSS nfet_03v3 ad=3.456p pd=12.72u as=3.456p ps=12.72u w=5.76u l=8u
X2746 VMEM_1 VSS cap_mim_2f0_m4m5_noshield c_width=22.18u c_length=22.18u
X2750 VDD a_67078_63516# a_62978_57852# VDD pfet_03v3 ad=0.3p pd=2.2u as=0.3p ps=2.2u w=0.5u l=0.64u
X2751 VMEM_2 spike[2] a_89378_51444# VSS nfet_03v3 ad=0.3p pd=2.2u as=0.3p ps=2.2u w=0.5u l=11.36u
X2755 a_91556_57760# a_88370_51444# spike[2] VDD pfet_03v3 ad=0.3p pd=2.2u as=0.3p ps=2.2u w=0.5u l=0.64u
X2769 DPI_4__Vthr DPI_4__Vthr VDD VDD pfet_03v3 ad=0.14p pd=1.06u as=0.14p ps=1.06u w=0.5u l=0.64u
X2774 a_16310_94896# w[22] a_22014_94846# VSS nfet_03v3 ad=0.14p pd=1.06u as=0.14p ps=1.06u w=0.5u l=0.64u
X2776 VDD DPI_4__Vthr DAC_1__Isum_e DAC_1__Isum_e nfet_03v3 ad=0.3p pd=2.2u as=0.3p ps=2.2u w=0.5u l=0.64u
X2785 a_16558_125100# spike[3] a_16310_125100# VSS nfet_03v3 ad=0.3p pd=2.2u as=0.3p ps=2.2u w=0.5u l=0.64u
X2787 a_22014_64642# DAC_7__Vb VSS VSS nfet_03v3 ad=0.6p pd=3.2u as=0.6p ps=3.2u w=1u l=8u
X2796 a_16558_94896# spike[1] a_16310_94896# VSS nfet_03v3 ad=0.3p pd=2.2u as=0.3p ps=2.2u w=0.5u l=0.64u
X2804 a_16310_94896# w[23] a_19914_94846# VSS nfet_03v3 ad=0.14p pd=1.06u as=0.14p ps=1.06u w=0.5u l=0.64u
X2825 bias_0__VT_inh Iref VSS VSS nfet_03v3 ad=0.378p pd=2.46u as=0.378p ps=2.46u w=0.63u l=32u
X2829 a_19914_125050# DAC_7__Vb VSS VSS nfet_03v3 ad=0.6p pd=3.2u as=0.6p ps=3.2u w=1u l=8u
X2831 a_19914_110862# DAC_7__Vb VSS VSS nfet_03v3 ad=0.6p pd=3.2u as=0.6p ps=3.2u w=1u l=8u
X2837 a_88370_32968# a_87742_32618# a_88122_32968# VSS nfet_03v3 ad=0.3p pd=2.2u as=0.3p ps=2.2u w=0.5u l=0.64u
X2838 a_19914_31978# DAC_7__Vb VSS VSS nfet_03v3 ad=0.6p pd=3.2u as=0.6p ps=3.2u w=1u l=8u
X2846 a_16310_110912# w[27] a_19914_110862# VSS nfet_03v3 ad=0.14p pd=1.06u as=0.14p ps=1.06u w=0.5u l=0.64u
X2850 a_19914_125050# w[31] a_16310_125100# VSS nfet_03v3 ad=0.14p pd=1.06u as=0.14p ps=1.06u w=0.5u l=0.64u
X2857 VDD DPI_4__Vthr DPI_4__Vthr VDD pfet_03v3 ad=0.14p pd=1.06u as=0.14p ps=1.06u w=0.5u l=0.64u
X2858 a_22014_13502# DAC_7__Vb VSS VSS nfet_03v3 ad=0.6p pd=3.2u as=0.6p ps=3.2u w=1u l=8u
X2868 a_19914_94846# DAC_7__Vb VSS VSS nfet_03v3 ad=0.6p pd=3.2u as=0.6p ps=3.2u w=1u l=8u
X2876 VDD s[0] a_17058_13344# VDD pfet_03v3 ad=0.3p pd=2.2u as=0.3p ps=2.2u w=0.5u l=0.32u
X2889 a_16310_80708# w[17] a_26214_80658# VSS nfet_03v3 ad=0.14p pd=1.06u as=0.3p ps=2.2u w=0.5u l=0.64u
X2891 a_26214_31978# DAC_7__Vb VSS VSS nfet_03v3 ad=0.6p pd=3.2u as=0.6p ps=3.2u w=1u l=8u
X2897 a_16310_94896# w[23] a_19914_94846# VSS nfet_03v3 ad=0.14p pd=1.06u as=0.14p ps=1.06u w=0.5u l=0.64u
X2903 VSS neuron_4__Vlk neuron_4__Vlk VSS nfet_03v3 ad=0.28p pd=1.56u as=0.28p ps=1.56u w=1u l=1u
X2906 VMEM_3 a_62978_88056# VSS VSS nfet_03v3 ad=1.44p pd=6u as=1.44p ps=6u w=2.4u l=8u
X2912 VDD a_21486_142736# neuron_4__Vamp_bias VDD pfet_03v3 ad=5.484p pd=19.48u as=5.484p ps=19.48u w=9.14u l=8u
X2918 a_16310_125100# w[31] a_19914_125050# VSS nfet_03v3 ad=0.14p pd=1.06u as=0.3p ps=2.2u w=0.5u l=0.64u
X2921 a_16310_64692# w[13] a_26214_64642# VSS nfet_03v3 ad=0.14p pd=1.06u as=0.3p ps=2.2u w=0.5u l=0.64u
X2922 a_86480_87964# VMEM_3 a_85942_81648# VSS nfet_03v3 ad=2.4p pd=9.2u as=2.4p ps=9.2u w=4u l=2u
X2926 VDD DPI_4__VT DPI_4__VT VDD pfet_03v3 ad=0.14p pd=1.06u as=0.14p ps=1.06u w=0.5u l=0.64u
X2940 VMEM_2 neuron_4__Vlk VSS VSS nfet_03v3 ad=0.6p pd=3.2u as=0.6p ps=3.2u w=1u l=1u
X2944 a_67078_63516# a_67078_63516# DAC_5__Isum_i DAC_5__Isum_i nfet_03v3 ad=0.3p pd=2.2u as=0.3p ps=2.2u w=0.5u l=0.64u
X2954 a_16310_94896# w[23] a_19914_94846# VSS nfet_03v3 ad=0.14p pd=1.06u as=0.3p ps=2.2u w=0.5u l=0.64u
X2966 VDD neuron_4__VNA a_92184_57760# VDD pfet_03v3 ad=0.6p pd=3.2u as=0.6p ps=3.2u w=1u l=1u
X2970 a_62978_88056# a_62978_88056# VSS VSS nfet_03v3 ad=1.2p pd=5.2u as=1.2p ps=5.2u w=2u l=8u
X2972 a_92184_39284# a_88370_32968# VMEM_1 VDD pfet_03v3 ad=0.3p pd=2.2u as=0.3p ps=2.2u w=0.5u l=0.64u
X2982 VMEM_2 VSS cap_mim_2f0_m4m5_noshield c_width=22.18u c_length=22.18u
X2985 bias_0__VT_inh bias_0__VT_inh VDD VDD pfet_03v3 ad=0.2464p pd=1.44u as=0.2464p ps=1.44u w=0.88u l=1.12u
X2988 a_26214_110862# DAC_7__Vb VSS VSS nfet_03v3 ad=0.6p pd=3.2u as=0.6p ps=3.2u w=1u l=8u
X2990 a_34614_13502# DAC_7__Vb VSS VSS nfet_03v3 ad=0.6p pd=3.2u as=0.6p ps=3.2u w=1u l=8u
X2995 a_22014_50454# DAC_7__Vb VSS VSS nfet_03v3 ad=0.6p pd=3.2u as=0.6p ps=3.2u w=1u l=8u
X3002 DAC_1__Isum_e a_17058_110704# a_16558_110912# VSS nfet_03v3 ad=0.3p pd=2.2u as=0.3p ps=2.2u w=0.5u l=0.64u
X3005 DPI_4__VT DPI_4__VT VDD VDD pfet_03v3 ad=0.14p pd=1.06u as=0.14p ps=1.06u w=0.5u l=0.64u
C0 s[6] w[20] 0.0788f
C1 neuron_4__Vlk neuron_4__VNA 14.6938f
C2 w[16] a_16310_80708# 0.01848f
C3 neuron_4__Vamp_bias a_88370_14492# 0.06057f
C4 a_34614_31978# a_16310_32028# 1.31469f
C5 s[6] s[0] 0.01584f
C6 a_26214_31978# DAC_6__Isum_e 2.06134f
C7 w[6] w[18] 1.32956f
C8 s[2] w[6] 0.41354f
C9 DAC_1__Isum_e DPI_4__Vthr 0.94933f
C10 w[7] pulse[1] 1.31315f
C11 VDD a_22014_50454# 0.42217f
C12 VMEM_4 spike[4] 2.75441f
C13 w[11] w[21] 0.12458f
C14 w[13] w[28] 0.14053f
C15 a_34614_80658# DAC_3__Isum_i 0.11679f
C16 w[26] s[3] 0.10561f
C17 s[3] w[20] 25.4308f
C18 spike[1] s[3] 1.61294f
C19 w[18] w[24] 0.14185f
C20 a_34614_80658# a_17058_80500# 0.75055f
C21 s[2] w[24] 0.21791f
C22 spike[2] w[24] 0.08662f
C23 VDD w[28] 0.19271f
C24 DAC_5__Isum_e a_16310_50504# 0.07931f
C25 a_26214_94846# a_22014_94846# 0.29412f
C26 neuron_4__VIp DPI_4__Vthr 1.86209f
C27 VMEM_4 a_89378_111852# 3.31883f
C28 s[7] w[25] 0.05432f
C29 s[3] s[0] 0.09311f
C30 w[21] w[22] 18.3063f
C31 w[11] w[23] 0.12972f
C32 DAC_3__Isum_i s[5] 0.01848f
C33 DAC_5__Isum_i a_22014_64642# 12.8867f
C34 VDD a_16310_50504# 0.54717f
C35 neuron_4__Vamp_bias a_85942_81648# 0.05117f
C36 a_26214_110862# a_22014_110862# 0.29412f
C37 w[13] w[19] 0.61885f
C38 a_16558_80708# DAC_3__Isum_e 2.10366f
C39 w[24] spike[0] 13.2611f
C40 s[4] w[2] 0.06389f
C41 a_89378_14492# neuron_4__VK 0.04013f
C42 a_86480_118168# neuron_4__VNA 0.33746f
C43 a_85942_51444# a_88122_51444# 0.02914f
C44 a_16558_13552# pulse[0] 0.01869f
C45 VMEM_2 neuron_4__VIp 3.88058f
C46 w[25] pulse[1] 0.12082f
C47 w[15] w[7] 0.18015f
C48 w[14] w[7] 0.16648f
C49 VDD w[19] 2.34855f
C50 VMEM_3 a_89378_81648# 3.31883f
C51 w[23] w[22] 24.0421f
C52 a_19914_13502# a_16310_13552# 17.2602f
C53 VMEM_4 neuron_4__Vamp_bias 1.64558f
C54 w[29] w[13] 0.14053f
C55 DAC_3__Isum_i a_19914_94846# 0.01896f
C56 w[1] a_16310_13552# 0.10002f
C57 w[2] w[1] 10.5007f
C58 w[4] w[9] 0.08973f
C59 a_26214_50454# DAC_5__Isum_e 2.06134f
C60 w[18] w[28] 0.14741f
C61 a_16558_32028# s[1] 0.04246f
C62 w[16] w[26] 0.12982f
C63 VDD a_34614_94846# 0.19093f
C64 s[2] w[28] 0.21605f
C65 VDD w[29] 0.19264f
C66 w[16] w[20] 3.33253f
C67 VDD DAC_3__Isum_e 16.6792f
C68 w[16] spike[1] 0.06023f
C69 neuron_4__Vamp_bias VMEM_0 2.05434f
C70 a_26214_50454# VDD 0.26038f
C71 a_88122_14492# a_87742_14142# 0.60758f
C72 s[1] s[5] 0.37578f
C73 a_86480_20808# neuron_4__VKdn 0.02781f
C74 a_91556_118168# a_92184_118168# 0.53841f
C75 VMEM_0 a_62266_15456# 0.06733f
C76 w[7] w[8] 0.48263f
C77 DAC_1__Isum_e a_62266_112816# 4.6943f
C78 a_91556_118168# a_88370_111852# 0.37248f
C79 w[13] w[17] 0.18329f
C80 a_19914_80658# a_16310_80708# 17.2602f
C81 w[9] w[27] 9.52518f
C82 DPI_4__VT VDD 59.4786f
C83 w[3] s[6] 0.06563f
C84 VDD a_88750_14492# 0.15438f
C85 s[6] DAC_7__Vb 7.14893f
C86 a_17058_110704# a_16558_110912# 0.11824f
C87 a_16310_110912# a_19914_110862# 17.2602f
C88 a_19914_64642# DAC_5__Isum_i 0.01896f
C89 w[18] w[19] 8.95509f
C90 VDD w[17] 9.6677f
C91 neuron_4__VIp a_88122_111852# 0.04013f
C92 s[2] w[19] 0.19185f
C93 a_34614_94846# a_22014_94846# 0.11882f
C94 a_16310_50504# spike[0] 0.04246f
C95 s[4] w[26] 0.1404f
C96 pulse[0] pulse[1] 0.34614f
C97 a_88750_111852# a_88122_111852# 1.82301f
C98 s[6] w[5] 0.04126f
C99 bias_0__VT_inh Iref 0.10346f
C100 w[7] w[10] 0.22622f
C101 VDD a_62266_82612# 9.65024f
C102 spike[1] s[4] 0.24562f
C103 w[7] s[1] 0.63586f
C104 DAC_1__Isum_e a_34614_110862# 6.81042f
C105 a_86480_57760# neuron_4__VKup 3.24373f
C106 a_26214_31978# a_16310_32028# 1.78781f
C107 DAC_7__Vb s[3] 6.84851f
C108 w[3] s[3] 0.02841f
C109 VMEM_4 a_92184_118168# 0.93986f
C110 a_88370_111852# VMEM_4 0.29575f
C111 s[3] a_16558_64692# 0.04246f
C112 w[29] w[18] 0.14741f
C113 VDD VMEM_3 6.67913f
C114 DAC_1__Isum_i a_22014_110862# 12.8867f
C115 a_17058_64484# s[3] 3.46922f
C116 s[4] s[0] 0.1088f
C117 s[2] w[29] 0.21302f
C118 a_34614_125050# a_22014_125050# 0.11882f
C119 w[19] spike[0] 0.23625f
C120 a_88122_32968# a_86480_39284# 0.09468f
C121 w[25] w[8] 0.13427f
C122 w[31] s[5] 0.08728f
C123 w[22] a_16310_94896# 0.18228f
C124 a_88122_32968# a_88370_32968# 1.31172f
C125 VDD a_17058_110704# 8.90832f
C126 s[3] w[5] 0.07876f
C127 spike[1] a_16558_94896# 0.01869f
C128 a_16310_110912# w[24] 0.01848f
C129 DPI_4__VT spike[2] 0.27611f
C130 DAC_7__Vb a_17058_50296# 0.01172f
C131 w[30] s[5] 0.32574f
C132 a_88122_81648# VMEM_3 0.1368f
C133 DPI_4__VT a_67078_93720# 1.46104f
C134 w[1] s[0] 0.5453f
C135 w[18] w[17] 7.4557f
C136 VMEM_4 a_87742_111502# 3.23701f
C137 a_62266_33932# DPI_4__VT 1.7247f
C138 s[2] w[17] 0.23586f
C139 spike[1] DAC_5__Isum_i 0.38503f
C140 VDD a_26214_13502# 11.1263f
C141 s[6] w[6] 0.05881f
C142 w[21] w[20] 7.7809f
C143 VDD a_22014_13502# 13.3088f
C144 a_16558_13552# VDD 1.5403f
C145 spike[1] w[21] 0.21252f
C146 w[25] w[10] 0.13327f
C147 w[25] s[1] 0.13163f
C148 a_26214_80658# a_22014_80658# 0.29412f
C149 w[31] w[7] 3.68775f
C150 a_16310_125100# w[28] 0.01848f
C151 DPI_4__VT spike[0] 2.74473f
C152 a_16558_50504# a_17058_50296# 0.11824f
C153 w[11] a_19914_50454# 0.56837f
C154 a_88750_14492# spike[0] 1.35619f
C155 a_62266_82612# a_67078_93720# 0.10782f
C156 w[7] w[30] 3.79166f
C157 s[7] w[13] 0.07355f
C158 s[6] w[24] 1.3501f
C159 DAC_5__Isum_e DPI_4__Vthr 0.94933f
C160 spike[2] VMEM_3 0.34131f
C161 neuron_4__VIp VT 19.2065f
C162 w[17] spike[0] 0.24716f
C163 neuron_4__VNA Iref 0.44527f
C164 VMEM_3 a_67078_93720# 5.6305f
C165 w[6] s[3] 0.03061f
C166 w[16] DAC_7__Vb 7.10841f
C167 DAC_7__Isum_e a_34614_13502# 6.81042f
C168 neuron_4__VKdn a_21486_142736# 1.13015f
C169 a_19914_13502# a_17058_13344# 0.11443f
C170 spike[2] a_17058_110704# 0.37995f
C171 VDD DPI_4__Vthr 54.2297f
C172 w[23] w[20] 0.28459f
C173 spike[1] w[23] 0.45499f
C174 a_91556_87964# VDD 2.79898f
C175 w[11] w[12] 11.0401f
C176 a_87742_81298# VMEM_3 3.23701f
C177 a_17058_94688# s[5] 3.46922f
C178 s[7] VDD 1.74767f
C179 a_19914_125050# DAC_1__Isum_i 0.01896f
C180 a_88750_14492# a_88370_14492# 0.67211f
C181 a_86480_39284# neuron_4__VNA 0.34285f
C182 s[3] w[24] 0.09675f
C183 a_88370_81648# VMEM_3 0.29575f
C184 w[13] pulse[1] 0.09711f
C185 a_87742_14142# a_85942_14492# 0.9311f
C186 a_88370_32968# neuron_4__VNA 0.41209f
C187 pulse[0] w[0] 0.44592f
C188 a_34614_13502# a_16310_13552# 1.31469f
C189 bias_0__VT_inh neuron_4__VKup 0.42435f
C190 w[12] w[22] 0.11766f
C191 VDD a_87742_51094# 6.10183f
C192 w[27] s[5] 0.06655f
C193 VMEM_2 VDD 6.82448f
C194 w[29] a_16310_125100# 0.10002f
C195 s[4] DAC_7__Vb 6.63255f
C196 VDD pulse[1] 1.07813f
C197 w[3] s[4] 0.07968f
C198 a_19914_94846# a_17058_94688# 0.11443f
C199 w[4] w[7] 1.06381f
C200 a_86480_39284# a_85942_32968# 2.33814f
C201 s[6] w[28] 0.13859f
C202 DAC_1__Isum_e a_26214_125050# 2.06134f
C203 VMEM_2 a_88750_51444# 0.25888f
C204 s[4] w[5] 0.05318f
C205 s[7] a_17058_124892# 3.46922f
C206 a_19914_13502# DAC_7__Vb 0.74342f
C207 a_19914_13502# w[3] 0.56837f
C208 a_26214_80658# a_34614_80658# 7.01128f
C209 neuron_4__VK bias_0__VT_inh 0.24162f
C210 neuron_4__Vlk Iref 5.6193f
C211 s[7] w[18] 0.74408f
C212 spike[2] DPI_4__Vthr 0.14544f
C213 a_88750_81648# VMEM_3 0.25888f
C214 DAC_7__Vb w[1] 1.3879f
C215 s[7] s[2] 0.97701f
C216 w[3] w[1] 1.47991f
C217 a_16558_80708# DAC_3__Isum_i 1.32914f
C218 a_16558_32028# a_17058_31820# 0.11824f
C219 DPI_4__Vthr a_67078_93720# 1.63304f
C220 w[7] w[27] 1.82533f
C221 a_34614_125050# DAC_7__Vb 0.093f
C222 a_62266_33932# DPI_4__Vthr 1.24067f
C223 a_34614_80658# a_22014_80658# 0.11882f
C224 s[3] w[28] 0.09712f
C225 a_16558_80708# a_17058_80500# 0.11824f
C226 w[15] w[13] 0.24778f
C227 w[14] w[13] 7.32079f
C228 VDD a_62978_118260# 3.01921f
C229 DPI_4__Vthr spike[0] 1.86716f
C230 a_22014_50454# a_17058_50296# 0.05882f
C231 a_16310_94896# w[20] 0.01848f
C232 w[16] w[24] 0.23779f
C233 spike[1] a_16310_94896# 0.04246f
C234 s[6] w[19] 0.05521f
C235 w[21] DAC_7__Vb 1.49429f
C236 w[3] w[21] 0.54208f
C237 VMEM_4 DPI_4__VT 0.31796f
C238 VT a_85942_14492# 0.26497f
C239 spike[2] a_87742_51094# 0.14351f
C240 a_17058_64484# DAC_5__Isum_i 0.05814f
C241 DAC_5__Isum_i a_16558_64692# 1.32914f
C242 a_91556_87964# a_88370_81648# 0.37248f
C243 VMEM_2 spike[2] 2.78368f
C244 s[2] pulse[1] 0.77181f
C245 VDD a_88122_111852# 0.14568f
C246 a_62266_112816# VDD 9.6274f
C247 VDD w[14] 0.33047f
C248 a_86480_57760# a_85942_51444# 2.33814f
C249 a_85942_81648# VMEM_3 0.27205f
C250 w[15] VDD 3.01389f
C251 VDD a_92184_87964# 2.94927f
C252 a_19914_80658# DAC_7__Vb 0.74342f
C253 w[7] w[9] 0.22698f
C254 neuron_4__VNA neuron_4__VKup 42.4338f
C255 VDD a_87742_14142# 6.10078f
C256 w[21] w[5] 0.14475f
C257 a_88122_32968# spike[1] 0.04786f
C258 s[4] w[6] 0.07199f
C259 s[6] w[29] 0.1385f
C260 VDD DAC_3__Isum_i 11.4526f
C261 w[13] w[8] 0.32068f
C262 a_16558_50504# DAC_5__Isum_i 1.32914f
C263 a_87742_32618# VDD 6.101f
C264 VMEM_0 a_88750_14492# 0.25888f
C265 s[3] w[19] 0.11272f
C266 a_86480_20808# a_88122_14492# 0.09468f
C267 DPI_4__VT VMEM_0 0.31676f
C268 a_86480_57760# neuron_4__Vamp_bias 0.0348f
C269 VMEM_2 spike[0] 0.01764f
C270 w[7] a_17058_31820# 1.52889f
C271 a_16310_50504# a_17058_50296# 0.10497f
C272 VDD a_17058_80500# 8.84723f
C273 a_91556_20808# neuron_4__VKup 0.04013f
C274 DAC_7__Vb w[23] 1.46743f
C275 w[3] w[23] 1.15458f
C276 spike[3] a_67078_123924# 1.45846f
C277 w[25] w[27] 0.0901f
C278 s[4] w[24] 0.14915f
C279 VDD w[8] 0.41878f
C280 neuron_4__VIp neuron_4__VKdn 21.6567f
C281 spike[3] neuron_4__VNA 0.05734f
C282 neuron_4__VK neuron_4__VNA 5.13914f
C283 VDD a_34614_110862# 0.19093f
C284 VDD a_67078_63516# 8.79692f
C285 w[29] s[3] 0.09945f
C286 a_88750_111852# neuron_4__VKdn 0.04013f
C287 a_17058_110704# a_16310_110912# 0.10497f
C288 w[23] w[5] 0.13938f
C289 s[6] w[17] 0.0622f
C290 w[16] w[28] 0.12082f
C291 DAC_1__Isum_i spike[3] 0.45772f
C292 a_88370_51444# neuron_4__VKup 0.83541f
C293 a_16310_32028# w[5] 0.10002f
C294 VDD w[0] 0.0835f
C295 a_22014_94846# DAC_3__Isum_i 12.8867f
C296 w[15] s[2] 0.38106f
C297 s[2] w[14] 5.13507f
C298 a_62266_112816# spike[2] 0.16221f
C299 a_16558_125100# DAC_1__Isum_i 1.32914f
C300 neuron_4__VIp a_86480_20808# 0.01714f
C301 w[6] w[21] 0.13009f
C302 w[25] w[9] 8.21365f
C303 VDD w[10] 0.14837f
C304 VDD s[1] 2.00116f
C305 w[26] w[12] 0.12787f
C306 a_88122_32968# a_88750_32968# 1.82301f
C307 s[3] w[17] 0.11518f
C308 a_34614_13502# a_17058_13344# 0.75055f
C309 DAC_3__Isum_i a_67078_93720# 3.72888f
C310 a_26214_50454# a_17058_50296# 0.06004f
C311 neuron_4__Vlk neuron_4__VKup 7.63361f
C312 s[6] a_17058_110704# 3.46922f
C313 VDD VT 1.01293f
C314 w[12] w[20] 0.09411f
C315 spike[1] w[12] 0.14561f
C316 a_85942_111852# neuron_4__Vamp_bias 0.05117f
C317 DAC_1__Isum_i a_22014_125050# 12.8867f
C318 w[15] spike[0] 0.06801f
C319 w[14] spike[0] 0.05598f
C320 a_88122_32968# VMEM_1 0.1368f
C321 w[18] w[8] 0.13808f
C322 w[16] w[19] 0.1946f
C323 s[2] w[8] 1.30831f
C324 spike[1] neuron_4__VNA 0.10184f
C325 s[4] w[28] 0.1404f
C326 a_16310_64692# w[15] 0.364f
C327 a_16310_64692# w[14] 0.18228f
C328 a_92184_87964# a_88370_81648# 0.04621f
C329 a_87742_14142# spike[0] 0.14351f
C330 w[6] w[23] 0.14255f
C331 VMEM_4 DPI_4__Vthr 1.35556f
C332 a_26214_94846# w[21] 0.08445f
C333 a_17058_80500# spike[0] 0.37995f
C334 neuron_4__Vlk spike[3] 1.9864f
C335 neuron_4__Vlk neuron_4__VK 15.8342f
C336 w[6] a_16310_32028# 0.18228f
C337 w[31] w[13] 0.14691f
C338 w[16] w[29] 0.12071f
C339 spike[0] w[8] 0.159f
C340 a_19914_31978# a_16310_32028# 17.2602f
C341 w[23] w[24] 9.4273f
C342 w[13] w[30] 0.14053f
C343 a_22014_50454# DAC_5__Isum_i 12.8867f
C344 s[2] w[10] 0.46851f
C345 s[1] w[18] 0.1496f
C346 s[2] s[1] 1.15859f
C347 w[31] VDD 0.30809f
C348 VMEM_0 DPI_4__Vthr 0.07556f
C349 a_26214_110862# DAC_7__Vb 0.18591f
C350 a_34614_125050# w[28] 0.04246f
C351 a_26214_64642# a_22014_64642# 0.29412f
C352 a_87742_14142# a_88370_14492# 14.8965f
C353 neuron_4__Vamp_bias bias_0__VT_inh 6.42212f
C354 s[4] w[19] 0.42528f
C355 bias_0__VT_inh DAC_7__Vb 0.18646f
C356 DAC_7__Vb a_34614_13502# 0.093f
C357 spike[2] VT 3.81921f
C358 VDD w[30] 0.19498f
C359 a_86480_118168# neuron_4__VKup 3.27078f
C360 a_88122_51444# a_87742_51094# 0.60758f
C361 VMEM_2 a_88122_51444# 0.1368f
C362 a_89378_14492# a_88750_14492# 1.47502f
C363 s[7] s[6] 49.5239f
C364 w[16] w[17] 6.89619f
C365 w[10] spike[0] 0.14503f
C366 s[4] w[29] 0.1404f
C367 a_87742_81298# VT 0.51489f
C368 DAC_5__Isum_i a_16310_50504# 1.77847f
C369 a_86480_20808# a_85942_14492# 2.33814f
C370 w[1] w[19] 0.22632f
C371 spike[1] neuron_4__Vlk 1.99216f
C372 VT spike[0] 0.18137f
C373 a_26214_125050# VDD 0.26038f
C374 VMEM_1 neuron_4__VNA 0.09211f
C375 a_92184_39284# a_91556_39284# 0.53841f
C376 VT a_88370_81648# 0.07035f
C377 w[31] a_17058_124892# 1.50762f
C378 a_26214_110862# a_19914_110862# 0.27118f
C379 s[7] s[3] 0.1052f
C380 s[6] pulse[1] 0.17648f
C381 neuron_4__VIp a_21486_142736# 0.35566f
C382 a_19914_50454# DAC_7__Vb 0.74342f
C383 w[31] w[18] 0.15379f
C384 VMEM_4 a_62978_118260# 0.20517f
C385 w[31] s[2] 2.17816f
C386 a_16558_94896# DAC_3__Isum_e 2.10366f
C387 w[21] w[19] 2.22841f
C388 s[4] w[17] 0.53775f
C389 a_85942_111852# a_87742_111502# 0.9311f
C390 VMEM_4 a_88122_111852# 0.1368f
C391 w[18] w[30] 0.14741f
C392 VMEM_1 a_85942_32968# 0.27205f
C393 w[4] VDD 0.23333f
C394 VDD a_17058_94688# 8.90896f
C395 a_62266_112816# VMEM_4 1.57228f
C396 DAC_7__Vb a_67078_123924# 0.29859f
C397 VT a_88370_14492# 0.07049f
C398 s[2] w[30] 0.22037f
C399 a_19914_80658# w[19] 0.56837f
C400 w[13] w[27] 0.14939f
C401 s[3] pulse[1] 0.84734f
C402 w[12] DAC_7__Vb 7.12995f
C403 a_26214_50454# DAC_5__Isum_i 10.8659f
C404 w[25] s[5] 0.06629f
C405 a_19914_64642# a_26214_64642# 0.27118f
C406 neuron_4__Vamp_bias neuron_4__VNA 2.59397f
C407 a_26214_125050# a_17058_124892# 0.06004f
C408 DAC_7__Vb neuron_4__VNA 0.28484f
C409 neuron_4__Vlk spike[4] 1.9191f
C410 w[1] w[17] 0.51678f
C411 VDD a_91556_39284# 2.79898f
C412 DAC_5__Isum_e a_62266_52408# 4.71506f
C413 a_26214_94846# a_16310_94896# 1.78781f
C414 VDD w[27] 0.42739f
C415 VDD neuron_4__VKdn 4.84025f
C416 a_89378_51444# neuron_4__VK 0.04013f
C417 DAC_1__Isum_i DAC_7__Vb 1.4321f
C418 a_16310_110912# a_34614_110862# 1.31469f
C419 VDD a_62266_52408# 9.55704f
C420 a_88370_32968# a_86480_39284# 4.40172f
C421 VMEM_0 a_87742_14142# 3.23701f
C422 VMEM_1 neuron_4__Vlk 0.29304f
C423 neuron_4__VKdn a_88750_51444# 0.04013f
C424 w[15] s[6] 0.04984f
C425 s[6] w[14] 0.04984f
C426 a_22014_94846# a_17058_94688# 0.05882f
C427 neuron_4__Vamp_bias a_85942_32968# 0.05117f
C428 DAC_6__Isum_e DPI_4__Vthr 0.94933f
C429 w[25] w[7] 0.25422f
C430 w[16] s[7] 0.07527f
C431 VDD a_86480_20808# 10.71f
C432 w[11] w[22] 0.12972f
C433 w[4] s[2] 0.16406f
C434 VT a_85942_81648# 0.26497f
C435 a_34614_31978# a_26214_31978# 7.01128f
C436 neuron_4__Vamp_bias a_88370_51444# 0.09837f
C437 VDD w[9] 0.26625f
C438 w[15] s[3] 0.37997f
C439 w[14] s[3] 0.3704f
C440 s[6] w[8] 0.07159f
C441 a_19914_13502# a_26214_13502# 0.27118f
C442 neuron_4__VIp a_88122_14492# 0.04013f
C443 a_19914_13502# a_22014_13502# 0.57119f
C444 VDD a_17058_31820# 8.90537f
C445 DAC_1__Isum_i a_19914_110862# 0.01896f
C446 a_17058_31820# a_22014_31978# 0.05882f
C447 a_26214_80658# VDD 0.26038f
C448 a_86480_118168# spike[4] 0.52077f
C449 VDD a_86480_87964# 10.7066f
C450 a_26214_13502# w[1] 0.08445f
C451 pulse[0] s[5] 0.14772f
C452 w[18] w[27] 0.14185f
C453 VMEM_4 VT 2.06986f
C454 neuron_4__Vamp_bias neuron_4__Vlk 6.58015f
C455 neuron_4__VNA a_92184_118168# 0.04168f
C456 a_88370_111852# neuron_4__VNA 0.40537f
C457 s[2] w[27] 0.20544f
C458 spike[2] w[27] 0.07426f
C459 neuron_4__Vlk DAC_7__Vb 20.3646f
C460 spike[2] neuron_4__VKdn 0.97139f
C461 s[4] s[7] 0.15784f
C462 w[31] a_16310_125100# 0.364f
C463 VDD a_22014_80658# 0.42217f
C464 s[6] w[0] 0.05789f
C465 w[26] a_22014_110862# 0.25032f
C466 a_34614_50454# DAC_7__Vb 0.093f
C467 w[12] w[24] 0.11912f
C468 Iref neuron_4__VKup 1.51353f
C469 s[3] w[8] 18.5177f
C470 s[6] w[10] 0.06497f
C471 VT VMEM_0 2.14887f
C472 a_16310_125100# w[30] 0.18228f
C473 a_86480_87964# a_88122_81648# 0.09468f
C474 s[6] s[1] 0.28042f
C475 neuron_4__VKdn spike[0] 0.20103f
C476 a_22014_50454# a_19914_50454# 0.57119f
C477 s[7] w[1] 0.24396f
C478 s[2] w[9] 0.46828f
C479 spike[0] a_62266_52408# 0.09793f
C480 s[4] pulse[1] 0.18679f
C481 a_34614_94846# a_16310_94896# 1.31469f
C482 neuron_4__VNA a_87742_111502# 0.16872f
C483 VMEM_2 a_92184_57760# 0.93986f
C484 w[0] s[3] 0.02849f
C485 spike[3] Iref 0.06717f
C486 neuron_4__VK Iref 2.07108f
C487 a_86480_39284# neuron_4__VKup 3.23723f
C488 DAC_3__Isum_e a_16310_94896# 0.07931f
C489 a_88370_32968# neuron_4__VKup 0.84227f
C490 a_26214_125050# a_16310_125100# 1.78781f
C491 s[3] w[10] 0.03061f
C492 a_86480_20808# spike[0] 0.52077f
C493 DAC_5__Isum_i DPI_4__Vthr 0.94757f
C494 s[1] s[3] 0.12873f
C495 w[16] w[15] 0.45076f
C496 w[9] spike[0] 0.13817f
C497 w[18] a_22014_80658# 0.25032f
C498 s[7] w[21] 0.06844f
C499 w[1] pulse[1] 0.2949f
C500 a_19914_50454# a_16310_50504# 17.2602f
C501 w[12] w[28] 0.11923f
C502 a_86480_87964# a_87742_81298# 0.68101f
C503 a_88750_81648# neuron_4__VKdn 0.04013f
C504 a_19914_125050# a_22014_125050# 0.57119f
C505 w[31] s[6] 0.13613f
C506 VDD a_21486_142736# 37.1972f
C507 a_86480_87964# a_88370_81648# 4.40172f
C508 VMEM_2 DAC_5__Isum_i 0.38082f
C509 a_86480_20808# a_88370_14492# 4.40172f
C510 a_19914_64642# a_22014_64642# 0.57119f
C511 DPI_4__VT bias_0__VT_inh 23.6623f
C512 w[21] pulse[1] 0.14767f
C513 a_88122_14492# a_85942_14492# 0.02914f
C514 s[7] w[23] 0.06307f
C515 DAC_7__Isum_e a_16310_13552# 0.07931f
C516 VDD a_34614_80658# 0.19093f
C517 s[6] w[30] 0.12975f
C518 spike[1] Iref 0.08129f
C519 s[4] w[15] 0.06163f
C520 s[4] w[14] 0.06163f
C521 a_16558_32028# VDD 1.5403f
C522 w[26] w[11] 0.13869f
C523 VDD a_91556_57760# 2.79898f
C524 w[31] s[3] 0.22134f
C525 s[4] DAC_3__Isum_i 0.01848f
C526 DAC_7__Vb a_26214_64642# 0.18591f
C527 a_26214_50454# a_19914_50454# 0.27118f
C528 a_86480_57760# VMEM_2 1.71864f
C529 a_86480_57760# a_87742_51094# 0.68101f
C530 w[12] w[19] 0.11612f
C531 a_17058_64484# a_26214_64642# 0.06004f
C532 s[4] a_17058_80500# 3.46922f
C533 VDD s[5] 1.9028f
C534 w[23] pulse[1] 0.12957f
C535 spike[1] a_86480_39284# 0.52077f
C536 s[3] w[30] 0.21551f
C537 w[16] s[1] 0.01228f
C538 w[15] w[1] 0.45965f
C539 w[14] w[1] 1.55566f
C540 w[2] a_16310_13552# 0.18228f
C541 a_62978_57852# DPI_4__Vthr 0.0114f
C542 spike[1] a_88370_32968# 9.68412f
C543 a_86480_118168# a_88370_111852# 4.40172f
C544 a_26214_110862# a_17058_110704# 0.06004f
C545 a_88750_81648# a_86480_87964# 0.01339f
C546 s[4] w[8] 0.9669f
C547 a_16310_32028# pulse[1] 0.04246f
C548 a_16310_110912# w[27] 0.364f
C549 w[29] w[12] 0.11931f
C550 VMEM_4 neuron_4__VKdn 0.58511f
C551 DAC_3__Isum_i a_16558_94896# 1.32914f
C552 a_22014_110862# DAC_7__Vb 0.37182f
C553 w[7] w[13] 1.00917f
C554 a_34614_50454# a_22014_50454# 0.11882f
C555 spike[1] w[22] 0.47491f
C556 w[22] w[20] 0.29335f
C557 w[4] s[6] 0.05242f
C558 s[4] w[0] 0.17056f
C559 w[14] w[21] 16.0185f
C560 w[15] w[21] 12.7483f
C561 VDD a_19914_94846# 0.75723f
C562 DPI_4__VT a_67078_123924# 1.04161f
C563 DAC_1__Isum_e a_16558_110912# 2.10366f
C564 spike[3] neuron_4__VKup 0.34695f
C565 neuron_4__VK neuron_4__VKup 2.65165f
C566 VDD w[7] 0.26723f
C567 VMEM_2 a_62978_57852# 0.20517f
C568 VMEM_0 neuron_4__VKdn 0.18374f
C569 s[4] w[10] 0.07676f
C570 a_26214_13502# a_34614_13502# 7.01128f
C571 DPI_4__VT neuron_4__VNA 19.0099f
C572 a_34614_13502# a_22014_13502# 0.11882f
C573 a_86480_87964# a_85942_81648# 2.33814f
C574 a_86480_118168# a_87742_111502# 0.68101f
C575 s[4] s[1] 0.46442f
C576 spike[2] a_91556_57760# 1.98323f
C577 VMEM_1 Iref 0.08844f
C578 w[12] w[17] 0.13935f
C579 s[6] w[27] 0.4159f
C580 w[4] s[3] 0.03078f
C581 w[0] w[1] 7.04956f
C582 a_19914_80658# DAC_3__Isum_i 0.01896f
C583 a_34614_50454# a_16310_50504# 1.31469f
C584 VDD a_88122_14492# 0.14568f
C585 s[2] s[5] 3.36476f
C586 a_34614_31978# DAC_7__Vb 0.093f
C587 w[16] w[31] 0.13439f
C588 w[21] w[8] 0.13089f
C589 DAC_5__Isum_e a_34614_64642# 6.81042f
C590 neuron_4__VK spike[3] 0.15887f
C591 a_67078_63516# DAC_5__Isum_i 3.72682f
C592 a_22014_110862# a_19914_110862# 0.57119f
C593 a_88750_32968# a_86480_39284# 0.01339f
C594 a_19914_80658# a_17058_80500# 0.11443f
C595 VMEM_0 a_86480_20808# 1.71072f
C596 w[1] w[10] 0.43702f
C597 a_88750_32968# a_88370_32968# 0.67211f
C598 DAC_1__Isum_e VDD 15.8553f
C599 a_16558_125100# spike[3] 0.01869f
C600 bias_0__VT_inh DPI_4__Vthr 7.16516f
C601 VMEM_1 a_86480_39284# 1.71072f
C602 w[25] w[13] 0.14825f
C603 w[16] w[30] 0.12071f
C604 s[1] w[1] 0.54914f
C605 a_22014_94846# a_19914_94846# 0.57119f
C606 VDD a_34614_64642# 0.19093f
C607 a_88370_32968# VMEM_1 0.29575f
C608 VMEM_3 neuron_4__VNA 3.01948f
C609 w[27] s[3] 0.10568f
C610 w[7] w[18] 1.86306f
C611 s[6] w[9] 0.06563f
C612 spike[1] neuron_4__VKup 0.0554f
C613 w[23] w[8] 0.13427f
C614 w[25] VDD 0.31231f
C615 neuron_4__Vamp_bias Iref 0.1819f
C616 w[21] w[10] 0.12949f
C617 s[2] w[7] 0.4302f
C618 DAC_7__Vb Iref 1.09647f
C619 VDD neuron_4__VIp 19.1387f
C620 s[1] w[21] 0.12998f
C621 a_19914_125050# DAC_7__Vb 0.74342f
C622 w[2] s[0] 0.5572f
C623 s[4] w[31] 0.14678f
C624 VDD a_88750_111852# 0.15438f
C625 a_17058_110704# DAC_1__Isum_i 0.05814f
C626 a_26214_50454# a_34614_50454# 7.01128f
C627 DPI_4__VT neuron_4__Vlk 0.24142f
C628 s[4] w[30] 0.1404f
C629 w[11] DAC_7__Vb 1.5654f
C630 spike[1] spike[3] 6.18168f
C631 spike[1] neuron_4__VK 0.17014f
C632 DAC_1__Isum_e a_17058_124892# 14.2174f
C633 DAC_7__Isum_e a_17058_13344# 14.2174f
C634 a_85942_111852# a_88122_111852# 0.02914f
C635 w[9] s[3] 0.03061f
C636 neuron_4__Vamp_bias a_88370_32968# 0.06057f
C637 neuron_4__VIp a_88122_81648# 0.04013f
C638 w[16] w[4] 0.01104f
C639 w[23] w[10] 8.2204f
C640 s[1] w[23] 0.14073f
C641 w[11] w[5] 0.69915f
C642 a_62978_57852# a_67078_63516# 8.75182f
C643 a_88122_14492# spike[0] 0.04786f
C644 a_67078_123924# DPI_4__Vthr 1.18403f
C645 a_19914_31978# a_34614_31978# 0.16484f
C646 DAC_7__Vb w[22] 1.44834f
C647 w[3] w[22] 1.28574f
C648 spike[4] neuron_4__VKup 0.04329f
C649 w[25] w[18] 0.1331f
C650 a_17058_13344# a_16310_13552# 0.10497f
C651 neuron_4__Vlk VMEM_3 6.1126f
C652 w[25] s[2] 0.22465f
C653 s[7] w[12] 0.12751f
C654 DAC_7__Vb a_22014_64642# 0.37182f
C655 DPI_4__Vthr neuron_4__VNA 0.4718f
C656 w[25] spike[2] 0.08662f
C657 neuron_4__VIp spike[2] 2.25404f
C658 w[16] w[27] 0.12964f
C659 a_17058_64484# a_22014_64642# 0.05882f
C660 pulse[0] VDD 0.0889f
C661 DAC_3__Isum_i a_16310_94896# 1.77847f
C662 w[22] w[5] 0.13872f
C663 w[26] w[20] 0.17776f
C664 spike[1] w[26] 0.14375f
C665 VMEM_1 neuron_4__VKup 0.06277f
C666 DAC_1__Isum_i DPI_4__Vthr 0.94757f
C667 s[4] w[4] 0.06232f
C668 a_16310_64692# a_34614_64642# 1.31469f
C669 spike[1] w[20] 0.18602f
C670 spike[3] spike[4] 10.2001f
C671 neuron_4__VK spike[4] 0.08809f
C672 a_86480_118168# DPI_4__VT 0.02058f
C673 s[7] DAC_1__Isum_i 0.01848f
C674 a_62266_15456# DAC_7__Isum_e 4.70855f
C675 a_88122_14492# a_88370_14492# 1.31172f
C676 a_26214_125050# a_34614_125050# 7.01128f
C677 neuron_4__VIp spike[0] 0.1718f
C678 w[12] pulse[1] 0.38929f
C679 neuron_4__VNA a_87742_51094# 0.17044f
C680 a_88122_32968# a_87742_32618# 0.60758f
C681 VMEM_2 neuron_4__VNA 0.43581f
C682 w[6] w[11] 0.13085f
C683 VMEM_1 neuron_4__VK 1.60699f
C684 neuron_4__VK a_89378_111852# 0.04013f
C685 w[4] w[1] 0.11527f
C686 a_26214_110862# a_34614_110862# 7.01128f
C687 VDD a_85942_14492# 0.22723f
C688 s[4] w[27] 0.14915f
C689 a_85942_111852# VT 0.26497f
C690 a_16558_94896# a_17058_94688# 0.11824f
C691 DAC_7__Vb a_26214_31978# 0.18591f
C692 a_17058_31820# DAC_6__Isum_e 14.2174f
C693 w[11] w[24] 0.12972f
C694 w[3] a_16310_13552# 0.364f
C695 neuron_4__Vamp_bias neuron_4__VKup 11.193f
C696 w[3] w[2] 8.32981f
C697 DAC_7__Vb neuron_4__VKup 0.17265f
C698 VDD a_89378_81648# 0.17724f
C699 w[2] DAC_7__Vb 1.35466f
C700 w[6] w[22] 0.12694f
C701 pulse[0] s[2] 0.2127f
C702 a_26214_31978# w[5] 0.08445f
C703 a_67078_123924# a_62978_118260# 8.75182f
C704 neuron_4__Vlk DPI_4__Vthr 10.4385f
C705 a_88370_51444# a_87742_51094# 14.8965f
C706 VMEM_2 a_88370_51444# 0.29575f
C707 a_19914_64642# DAC_7__Vb 0.74342f
C708 spike[1] spike[4] 13.0143f
C709 w[0] a_34614_13502# 0.04246f
C710 a_17058_64484# a_19914_64642# 0.11443f
C711 DAC_1__Isum_e a_16310_125100# 0.07931f
C712 s[4] w[9] 0.07985f
C713 neuron_4__Vamp_bias spike[3] 0.79155f
C714 neuron_4__Vamp_bias neuron_4__VK 18.7113f
C715 a_62266_112816# a_67078_123924# 0.11305f
C716 spike[1] a_88750_32968# 1.35619f
C717 s[6] s[5] 0.48713f
C718 DAC_7__Vb spike[3] 10.8339f
C719 a_88122_81648# a_89378_81648# 0.26264f
C720 VDD a_92184_39284# 2.94927f
C721 neuron_4__VK DAC_7__Vb 0.23331f
C722 w[15] w[12] 0.22132f
C723 w[14] w[12] 0.19007f
C724 VDD a_16558_80708# 0.21115f
C725 s[0] a_17058_13344# 3.46922f
C726 VDD a_16558_110912# 0.21115f
C727 spike[1] VMEM_1 2.77176f
C728 DAC_1__Isum_i a_62978_118260# 0.16288f
C729 VMEM_2 neuron_4__Vlk 2.56932f
C730 a_92184_87964# neuron_4__VNA 0.04168f
C731 w[23] a_17058_94688# 1.50762f
C732 a_87742_14142# neuron_4__VNA 0.16858f
C733 s[3] s[5] 0.82837f
C734 w[4] a_16310_32028# 0.01848f
C735 a_87742_32618# neuron_4__VNA 0.16862f
C736 w[11] w[28] 0.13946f
C737 DAC_1__Isum_e a_16310_110912# 0.07931f
C738 VDD w[13] 0.14776f
C739 DAC_7__Vb a_22014_125050# 0.37182f
C740 w[12] w[8] 5.84248f
C741 s[6] w[7] 0.16853f
C742 VDD DAC_5__Isum_e 16.2341f
C743 VMEM_0 a_88122_14492# 0.1368f
C744 a_88370_111852# neuron_4__VKup 0.86276f
C745 w[11] a_16310_50504# 0.364f
C746 w[26] DAC_7__Vb 1.38143f
C747 a_19914_31978# a_26214_31978# 0.27118f
C748 w[21] w[9] 0.12088f
C749 VDD a_22014_31978# 13.3088f
C750 w[25] a_16310_110912# 0.10002f
C751 spike[1] neuron_4__Vamp_bias 0.1612f
C752 DAC_7__Vb w[20] 7.28716f
C753 a_87742_32618# a_85942_32968# 0.9311f
C754 a_62978_88056# VMEM_3 0.20517f
C755 spike[1] DAC_7__Vb 0.51039f
C756 VMEM_4 neuron_4__VIp 0.7581f
C757 spike[1] a_16558_64692# 0.01869f
C758 DAC_1__Isum_i a_34614_110862# 0.11679f
C759 VDD a_88750_51444# 0.15438f
C760 spike[1] a_17058_64484# 0.37995f
C761 a_17058_110704# a_22014_110862# 0.05882f
C762 w[7] s[3] 0.03977f
C763 VMEM_4 a_88750_111852# 0.25888f
C764 w[26] w[5] 10.4408f
C765 DAC_7__Vb s[0] 6.3459f
C766 neuron_4__VIp a_88122_51444# 0.04013f
C767 w[3] s[0] 0.67404f
C768 a_89378_111852# spike[4] 1.13486f
C769 spike[2] a_16558_110912# 0.01869f
C770 a_88750_32968# VMEM_1 0.25888f
C771 s[1] w[12] 2.85316f
C772 w[11] w[19] 0.13407f
C773 w[16] a_34614_80658# 0.04246f
C774 VDD a_88122_81648# 0.14568f
C775 a_89378_32968# VDD 0.17724f
C776 neuron_4__VIp VMEM_0 0.18865f
C777 a_87742_111502# neuron_4__VKup 0.16414f
C778 a_26214_80658# a_19914_80658# 0.27118f
C779 w[9] w[23] 0.1251f
C780 w[18] w[13] 0.17127f
C781 a_16558_32028# DAC_6__Isum_e 2.10366f
C782 s[2] w[13] 0.08205f
C783 VDD a_22014_94846# 0.42217f
C784 a_16558_80708# spike[0] 0.01869f
C785 w[25] s[6] 0.43004f
C786 w[11] w[29] 0.14077f
C787 DPI_4__VT Iref 5.21134f
C788 VT neuron_4__VNA 5.45133f
C789 VDD a_17058_124892# 8.84723f
C790 a_19914_80658# a_22014_80658# 0.57119f
C791 w[16] s[5] 32.1788f
C792 VDD w[18] 0.36179f
C793 a_17058_94688# a_16310_94896# 0.10497f
C794 s[2] VDD 2.05814f
C795 a_17058_31820# a_16310_32028# 0.10497f
C796 neuron_4__Vamp_bias spike[4] 0.08158f
C797 a_88750_81648# a_89378_81648# 1.47502f
C798 VDD spike[2] 2.31954f
C799 VDD a_67078_93720# 8.80185f
C800 w[13] spike[0] 0.06204f
C801 DAC_7__Vb a_17058_13344# 0.03189f
C802 w[26] w[6] 0.13048f
C803 w[3] a_17058_13344# 1.52969f
C804 a_62266_33932# VDD 9.58899f
C805 w[25] s[3] 0.1055f
C806 VT a_85942_32968# 0.26497f
C807 spike[2] a_88750_51444# 1.35619f
C808 a_16310_64692# w[13] 0.10002f
C809 a_34614_50454# w[8] 0.04246f
C810 VDD a_87742_81298# 6.10097f
C811 neuron_4__Vamp_bias VMEM_1 2.9444f
C812 a_16310_64692# DAC_5__Isum_e 0.07931f
C813 w[11] w[17] 0.15715f
C814 VMEM_3 Iref 1.33303f
C815 w[31] w[12] 0.16345f
C816 a_62978_88056# DPI_4__Vthr 0.01209f
C817 a_92184_57760# a_91556_57760# 0.53841f
C818 a_88370_51444# VT 0.07035f
C819 VDD spike[0] 2.34572f
C820 VMEM_2 a_89378_51444# 3.31883f
C821 w[16] w[7] 2.17484f
C822 VDD a_88370_81648# 3.95792f
C823 w[6] s[0] 0.2368f
C824 a_86480_118168# a_88122_111852# 0.09468f
C825 w[26] w[24] 0.08348f
C826 s[4] s[5] 0.43077f
C827 a_16310_64692# VDD 0.54717f
C828 w[12] w[30] 0.11949f
C829 spike[1] w[24] 0.13584f
C830 w[24] w[20] 0.17776f
C831 w[19] a_16310_80708# 0.364f
C832 a_85942_51444# neuron_4__Vamp_bias 0.05117f
C833 spike[3] w[28] 0.08662f
C834 a_87742_81298# a_88122_81648# 0.60758f
C835 bias_0__VT_inh neuron_4__VKdn 0.20895f
C836 s[2] w[18] 2.906f
C837 neuron_4__Vlk VT 1.88617f
C838 a_88122_81648# a_88370_81648# 1.31172f
C839 a_16558_94896# s[5] 0.04246f
C840 a_89378_14492# a_88122_14492# 0.26264f
C841 VDD a_88370_14492# 3.95767f
C842 DAC_3__Isum_e a_16310_80708# 0.07931f
C843 neuron_4__Vamp_bias DAC_7__Vb 19.9267f
C844 w[3] DAC_7__Vb 1.5462f
C845 spike[4] a_92184_118168# 0.28806f
C846 a_88370_111852# spike[4] 9.68412f
C847 s[4] w[7] 0.18024f
C848 a_17058_64484# DAC_7__Vb 0.01765f
C849 a_34614_80658# a_19914_80658# 0.16484f
C850 a_88750_81648# VDD 0.15438f
C851 VMEM_0 a_85942_14492# 0.27205f
C852 a_17058_64484# a_16558_64692# 0.11824f
C853 w[18] spike[0] 0.08662f
C854 pulse[0] s[3] 0.37887f
C855 spike[2] spike[0] 1.02249f
C856 a_26214_125050# DAC_1__Isum_i 10.8659f
C857 s[2] spike[0] 2.15433f
C858 w[16] w[25] 0.13048f
C859 DAC_7__Vb w[5] 1.78035f
C860 w[21] s[5] 0.34459f
C861 w[4] w[12] 0.34541f
C862 DPI_4__Vthr Iref 6.25044f
C863 a_91556_118168# VDD 2.79898f
C864 a_16310_80708# w[17] 0.10002f
C865 a_16310_110912# a_16558_110912# 1.6884f
C866 w[28] w[20] 0.17776f
C867 DPI_4__VT neuron_4__VKup 5.13688f
C868 spike[1] w[28] 13.3766f
C869 a_88750_81648# a_88122_81648# 1.82301f
C870 VDD a_16310_125100# 0.54717f
C871 spike[4] a_87742_111502# 0.14351f
C872 a_87742_81298# a_88370_81648# 14.8965f
C873 w[29] spike[3] 0.08662f
C874 VDD a_85942_81648# 0.22723f
C875 a_16558_32028# a_16310_32028# 1.6884f
C876 DAC_7__Vb a_19914_110862# 0.74342f
C877 w[23] s[5] 0.33458f
C878 w[12] w[27] 0.12787f
C879 s[7] w[11] 8.16258f
C880 w[7] w[21] 0.11914f
C881 DPI_4__VT spike[3] 2.57683f
C882 s[4] w[25] 0.1404f
C883 VMEM_2 Iref 1.59641f
C884 neuron_4__VKdn neuron_4__VNA 10.3692f
C885 DPI_4__VT neuron_4__VK 0.30966f
C886 a_62978_88056# DAC_3__Isum_i 0.15493f
C887 a_88370_111852# neuron_4__Vamp_bias 0.06057f
C888 VMEM_3 neuron_4__VKup 2.51168f
C889 s[6] a_16558_110912# 0.04246f
C890 VMEM_4 VDD 6.78936f
C891 VDD a_16310_110912# 0.54717f
C892 w[6] DAC_7__Vb 1.45843f
C893 w[19] w[20] 0.1524f
C894 w[3] w[6] 0.05891f
C895 a_88122_81648# a_85942_81648# 0.02914f
C896 a_26214_13502# DAC_7__Isum_e 2.06134f
C897 spike[1] w[19] 0.08545f
C898 a_16558_13552# DAC_7__Isum_e 2.10366f
C899 DAC_1__Isum_e a_34614_125050# 6.81042f
C900 a_88370_14492# spike[0] 9.68412f
C901 s[7] w[22] 0.06307f
C902 a_22014_110862# a_34614_110862# 0.11882f
C903 VDD a_88122_51444# 0.14568f
C904 a_19914_31978# DAC_7__Vb 0.74342f
C905 a_19914_94846# w[23] 0.56837f
C906 w[11] pulse[1] 0.16889f
C907 a_86480_20808# neuron_4__VNA 0.33563f
C908 a_17058_124892# a_16310_125100# 0.10497f
C909 w[7] w[23] 2.8405f
C910 a_34614_94846# w[20] 0.04246f
C911 s[6] w[13] 0.06717f
C912 w[6] w[5] 6.91869f
C913 a_34614_64642# DAC_5__Isum_i 0.11679f
C914 w[29] w[20] 0.17793f
C915 DAC_7__Vb w[24] 7.21287f
C916 spike[3] VMEM_3 2.77841f
C917 neuron_4__VK VMEM_3 1.3531f
C918 a_88122_51444# a_88750_51444# 1.82301f
C919 VDD VMEM_0 5.90722f
C920 a_88750_81648# a_88370_81648# 0.67211f
C921 spike[1] w[29] 13.2611f
C922 w[7] a_16310_32028# 0.364f
C923 a_26214_13502# a_16310_13552# 1.78781f
C924 neuron_4__Vamp_bias a_87742_111502# 0.07771f
C925 a_22014_13502# a_16310_13552# 15.0391f
C926 a_26214_94846# DAC_7__Vb 0.18591f
C927 a_16558_13552# a_16310_13552# 1.6884f
C928 DAC_7__Isum_e DPI_4__Vthr 0.94933f
C929 w[2] a_22014_13502# 0.25032f
C930 w[22] pulse[1] 0.14232f
C931 w[24] w[5] 0.14813f
C932 s[6] VDD 1.85632f
C933 a_86480_87964# neuron_4__VNA 0.33874f
C934 spike[1] DPI_4__VT 0.45279f
C935 w[13] s[3] 0.48553f
C936 bias_0__VT_inh a_21486_142736# 0.15271f
C937 a_87742_81298# a_85942_81648# 0.9311f
C938 spike[1] w[17] 0.08567f
C939 spike[2] a_16310_110912# 0.04246f
C940 neuron_4__Vlk neuron_4__VKdn 13.764f
C941 VMEM_4 spike[2] 1.56425f
C942 a_22014_50454# DAC_7__Vb 0.37182f
C943 a_88370_111852# a_92184_118168# 0.04621f
C944 VDD s[3] 1.72516f
C945 spike[2] a_88122_51444# 0.04786f
C946 w[15] w[11] 0.1387f
C947 w[11] w[14] 0.10492f
C948 DPI_4__Vthr neuron_4__VKup 3.49403f
C949 a_91556_87964# neuron_4__VKup 0.04013f
C950 s[7] w[2] 0.05638f
C951 DAC_7__Vb w[28] 6.90505f
C952 pulse[0] w[1] 1.07018f
C953 DAC_5__Isum_e a_17058_50296# 14.2174f
C954 s[6] w[18] 0.50426f
C955 a_87742_32618# a_86480_39284# 0.68101f
C956 w[6] w[24] 0.14288f
C957 s[2] s[6] 0.22699f
C958 a_87742_32618# a_88370_32968# 14.8965f
C959 s[6] spike[2] 1.13704f
C960 spike[3] DPI_4__Vthr 3.98135f
C961 VDD a_17058_50296# 8.90408f
C962 a_19914_94846# a_16310_94896# 17.2602f
C963 w[14] w[22] 12.6444f
C964 a_91556_87964# spike[3] 1.98323f
C965 neuron_4__VK DPI_4__Vthr 1.43065f
C966 a_87742_51094# neuron_4__VKup 0.14183f
C967 w[11] w[8] 0.24702f
C968 a_88370_111852# a_87742_111502# 14.8965f
C969 s[7] spike[3] 1.10853f
C970 VMEM_2 neuron_4__VKup 0.20334f
C971 w[2] pulse[1] 1.33501f
C972 VMEM_0 spike[0] 2.77841f
C973 w[14] a_22014_64642# 0.25032f
C974 s[7] a_16558_125100# 0.04246f
C975 DPI_4__VT VMEM_1 0.38403f
C976 w[16] w[13] 13.6018f
C977 w[18] s[3] 0.10623f
C978 a_16558_50504# a_16310_50504# 1.6884f
C979 DAC_7__Vb w[19] 1.51589f
C980 w[3] w[19] 0.1163f
C981 s[2] s[3] 7.10281f
C982 VT Iref 14.1806f
C983 a_21486_142736# neuron_4__VNA 0.22665f
C984 VMEM_2 neuron_4__VK 1.14287f
C985 w[22] w[8] 0.13427f
C986 a_16558_13552# s[0] 0.04246f
C987 a_34614_94846# DAC_7__Vb 0.093f
C988 w[11] w[10] 7.04121f
C989 w[11] s[1] 0.20003f
C990 w[16] VDD 0.14144f
C991 w[19] w[5] 0.13753f
C992 s[4] a_16558_80708# 0.04246f
C993 VDD DAC_6__Isum_e 14.8836f
C994 VMEM_0 a_88370_14492# 0.29575f
C995 w[29] DAC_7__Vb 1.30647f
C996 s[7] w[26] 0.05432f
C997 a_26214_50454# DAC_7__Vb 0.18591f
C998 VDD a_89378_14492# 0.17724f
C999 s[3] spike[0] 0.0596f
C1000 DAC_1__Isum_e a_26214_110862# 2.06134f
C1001 spike[1] DPI_4__Vthr 0.07989f
C1002 w[6] w[28] 3.71555f
C1003 a_91556_118168# VMEM_4 0.12888f
C1004 VT a_86480_39284# 0.01706f
C1005 s[2] a_17058_50296# 3.46922f
C1006 s[7] w[20] 0.07679f
C1007 a_88370_32968# VT 0.07609f
C1008 DPI_4__VT neuron_4__Vamp_bias 0.23755f
C1009 DPI_4__VT a_62266_15456# 1.72102f
C1010 DAC_3__Isum_i a_16310_80708# 1.77847f
C1011 DPI_4__VT DAC_7__Vb 0.73148f
C1012 s[4] w[13] 0.06738f
C1013 w[22] w[10] 0.13352f
C1014 s[1] w[22] 0.13377f
C1015 s[7] s[0] 0.07084f
C1016 a_17058_80500# a_16310_80708# 0.10497f
C1017 DAC_7__Vb w[17] 4.49064f
C1018 a_26214_110862# w[25] 0.08445f
C1019 w[3] w[17] 0.15186f
C1020 a_26214_13502# a_17058_13344# 0.06004f
C1021 spike[3] a_62978_118260# 0.18859f
C1022 a_87742_14142# neuron_4__VKup 0.14784f
C1023 w[26] pulse[1] 0.13832f
C1024 a_88122_32968# neuron_4__VIp 0.04013f
C1025 a_22014_13502# a_17058_13344# 0.05882f
C1026 spike[0] a_17058_50296# 0.37995f
C1027 s[4] VDD 1.77248f
C1028 a_16558_13552# a_17058_13344# 0.11824f
C1029 w[15] a_19914_64642# 0.56837f
C1030 w[31] a_19914_125050# 0.56837f
C1031 a_87742_32618# neuron_4__VKup 0.15042f
C1032 VDD a_92184_57760# 2.94927f
C1033 neuron_4__VIp bias_0__VT_inh 0.15808f
C1034 w[16] w[18] 0.56107f
C1035 a_88370_51444# a_91556_57760# 0.37248f
C1036 w[7] w[12] 4.72503f
C1037 w[6] w[19] 0.14245f
C1038 w[5] w[17] 0.14511f
C1039 w[16] s[2] 0.06866f
C1040 w[31] w[11] 7.18911f
C1041 neuron_4__Vamp_bias VMEM_3 1.58276f
C1042 a_92184_87964# spike[3] 0.28806f
C1043 neuron_4__Vlk a_21486_142736# 0.27543f
C1044 s[0] pulse[1] 0.63103f
C1045 a_19914_13502# VDD 0.77619f
C1046 w[4] a_34614_31978# 0.04246f
C1047 VDD a_16558_94896# 0.21115f
C1048 VDD w[1] 0.08575f
C1049 w[11] w[30] 4.86124f
C1050 a_17058_110704# DAC_7__Vb 0.01484f
C1051 a_62266_33932# DAC_6__Isum_e 4.72103f
C1052 w[0] a_16310_13552# 0.01848f
C1053 w[6] w[29] 1.48492f
C1054 w[21] w[13] 0.27513f
C1055 VDD a_34614_125050# 0.19093f
C1056 DAC_5__Isum_e DAC_5__Isum_i 11.3442f
C1057 a_26214_125050# a_19914_125050# 0.27118f
C1058 w[2] w[0] 1.60645f
C1059 w[16] spike[0] 0.0934f
C1060 VMEM_1 DPI_4__Vthr 0.22547f
C1061 a_22014_50454# a_16310_50504# 15.0391f
C1062 w[2] w[10] 0.26911f
C1063 VDD DAC_5__Isum_i 11.7275f
C1064 VDD w[21] 1.54094f
C1065 a_89378_14492# spike[0] 1.13486f
C1066 s[4] w[18] 30.7471f
C1067 a_26214_13502# DAC_7__Vb 0.18591f
C1068 s[1] w[2] 1.62362f
C1069 w[12] a_34614_64642# 0.04246f
C1070 DAC_7__Vb a_22014_13502# 0.37182f
C1071 s[4] s[2] 0.24706f
C1072 spike[2] a_92184_57760# 0.28806f
C1073 a_92184_20808# VDD 2.94927f
C1074 a_26214_94846# a_34614_94846# 7.01128f
C1075 w[13] w[23] 0.24747f
C1076 spike[1] w[14] 0.14735f
C1077 w[6] w[17] 0.1553f
C1078 VT neuron_4__VKup 1.48945f
C1079 VDD a_19914_80658# 0.75723f
C1080 spike[1] w[15] 0.14735f
C1081 a_26214_94846# DAC_3__Isum_e 2.06134f
C1082 DAC_1__Isum_e DAC_1__Isum_i 8.42379f
C1083 w[25] w[12] 0.12787f
C1084 a_17058_110704# a_19914_110862# 0.11443f
C1085 a_34614_125050# a_17058_124892# 0.75055f
C1086 s[4] spike[0] 1.51933f
C1087 neuron_4__VIp neuron_4__VNA 9.61565f
C1088 w[4] w[11] 0.20253f
C1089 a_86480_57760# VDD 10.7107f
C1090 spike[1] a_87742_32618# 0.14351f
C1091 s[2] w[1] 0.62712f
C1092 VDD w[23] 0.43566f
C1093 neuron_4__Vamp_bias DPI_4__Vthr 0.59643f
C1094 w[26] w[8] 0.1314f
C1095 a_62266_15456# DPI_4__Vthr 1.22157f
C1096 neuron_4__VKdn Iref 3.53198f
C1097 DAC_7__Vb DPI_4__Vthr 1.34923f
C1098 VT spike[3] 0.15634f
C1099 neuron_4__VK VT 4.58179f
C1100 VDD a_16310_32028# 2.32564f
C1101 w[3] s[7] 0.14218f
C1102 a_22014_31978# a_16310_32028# 15.0391f
C1103 a_86480_57760# a_88750_51444# 0.01339f
C1104 s[7] DAC_7__Vb 6.86066f
C1105 a_26214_50454# a_22014_50454# 0.29412f
C1106 VMEM_2 a_85942_51444# 0.27205f
C1107 a_85942_51444# a_87742_51094# 0.9311f
C1108 a_17058_31820# a_34614_31978# 0.75055f
C1109 w[18] w[21] 0.1391f
C1110 s[2] DAC_5__Isum_i 0.01848f
C1111 w[11] w[27] 0.1391f
C1112 s[2] w[21] 3.40371f
C1113 w[29] w[28] 27.2179f
C1114 s[7] w[5] 0.04571f
C1115 a_88370_32968# a_91556_39284# 0.37248f
C1116 spike[4] a_88122_111852# 0.04786f
C1117 s[6] s[3] 0.09887f
C1118 neuron_4__Vamp_bias a_87742_51094# 0.10425f
C1119 VMEM_2 neuron_4__Vamp_bias 3.50082f
C1120 w[26] w[10] 9.65104f
C1121 a_62978_57852# VDD 3.03034f
C1122 DAC_7__Vb pulse[1] 1.22973f
C1123 w[26] s[1] 0.13331f
C1124 w[3] pulse[1] 0.38298f
C1125 w[0] s[0] 1.02123f
C1126 a_26214_50454# a_16310_50504# 1.78781f
C1127 w[21] spike[0] 0.13367f
C1128 w[18] w[23] 0.14232f
C1129 w[31] spike[3] 0.07426f
C1130 s[2] w[23] 2.50235f
C1131 a_89378_111852# a_88122_111852# 0.26264f
C1132 a_86480_57760# spike[2] 0.52077f
C1133 a_16310_64692# DAC_5__Isum_i 1.77847f
C1134 w[5] pulse[1] 0.87532f
C1135 s[0] w[10] 0.12236f
C1136 a_92184_20808# spike[0] 0.28806f
C1137 a_85942_111852# VDD 0.22723f
C1138 w[11] w[9] 0.09074f
C1139 s[1] s[0] 1.87916f
C1140 spike[1] VT 0.17352f
C1141 neuron_4__VIp neuron_4__Vlk 2.68553f
C1142 spike[3] w[30] 0.08662f
C1143 a_87742_32618# VMEM_1 3.23701f
C1144 w[23] spike[0] 13.3789f
C1145 VDD a_16310_94896# 0.54717f
C1146 a_34614_94846# DAC_3__Isum_e 6.81042f
C1147 s[7] w[6] 2.34747f
C1148 w[9] w[22] 0.12444f
C1149 a_92184_20808# a_88370_14492# 0.04621f
C1150 a_22014_125050# w[30] 0.25032f
C1151 w[14] DAC_7__Vb 1.43031f
C1152 a_26214_110862# VDD 0.26038f
C1153 w[15] DAC_7__Vb 1.50195f
C1154 w[19] w[17] 7.05825f
C1155 w[3] w[15] 0.21066f
C1156 w[3] w[14] 0.11744f
C1157 a_88122_32968# VDD 0.14568f
C1158 s[7] w[24] 0.06307f
C1159 w[16] s[6] 0.0725f
C1160 a_17058_64484# w[15] 1.50762f
C1161 VDD bias_0__VT_inh 19.4669f
C1162 w[31] w[20] 0.19095f
C1163 a_89378_14492# VMEM_0 3.31883f
C1164 VDD a_34614_13502# 0.30771f
C1165 neuron_4__Vamp_bias a_87742_14142# 0.07771f
C1166 s[1] a_17058_13344# 0.03946f
C1167 w[6] pulse[1] 0.48707f
C1168 VT spike[4] 0.07353f
C1169 a_34614_125050# a_16310_125100# 1.31469f
C1170 a_91556_39284# neuron_4__VKup 0.04013f
C1171 a_87742_32618# neuron_4__Vamp_bias 0.07771f
C1172 w[14] w[5] 0.49529f
C1173 w[30] w[20] 0.17727f
C1174 w[15] w[5] 0.51491f
C1175 DAC_7__Vb a_17058_80500# 0.02891f
C1176 a_26214_125050# a_22014_125050# 0.29412f
C1177 neuron_4__VKdn neuron_4__VKup 10.681f
C1178 a_22014_94846# a_16310_94896# 15.0391f
C1179 w[24] pulse[1] 0.12082f
C1180 DAC_7__Vb w[8] 7.05811f
C1181 a_62266_82612# DAC_3__Isum_e 4.71525f
C1182 w[16] s[3] 0.099f
C1183 VMEM_1 VT 1.72977f
C1184 a_86480_118168# a_88750_111852# 0.01339f
C1185 a_88122_32968# a_89378_32968# 0.26264f
C1186 DAC_7__Vb a_34614_110862# 0.093f
C1187 a_92184_39284# neuron_4__VNA 0.04168f
C1188 neuron_4__VK neuron_4__VKdn 40.4648f
C1189 s[4] s[6] 19.1732f
C1190 a_86480_20808# neuron_4__VKup 3.23723f
C1191 a_21486_142736# Iref 3.56302f
C1192 neuron_4__VKdn spike[3] 0.24035f
C1193 w[5] w[8] 1.29434f
C1194 DPI_4__VT a_62266_82612# 0.84773f
C1195 VDD a_19914_50454# 0.75723f
C1196 DAC_7__Vb w[0] 7.29274f
C1197 w[3] w[0] 1.59209f
C1198 w[2] w[9] 0.076f
C1199 w[12] w[13] 7.78311f
C1200 a_26214_80658# a_16310_80708# 1.78781f
C1201 DAC_1__Isum_i a_16558_110912# 1.32914f
C1202 a_85942_51444# VT 0.26497f
C1203 a_17058_31820# a_26214_31978# 0.06004f
C1204 a_34614_64642# a_26214_64642# 7.01128f
C1205 s[7] w[28] 1.4472f
C1206 DPI_4__VT VMEM_3 0.4329f
C1207 DAC_7__Vb w[10] 1.41445f
C1208 a_88370_111852# a_88122_111852# 1.31172f
C1209 w[3] w[10] 0.0129f
C1210 s[1] DAC_7__Vb 8.18615f
C1211 w[3] s[1] 0.23875f
C1212 w[6] w[14] 0.13517f
C1213 a_22014_80658# a_16310_80708# 15.0391f
C1214 w[15] w[6] 0.14054f
C1215 VDD a_67078_123924# 8.72064f
C1216 s[6] w[1] 0.05622f
C1217 a_86480_87964# neuron_4__VKup 3.2517f
C1218 VDD w[12] 0.15091f
C1219 neuron_4__Vamp_bias VT 2.50081f
C1220 s[4] s[3] 0.34409f
C1221 spike[1] a_17058_94688# 0.37995f
C1222 a_19914_110862# a_34614_110862# 0.16484f
C1223 VDD neuron_4__VNA 35.9266f
C1224 w[5] w[10] 0.1111f
C1225 a_62266_82612# VMEM_3 0.06733f
C1226 s[1] w[5] 1.72067f
C1227 pulse[1] w[28] 2.39243f
C1228 w[26] w[27] 25.5063f
C1229 a_92184_20808# VMEM_0 0.93986f
C1230 spike[1] a_91556_39284# 1.98323f
C1231 VDD a_91556_20808# 2.79898f
C1232 VDD DAC_1__Isum_i 12.0902f
C1233 a_86480_87964# spike[3] 0.52077f
C1234 w[27] w[20] 0.17776f
C1235 spike[1] neuron_4__VKdn 0.18649f
C1236 a_86480_57760# a_88122_51444# 0.09468f
C1237 w[6] w[8] 0.05073f
C1238 s[6] w[21] 0.06396f
C1239 s[7] w[19] 0.05969f
C1240 a_88122_111852# a_87742_111502# 0.60758f
C1241 spike[1] w[27] 0.14368f
C1242 w[1] s[3] 0.03061f
C1243 spike[1] a_62266_52408# 0.01074f
C1244 VDD a_85942_32968# 0.22723f
C1245 DAC_3__Isum_e DPI_4__Vthr 0.94933f
C1246 a_26214_94846# DAC_3__Isum_i 10.8659f
C1247 VDD a_88370_51444# 3.95905f
C1248 w[24] w[8] 0.13427f
C1249 s[7] w[29] 0.44004f
C1250 w[31] DAC_7__Vb 1.37791f
C1251 w[6] w[0] 1.4806f
C1252 DAC_5__Isum_i s[3] 0.01848f
C1253 w[26] w[9] 0.11803f
C1254 w[24] a_34614_110862# 0.04246f
C1255 w[21] s[3] 0.088f
C1256 w[18] w[12] 2.38046f
C1257 w[22] s[5] 0.34459f
C1258 s[6] w[23] 0.05859f
C1259 w[19] pulse[1] 0.11781f
C1260 s[2] w[12] 2.74675f
C1261 a_88370_51444# a_88750_51444# 0.67211f
C1262 w[6] w[10] 0.14284f
C1263 DPI_4__VT DPI_4__Vthr 40.3636f
C1264 w[6] s[1] 0.73748f
C1265 w[11] w[7] 1.39723f
C1266 DAC_7__Vb w[30] 1.3063f
C1267 spike[2] neuron_4__VNA 1.94446f
C1268 a_17058_124892# DAC_1__Isum_i 0.05814f
C1269 w[9] s[0] 0.39819f
C1270 w[16] s[4] 1.41785f
C1271 a_88370_111852# VT 0.07035f
C1272 a_34614_50454# DAC_5__Isum_e 6.81042f
C1273 VDD neuron_4__Vlk 4.93277f
C1274 a_34614_80658# a_16310_80708# 1.31469f
C1275 a_85942_111852# VMEM_4 0.27205f
C1276 DAC_5__Isum_i a_17058_50296# 0.05814f
C1277 neuron_4__VKdn spike[4] 0.10461f
C1278 w[24] w[10] 8.23445f
C1279 w[12] spike[0] 0.05875f
C1280 s[7] w[17] 0.06753f
C1281 w[23] s[3] 0.09675f
C1282 a_87742_81298# neuron_4__VNA 0.16958f
C1283 s[1] w[24] 0.14038f
C1284 a_62266_82612# DPI_4__Vthr 1.22157f
C1285 a_21486_142736# neuron_4__VKup 0.5325f
C1286 a_26214_125050# DAC_7__Vb 0.18591f
C1287 a_88750_32968# neuron_4__VKdn 0.04013f
C1288 VDD a_34614_50454# 0.19093f
C1289 VMEM_1 a_91556_39284# 0.12888f
C1290 neuron_4__VNA spike[0] 0.07719f
C1291 a_16310_64692# w[12] 0.01848f
C1292 w[7] w[22] 2.71874f
C1293 VMEM_2 DPI_4__VT 0.70228f
C1294 DPI_4__Vthr VMEM_3 0.57667f
C1295 a_88370_81648# neuron_4__VNA 0.4065f
C1296 a_91556_87964# VMEM_3 0.12888f
C1297 VMEM_1 neuron_4__VKdn 0.29778f
C1298 a_26214_13502# a_22014_13502# 0.29412f
C1299 neuron_4__VIp Iref 17.1821f
C1300 a_91556_20808# spike[0] 1.98323f
C1301 w[28] w[8] 0.14715f
C1302 spike[2] a_88370_51444# 9.68412f
C1303 VT a_87742_111502# 0.51489f
C1304 pulse[1] w[17] 0.15536f
C1305 a_91556_57760# neuron_4__VKup 0.04013f
C1306 neuron_4__VK a_21486_142736# 0.91781f
C1307 w[14] w[19] 8.93898f
C1308 w[15] w[19] 15.7906f
C1309 w[4] DAC_7__Vb 8.65593f
C1310 w[3] w[4] 0.3863f
C1311 a_26214_110862# a_16310_110912# 1.78781f
C1312 a_22014_50454# w[10] 0.25032f
C1313 w[31] w[6] 3.42049f
C1314 w[25] w[11] 0.13847f
C1315 a_16310_50504# w[8] 0.01848f
C1316 neuron_4__VNA a_88370_14492# 0.40519f
C1317 w[16] w[21] 0.13863f
C1318 w[4] w[5] 7.08539f
C1319 spike[2] neuron_4__Vlk 1.99684f
C1320 w[6] w[30] 1.39976f
C1321 a_17058_80500# w[19] 1.50762f
C1322 a_86480_118168# VDD 10.7108f
C1323 a_91556_20808# a_88370_14492# 0.37248f
C1324 a_34614_64642# a_22014_64642# 0.11882f
C1325 s[4] w[1] 0.07028f
C1326 a_34614_94846# DAC_3__Isum_i 0.11679f
C1327 s[1] w[28] 0.14156f
C1328 DAC_7__Vb w[27] 1.4569f
C1329 neuron_4__VKdn DAC_7__Vb 0.34214f
C1330 neuron_4__Vamp_bias neuron_4__VKdn 17.4825f
C1331 w[19] w[8] 0.14704f
C1332 DAC_3__Isum_i DAC_3__Isum_e 11.4824f
C1333 w[16] w[23] 0.23762f
C1334 a_16310_50504# w[10] 0.18228f
C1335 a_62266_112816# DPI_4__VT 0.82216f
C1336 neuron_4__Vlk spike[0] 1.99048f
C1337 a_17058_80500# DAC_3__Isum_e 14.2174f
C1338 s[4] w[21] 0.15247f
C1339 w[14] w[17] 0.13346f
C1340 w[29] w[8] 0.1559f
C1341 w[13] a_26214_64642# 0.08445f
C1342 DAC_6__Isum_e a_16310_32028# 0.07931f
C1343 w[15] w[17] 3.38768f
C1344 DAC_5__Isum_e a_26214_64642# 2.06134f
C1345 DAC_7__Vb w[9] 1.41089f
C1346 w[19] w[10] 0.15357f
C1347 s[1] w[19] 0.12f
C1348 DAC_1__Isum_i a_16310_125100# 1.77847f
C1349 VDD a_26214_64642# 0.26038f
C1350 w[4] w[6] 0.29239f
C1351 a_19914_110862# w[27] 0.56837f
C1352 VMEM_4 a_67078_123924# 6.53771f
C1353 VDD a_89378_51444# 0.17724f
C1354 w[26] s[5] 0.06636f
C1355 w[21] w[1] 0.89917f
C1356 a_92184_87964# VMEM_3 0.93986f
C1357 DPI_4__VT a_67078_63516# 1.07026f
C1358 neuron_4__Vamp_bias a_86480_87964# 0.03068f
C1359 s[4] w[23] 0.1416f
C1360 a_26214_80658# DAC_7__Vb 0.18591f
C1361 w[9] w[5] 0.57227f
C1362 w[31] w[28] 0.08777f
C1363 w[17] w[8] 0.1545f
C1364 VMEM_2 DPI_4__Vthr 0.97804f
C1365 w[20] s[5] 2.93377f
C1366 DAC_3__Isum_i VMEM_3 0.38082f
C1367 VMEM_4 neuron_4__VNA 0.0513f
C1368 spike[1] s[5] 2.64783f
C1369 s[1] w[29] 0.15906f
C1370 a_89378_51444# a_88750_51444# 1.47502f
C1371 DAC_7__Vb a_22014_80658# 0.37182f
C1372 s[7] pulse[1] 0.18189f
C1373 VDD a_22014_110862# 0.42217f
C1374 s[0] s[5] 0.07501f
C1375 w[6] w[27] 3.24812f
C1376 w[30] w[28] 0.08348f
C1377 a_19914_64642# a_34614_64642# 0.16484f
C1378 VMEM_4 DAC_1__Isum_i 0.38082f
C1379 DAC_1__Isum_i a_16310_110912# 1.77847f
C1380 neuron_4__VIp neuron_4__VKup 9.61669f
C1381 DAC_1__Isum_e spike[3] 0.25473f
C1382 a_62978_88056# VDD 3.05381f
C1383 a_26214_94846# a_17058_94688# 0.06004f
C1384 DAC_1__Isum_e a_16558_125100# 2.10366f
C1385 VMEM_2 a_87742_51094# 3.23701f
C1386 w[26] w[7] 1.57888f
C1387 s[6] w[12] 0.06724f
C1388 w[10] w[17] 0.15236f
C1389 w[27] w[24] 0.08777f
C1390 s[1] w[17] 1.26973f
C1391 w[7] w[20] 1.48505f
C1392 a_17058_110704# a_34614_110862# 0.75055f
C1393 VMEM_0 a_91556_20808# 0.12888f
C1394 neuron_4__VIp spike[3] 0.17256f
C1395 neuron_4__VIp neuron_4__VK 44.9481f
C1396 w[21] w[23] 0.0901f
C1397 spike[2] a_89378_51444# 1.13486f
C1398 w[6] w[9] 0.68831f
C1399 a_88370_51444# a_88122_51444# 1.31172f
C1400 VDD a_34614_31978# 0.30771f
C1401 s[6] DAC_1__Isum_i 0.01848f
C1402 a_34614_31978# a_22014_31978# 0.11882f
C1403 w[31] w[29] 0.0901f
C1404 w[12] s[3] 3.28136f
C1405 a_62266_112816# DPI_4__Vthr 1.22157f
C1406 a_19914_50454# a_17058_50296# 0.11443f
C1407 s[7] w[15] 0.04984f
C1408 s[7] w[14] 0.04254f
C1409 a_91556_87964# a_92184_87964# 0.53841f
C1410 VT VMEM_3 2.27601f
C1411 a_88370_32968# a_92184_39284# 0.04621f
C1412 VMEM_4 neuron_4__Vlk 2.28509f
C1413 a_19914_31978# a_17058_31820# 0.11443f
C1414 w[9] w[24] 8.22628f
C1415 w[29] w[30] 33.9428f
C1416 DAC_3__Isum_i DPI_4__Vthr 0.94757f
C1417 pulse[0] a_16310_13552# 0.04246f
C1418 a_16310_64692# a_26214_64642# 1.78781f
C1419 pulse[0] w[2] 0.92643f
C1420 DAC_7__Vb a_21486_142736# 0.32201f
C1421 a_62978_88056# a_67078_93720# 8.75182f
C1422 neuron_4__Vamp_bias a_21486_142736# 0.85706f
C1423 w[25] w[26] 25.5993f
C1424 a_62978_57852# DAC_5__Isum_i 0.15507f
C1425 VDD Iref 10.7325f
C1426 w[11] w[13] 1.38476f
C1427 a_34614_80658# DAC_7__Vb 0.093f
C1428 w[27] w[28] 16.4104f
C1429 neuron_4__Vlk VMEM_0 0.22319f
C1430 w[25] w[20] 0.17776f
C1431 VDD a_19914_125050# 0.75723f
C1432 spike[1] w[25] 0.14393f
C1433 w[14] pulse[1] 0.21135f
C1434 s[7] w[8] 0.06259f
C1435 spike[1] neuron_4__VIp 0.15241f
C1436 a_26214_125050# w[29] 0.08445f
C1437 w[15] pulse[1] 0.12707f
C1438 a_67078_63516# DPI_4__Vthr 1.99932f
C1439 a_16558_94896# a_16310_94896# 1.6884f
C1440 VDD w[11] 0.26847f
C1441 VDD a_86480_39284# 10.7067f
C1442 w[13] w[22] 0.246f
C1443 DAC_7__Vb s[5] 6.47282f
C1444 VDD a_88370_32968# 3.95796f
C1445 s[7] w[0] 0.57237f
C1446 a_34614_94846# a_17058_94688# 0.75055f
C1447 a_19914_13502# a_34614_13502# 0.16484f
C1448 w[9] w[28] 9.40912f
C1449 pulse[1] w[8] 0.12836f
C1450 a_86480_118168# VMEM_4 1.71072f
C1451 VMEM_2 a_67078_63516# 5.70003f
C1452 DAC_3__Isum_e a_17058_94688# 14.2174f
C1453 w[16] w[12] 3.0965f
C1454 s[7] w[10] 0.0703f
C1455 w[21] a_16310_94896# 0.10002f
C1456 s[7] s[1] 0.38964f
C1457 VDD w[22] 1.33814f
C1458 a_17058_124892# a_19914_125050# 0.11443f
C1459 VT DPI_4__Vthr 0.17014f
C1460 w[9] a_16310_50504# 0.10002f
C1461 VDD a_22014_64642# 0.42217f
C1462 spike[2] Iref 0.06354f
C1463 a_16558_80708# a_16310_80708# 1.6884f
C1464 a_19914_94846# DAC_7__Vb 0.74342f
C1465 w[0] pulse[1] 0.87062f
C1466 neuron_4__VIp spike[4] 0.08826f
C1467 w[7] DAC_7__Vb 1.48799f
C1468 w[3] w[7] 0.04533f
C1469 spike[3] a_89378_81648# 1.13486f
C1470 neuron_4__VK a_89378_81648# 0.04013f
C1471 a_88750_111852# spike[4] 1.35619f
C1472 w[15] w[14] 9.12276f
C1473 w[4] w[17] 1.51529f
C1474 pulse[1] w[10] 0.78417f
C1475 w[11] w[18] 2.26335f
C1476 s[2] w[11] 0.58306f
C1477 w[23] a_16310_94896# 0.364f
C1478 s[1] pulse[1] 3.61114f
C1479 VDD DAC_7__Isum_e 14.5289f
C1480 w[9] w[19] 0.14902f
C1481 neuron_4__VIp VMEM_1 0.54209f
C1482 s[4] w[12] 0.06676f
C1483 spike[0] Iref 0.08129f
C1484 VMEM_2 VT 1.99205f
C1485 VT a_87742_51094# 0.51489f
C1486 pulse[0] s[0] 1.96255f
C1487 DPI_4__VT neuron_4__VKdn 0.30643f
C1488 w[7] w[5] 0.38983f
C1489 neuron_4__VKdn a_88750_14492# 0.04013f
C1490 a_34614_50454# a_17058_50296# 0.75055f
C1491 a_22014_94846# w[22] 0.25032f
C1492 a_88750_111852# a_89378_111852# 1.47502f
C1493 DPI_4__VT a_62266_52408# 0.85444f
C1494 a_92184_57760# neuron_4__VNA 0.04168f
C1495 w[15] w[8] 0.12922f
C1496 w[14] w[8] 0.12265f
C1497 VDD a_16310_80708# 0.54717f
C1498 w[18] w[22] 0.14237f
C1499 DAC_3__Isum_i a_17058_80500# 0.05814f
C1500 w[11] spike[0] 0.13641f
C1501 DAC_1__Isum_e DAC_7__Vb 0.18792f
C1502 s[7] w[31] 7.78825f
C1503 s[2] w[22] 3.47522f
C1504 VDD a_26214_31978# 11.1263f
C1505 a_26214_50454# w[9] 0.08445f
C1506 DAC_7__Vb a_34614_64642# 0.093f
C1507 a_89378_51444# a_88122_51444# 0.26264f
C1508 a_22014_31978# a_26214_31978# 0.29412f
C1509 a_19914_50454# DAC_5__Isum_i 0.01896f
C1510 VDD a_16310_13552# 2.32564f
C1511 a_86480_20808# a_88750_14492# 0.01339f
C1512 VDD neuron_4__VKup 29.0291f
C1513 VDD w[2] 0.08809f
C1514 a_17058_64484# a_34614_64642# 0.75055f
C1515 a_22014_110862# a_16310_110912# 15.0391f
C1516 a_26214_80658# DAC_3__Isum_e 2.06134f
C1517 s[7] w[30] 0.41392f
C1518 neuron_4__VKdn VMEM_3 0.46354f
C1519 w[24] s[5] 0.06618f
C1520 w[25] DAC_7__Vb 1.47332f
C1521 neuron_4__Vamp_bias neuron_4__VIp 11.1287f
C1522 neuron_4__VIp DAC_7__Vb 0.23515f
C1523 w[22] spike[0] 0.13705f
C1524 VDD a_19914_64642# 0.75723f
C1525 w[9] w[17] 0.151f
C1526 a_17058_110704# w[27] 1.50762f
C1527 pulse[0] a_17058_13344# 0.37995f
C1528 w[15] w[10] 0.12634f
C1529 a_88370_51444# a_92184_57760# 0.04621f
C1530 w[14] w[10] 0.18026f
C1531 w[21] w[12] 0.11252f
C1532 w[15] s[1] 2.0347f
C1533 w[14] s[1] 0.68008f
C1534 w[6] w[7] 7.13462f
C1535 VDD spike[3] 2.65248f
C1536 w[25] w[5] 10.5608f
C1537 VDD neuron_4__VK 7.59537f
C1538 a_34614_125050# DAC_1__Isum_i 0.11679f
C1539 a_16310_64692# a_22014_64642# 15.0391f
C1540 a_19914_31978# w[7] 0.56837f
C1541 spike[1] a_92184_39284# 0.28806f
C1542 a_26214_80658# w[17] 0.08445f
C1543 w[18] a_16310_80708# 0.18228f
C1544 VDD a_16558_125100# 0.21115f
C1545 a_92184_20808# neuron_4__VNA 0.04168f
C1546 VT a_87742_14142# 0.51489f
C1547 w[7] w[24] 0.25274f
C1548 a_87742_32618# VT 0.52448f
C1549 w[10] w[8] 0.88018f
C1550 a_92184_20808# a_91556_20808# 0.53841f
C1551 a_19914_125050# a_16310_125100# 17.2602f
C1552 s[1] w[8] 1.72596f
C1553 w[26] w[13] 0.14946f
C1554 a_88122_81648# spike[3] 0.04786f
C1555 w[12] w[23] 0.11912f
C1556 s[7] w[4] 0.23441f
C1557 a_89378_32968# neuron_4__VK 0.04013f
C1558 a_26214_94846# a_19914_94846# 0.27118f
C1559 VDD a_22014_125050# 0.42217f
C1560 a_86480_87964# VMEM_3 1.71072f
C1561 spike[2] neuron_4__VKup 0.30794f
C1562 w[13] w[20] 25.4043f
C1563 a_86480_57760# neuron_4__VNA 0.3529f
C1564 spike[1] w[13] 0.1465f
C1565 spike[1] DAC_5__Isum_e 1.51567f
C1566 w[28] s[5] 0.05845f
C1567 a_16310_80708# spike[0] 0.04246f
C1568 w[0] w[10] 0.01151f
C1569 a_17058_124892# spike[3] 0.37995f
C1570 w[26] VDD 0.3145f
C1571 pulse[0] DAC_7__Vb 0.08662f
C1572 s[1] w[0] 1.30993f
C1573 w[3] pulse[0] 0.58749f
C1574 neuron_4__VKdn DPI_4__Vthr 3.07699f
C1575 a_87742_81298# neuron_4__VKup 0.14151f
C1576 VDD w[20] 0.60086f
C1577 spike[1] VDD 6.96238f
C1578 w[25] w[6] 0.13654f
C1579 VMEM_4 Iref 0.72103f
C1580 s[7] w[27] 0.06307f
C1581 spike[0] neuron_4__VKup 0.0554f
C1582 a_17058_124892# a_16558_125100# 0.11824f
C1583 spike[2] spike[3] 11.7668f
C1584 spike[2] neuron_4__VK 12.4209f
C1585 w[4] pulse[1] 5.59095f
C1586 s[1] w[10] 0.28917f
C1587 a_88370_81648# neuron_4__VKup 0.83586f
C1588 DPI_4__Vthr a_62266_52408# 1.73941f
C1589 a_88370_111852# a_88750_111852# 0.67211f
C1590 VDD s[0] 1.65282f
C1591 a_86480_57760# a_88370_51444# 4.40172f
C1592 a_34614_80658# DAC_3__Isum_e 6.81042f
C1593 w[25] w[24] 26.6424f
C1594 a_17058_124892# a_22014_125050# 0.05882f
C1595 w[7] w[28] 0.5135f
C1596 VMEM_0 Iref 0.43558f
C1597 a_87742_81298# spike[3] 0.14351f
C1598 VMEM_1 a_92184_39284# 0.93986f
C1599 a_34614_50454# DAC_5__Isum_i 0.11679f
C1600 spike[3] spike[0] 0.08022f
C1601 neuron_4__VK spike[0] 0.1686f
C1602 a_16310_64692# a_19914_64642# 17.2602f
C1603 w[31] w[8] 0.15252f
C1604 VMEM_2 neuron_4__VKdn 0.37902f
C1605 a_89378_32968# spike[1] 1.13486f
C1606 DPI_4__VT a_21486_142736# 0.13805f
C1607 neuron_4__Vamp_bias a_85942_14492# 0.05117f
C1608 w[27] pulse[1] 2.52415f
C1609 spike[3] a_88370_81648# 9.68412f
C1610 a_88370_14492# neuron_4__VKup 0.84227f
C1611 s[7] w[9] 0.07106f
C1612 VMEM_2 a_62266_52408# 0.06733f
C1613 w[30] w[8] 0.14715f
C1614 w[26] w[18] 0.1331f
C1615 w[29] s[5] 0.31756f
C1616 s[2] w[26] 0.21526f
C1617 w[26] spike[2] 0.08662f
C1618 VDD spike[4] 1.82784f
C1619 spike[1] w[18] 0.06128f
C1620 w[18] w[20] 0.89919f
C1621 s[2] w[20] 0.08203f
C1622 spike[1] s[2] 0.3649f
C1623 s[6] w[11] 0.06141f
C1624 spike[1] spike[2] 0.37839f
C1625 VDD a_17058_13344# 8.90537f
C1626 a_88750_32968# VDD 0.15438f
C1627 w[7] w[19] 0.10112f
C1628 w[4] w[14] 2.32702f
C1629 w[15] w[4] 1.17426f
C1630 w[31] s[1] 0.14156f
C1631 s[2] s[0] 0.13902f
C1632 w[9] pulse[1] 0.27076f
C1633 a_34614_94846# a_19914_94846# 0.16484f
C1634 VDD VMEM_1 5.97863f
C1635 a_91556_118168# neuron_4__VKup 0.04013f
C1636 VDD a_89378_111852# 0.17724f
C1637 DAC_3__Isum_i a_17058_94688# 0.05814f
C1638 a_88750_81648# spike[3] 1.35619f
C1639 s[1] w[30] 0.14156f
C1640 a_17058_31820# pulse[1] 0.37995f
C1641 spike[1] spike[0] 13.8795f
C1642 w[11] s[3] 0.02924f
C1643 s[6] w[22] 0.05859f
C1644 w[7] w[29] 0.27606f
C1645 bias_0__VT_inh neuron_4__VNA 0.41066f
C1646 a_89378_32968# a_88750_32968# 1.47502f
C1647 a_16310_64692# spike[1] 0.04246f
C1648 w[4] w[8] 0.45631f
C1649 a_26214_110862# DAC_1__Isum_i 10.8659f
C1650 a_85942_51444# VDD 0.22723f
C1651 w[13] DAC_7__Vb 1.45477f
C1652 a_89378_32968# VMEM_1 3.31883f
C1653 a_34614_31978# DAC_6__Isum_e 6.81042f
C1654 DAC_5__Isum_e a_16558_64692# 2.10366f
C1655 spike[3] a_16310_125100# 0.04246f
C1656 spike[2] spike[4] 2.22178f
C1657 a_17058_64484# DAC_5__Isum_e 14.2174f
C1658 a_88122_32968# a_85942_32968# 0.02914f
C1659 w[22] s[3] 0.09675f
C1660 VMEM_4 neuron_4__VKup 0.06785f
C1661 w[7] w[17] 0.12626f
C1662 VDD a_62266_15456# 9.55918f
C1663 w[11] a_17058_50296# 1.53484f
C1664 a_16558_125100# a_16310_125100# 1.6884f
C1665 VDD DAC_7__Vb 31.9141f
C1666 neuron_4__Vamp_bias VDD 4.70447f
C1667 w[13] w[5] 0.22571f
C1668 DAC_7__Vb a_22014_31978# 0.37182f
C1669 w[3] VDD 0.19721f
C1670 VDD a_16558_64692# 0.21115f
C1671 DAC_5__Isum_i a_26214_64642# 10.8659f
C1672 a_17058_64484# VDD 8.90724f
C1673 a_88122_14492# a_88750_14492# 1.82301f
C1674 w[27] w[8] 0.1314f
C1675 w[14] w[9] 0.10745f
C1676 DAC_5__Isum_e a_16558_50504# 2.10366f
C1677 w[15] w[9] 0.12461f
C1678 w[4] w[10] 0.09477f
C1679 a_86480_20808# a_87742_14142# 0.68101f
C1680 w[4] s[1] 2.24806f
C1681 VDD w[5] 0.15515f
C1682 spike[4] spike[0] 1.41818f
C1683 w[31] w[30] 30.0989f
C1684 a_22014_125050# a_16310_125100# 15.0391f
C1685 a_21486_142736# DPI_4__Vthr 19.7797f
C1686 VMEM_4 spike[3] 0.14972f
C1687 VMEM_4 neuron_4__VK 0.26349f
C1688 a_67078_63516# a_62266_52408# 0.118f
C1689 a_62266_33932# VMEM_1 0.06733f
C1690 VDD a_16558_50504# 0.21115f
C1691 s[6] w[2] 0.04984f
C1692 VMEM_1 spike[0] 0.024f
C1693 a_26214_80658# DAC_3__Isum_i 10.8659f
C1694 w[27] w[10] 9.5467f
C1695 neuron_4__Vlk bias_0__VT_inh 0.17447f
C1696 w[9] w[8] 8.15252f
C1697 a_22014_94846# DAC_7__Vb 0.37182f
C1698 s[1] w[27] 0.13273f
C1699 DPI_4__VT neuron_4__VIp 0.31141f
C1700 VDD a_19914_110862# 0.75723f
C1701 a_26214_80658# a_17058_80500# 0.06004f
C1702 neuron_4__VK VMEM_0 1.01143f
C1703 DAC_1__Isum_i a_67078_123924# 3.76294f
C1704 a_86480_118168# a_85942_111852# 2.33814f
C1705 DAC_3__Isum_i a_22014_80658# 12.8867f
C1706 w[18] DAC_7__Vb 1.42095f
C1707 VT neuron_4__VKdn 14.2342f
C1708 s[2] DAC_7__Vb 9.05814f
C1709 w[3] s[2] 0.2067f
C1710 neuron_4__Vamp_bias spike[2] 0.70396f
C1711 spike[2] DAC_7__Vb 0.20882f
C1712 s[6] spike[3] 0.25978f
C1713 w[2] s[3] 0.02841f
C1714 a_17058_80500# a_22014_80658# 0.05882f
C1715 s[7] s[5] 0.0791f
C1716 w[9] w[0] 0.10109f
C1717 VDD a_92184_118168# 2.94927f
C1718 w[16] w[22] 0.13031f
C1719 w[26] a_16310_110912# 0.18228f
C1720 DAC_1__Isum_e a_17058_110704# 14.2174f
C1721 a_88370_111852# VDD 3.9582f
C1722 VDD w[6] 0.15765f
C1723 w[18] w[5] 0.10878f
C1724 w[6] a_22014_31978# 0.25032f
C1725 w[13] w[24] 0.14016f
C1726 a_16558_32028# pulse[1] 0.01869f
C1727 neuron_4__Vamp_bias a_87742_81298# 0.10672f
C1728 s[2] w[5] 0.15528f
C1729 w[9] w[10] 10.2189f
C1730 s[1] w[9] 0.25837f
C1731 VMEM_2 a_91556_57760# 0.12888f
C1732 s[4] w[11] 0.1899f
C1733 neuron_4__VIp VMEM_3 1.81774f
C1734 neuron_4__Vamp_bias spike[0] 0.51883f
C1735 VDD a_19914_31978# 0.77619f
C1736 DAC_7__Vb spike[0] 0.8955f
C1737 s[2] a_16558_50504# 0.04246f
C1738 a_19914_31978# a_22014_31978# 0.57119f
C1739 neuron_4__Vamp_bias a_88370_81648# 0.09982f
C1740 a_88370_51444# neuron_4__VNA 0.40762f
C1741 a_91556_118168# spike[4] 1.98323f
C1742 pulse[1] s[5] 0.18235f
C1743 s[1] a_17058_31820# 3.46922f
C1744 VDD w[24] 0.43383f
C1745 a_34614_50454# a_19914_50454# 0.16484f
C1746 a_16310_64692# a_16558_64692# 1.6884f
C1747 s[7] w[7] 0.18307f
C1748 a_16310_64692# a_17058_64484# 0.10497f
C1749 a_34614_125050# a_19914_125050# 0.16484f
C1750 VDD a_87742_111502# 6.10118f
C1751 s[4] w[22] 0.14169f
C1752 w[26] s[6] 0.42421f
C1753 a_26214_94846# VDD 0.26038f
C1754 a_16558_50504# spike[0] 0.01869f
C1755 w[3] VSS 14.9383f
C1756 w[2] VSS 6.83551f
C1757 w[1] VSS 6.97954f
C1758 w[0] VSS 5.62299f
C1759 pulse[0] VSS 5.68371f
C1760 s[0] VSS 21.9147f
C1761 w[7] VSS 17.5904f
C1762 w[6] VSS 10.7281f
C1763 w[5] VSS 7.07042f
C1764 w[4] VSS 8.08943f
C1765 pulse[1] VSS 8.59205f
C1766 s[1] VSS 27.6972f
C1767 w[11] VSS 18.188f
C1768 w[10] VSS 8.87485f
C1769 w[9] VSS 7.46259f
C1770 w[8] VSS 9.64404f
C1771 s[2] VSS 29.7454f
C1772 w[15] VSS 16.3684f
C1773 w[14] VSS 8.84956f
C1774 w[13] VSS 9.94892f
C1775 w[12] VSS 9.48952f
C1776 s[3] VSS 25.7849f
C1777 w[19] VSS 17.4392f
C1778 w[18] VSS 13.0326f
C1779 w[17] VSS 14.3124f
C1780 w[16] VSS 10.338f
C1781 spike[0] VSS 62.6278f
C1782 s[4] VSS 25.759f
C1783 w[23] VSS 17.0757f
C1784 w[22] VSS 12.5092f
C1785 w[21] VSS 17.4735f
C1786 w[20] VSS 13.0929f
C1787 spike[1] VSS 56.3291f
C1788 s[5] VSS 42.2792f
C1789 VT VSS 33.4777f
C1790 w[27] VSS 18.211f
C1791 w[26] VSS 11.0893f
C1792 w[25] VSS 9.89249f
C1793 w[24] VSS 10.5742f
C1794 spike[2] VSS 63.2007f
C1795 spike[4] VSS 32.1923f
C1796 s[6] VSS 29.7449f
C1797 w[31] VSS 22.5904f
C1798 w[30] VSS 12.2388f
C1799 w[29] VSS 10.838f
C1800 w[28] VSS 11.5324f
C1801 spike[3] VSS 57.22961f
C1802 s[7] VSS 31.342f
C1803 Iref VSS 98.18221f
C1804 VDD VSS 3.32466p
C1805 a_89378_14492# VSS 4.53886f $ **FLOATING
C1806 a_88750_14492# VSS 3.65994f $ **FLOATING
C1807 a_88122_14492# VSS 5.91238f $ **FLOATING
C1808 a_85942_14492# VSS 5.03265f $ **FLOATING
C1809 a_62266_15456# VSS 8.55598f $ **FLOATING
C1810 a_34614_13502# VSS 5.10168f $ **FLOATING
C1811 a_26214_13502# VSS 9.33535f $ **FLOATING
C1812 a_22014_13502# VSS 16.5225f $ **FLOATING
C1813 a_19914_13502# VSS 43.9107f $ **FLOATING
C1814 a_16558_13552# VSS 2.88389f $ **FLOATING
C1815 a_16310_13552# VSS 9.72397f $ **FLOATING
C1816 a_92184_20808# VSS 0.1558f $ **FLOATING
C1817 VMEM_0 VSS 26.9716f $ **FLOATING
C1818 a_91556_20808# VSS 0.36469f $ **FLOATING
C1819 a_88370_14492# VSS 4.60927f $ **FLOATING
C1820 a_87742_14142# VSS 7.34113f $ **FLOATING
C1821 a_86480_20808# VSS 4.48294f $ **FLOATING
C1822 a_17058_13344# VSS 9.78008f $ **FLOATING
C1823 a_89378_32968# VSS 4.53886f $ **FLOATING
C1824 a_88750_32968# VSS 3.65994f $ **FLOATING
C1825 a_88122_32968# VSS 5.91238f $ **FLOATING
C1826 a_85942_32968# VSS 5.03265f $ **FLOATING
C1827 a_62266_33932# VSS 8.48072f $ **FLOATING
C1828 a_34614_31978# VSS 5.10168f $ **FLOATING
C1829 a_26214_31978# VSS 9.33535f $ **FLOATING
C1830 a_22014_31978# VSS 16.5225f $ **FLOATING
C1831 a_19914_31978# VSS 43.9107f $ **FLOATING
C1832 a_16558_32028# VSS 2.88389f $ **FLOATING
C1833 a_16310_32028# VSS 9.72397f $ **FLOATING
C1834 a_92184_39284# VSS 0.1558f $ **FLOATING
C1835 VMEM_1 VSS 26.6409f $ **FLOATING
C1836 a_91556_39284# VSS 0.36469f $ **FLOATING
C1837 a_88370_32968# VSS 4.6117f $ **FLOATING
C1838 a_87742_32618# VSS 7.34017f $ **FLOATING
C1839 a_86480_39284# VSS 4.51991f $ **FLOATING
C1840 a_17058_31820# VSS 9.8442f $ **FLOATING
C1841 a_89378_51444# VSS 4.53886f $ **FLOATING
C1842 a_88750_51444# VSS 3.65994f $ **FLOATING
C1843 a_88122_51444# VSS 5.91238f $ **FLOATING
C1844 a_85942_51444# VSS 5.03265f $ **FLOATING
C1845 a_62266_52408# VSS 8.43703f $ **FLOATING
C1846 a_34614_50454# VSS 5.10168f $ **FLOATING
C1847 a_26214_50454# VSS 9.33535f $ **FLOATING
C1848 a_22014_50454# VSS 16.5225f $ **FLOATING
C1849 a_19914_50454# VSS 43.9107f $ **FLOATING
C1850 a_16558_50504# VSS 2.88389f $ **FLOATING
C1851 a_16310_50504# VSS 9.72397f $ **FLOATING
C1852 a_92184_57760# VSS 0.1558f $ **FLOATING
C1853 a_91556_57760# VSS 0.36469f $ **FLOATING
C1854 a_88370_51444# VSS 4.58551f $ **FLOATING
C1855 a_87742_51094# VSS 7.32803f $ **FLOATING
C1856 a_86480_57760# VSS 4.46085f $ **FLOATING
C1857 VMEM_2 VSS 37.4327f $ **FLOATING
C1858 a_17058_50296# VSS 9.81225f $ **FLOATING
C1859 a_62978_57852# VSS 16.3887f $ **FLOATING
C1860 a_67078_63516# VSS 12.1446f $ **FLOATING
C1861 a_34614_64642# VSS 5.10168f $ **FLOATING
C1862 a_26214_64642# VSS 9.33535f $ **FLOATING
C1863 a_22014_64642# VSS 16.5225f $ **FLOATING
C1864 a_19914_64642# VSS 43.9107f $ **FLOATING
C1865 a_16558_64692# VSS 2.88389f $ **FLOATING
C1866 a_16310_64692# VSS 9.72397f $ **FLOATING
C1867 a_17058_64484# VSS 9.83105f $ **FLOATING
C1868 a_89378_81648# VSS 4.53886f $ **FLOATING
C1869 a_88750_81648# VSS 3.65994f $ **FLOATING
C1870 a_88122_81648# VSS 5.91238f $ **FLOATING
C1871 a_85942_81648# VSS 5.03265f $ **FLOATING
C1872 a_62266_82612# VSS 9.00621f $ **FLOATING
C1873 a_34614_80658# VSS 5.10168f $ **FLOATING
C1874 a_26214_80658# VSS 9.33535f $ **FLOATING
C1875 a_22014_80658# VSS 16.5225f $ **FLOATING
C1876 a_19914_80658# VSS 43.9107f $ **FLOATING
C1877 a_16558_80708# VSS 2.88389f $ **FLOATING
C1878 a_16310_80708# VSS 9.72397f $ **FLOATING
C1879 a_92184_87964# VSS 0.1558f $ **FLOATING
C1880 a_91556_87964# VSS 0.36469f $ **FLOATING
C1881 a_88370_81648# VSS 4.58516f $ **FLOATING
C1882 a_87742_81298# VSS 7.3269f $ **FLOATING
C1883 a_86480_87964# VSS 4.47429f $ **FLOATING
C1884 VMEM_3 VSS 34.5849f $ **FLOATING
C1885 a_17058_80500# VSS 9.84074f $ **FLOATING
C1886 a_62978_88056# VSS 16.3733f $ **FLOATING
C1887 a_67078_93720# VSS 12.1229f $ **FLOATING
C1888 a_34614_94846# VSS 5.10168f $ **FLOATING
C1889 a_26214_94846# VSS 9.33535f $ **FLOATING
C1890 a_22014_94846# VSS 16.5225f $ **FLOATING
C1891 a_19914_94846# VSS 43.9107f $ **FLOATING
C1892 a_16558_94896# VSS 2.88389f $ **FLOATING
C1893 a_16310_94896# VSS 9.72397f $ **FLOATING
C1894 a_17058_94688# VSS 9.83265f $ **FLOATING
C1895 a_89378_111852# VSS 4.53886f $ **FLOATING
C1896 a_88750_111852# VSS 3.65994f $ **FLOATING
C1897 a_88122_111852# VSS 5.91238f $ **FLOATING
C1898 a_85942_111852# VSS 5.03265f $ **FLOATING
C1899 a_62266_112816# VSS 8.24327f $ **FLOATING
C1900 a_34614_110862# VSS 5.10168f $ **FLOATING
C1901 a_26214_110862# VSS 9.33535f $ **FLOATING
C1902 a_22014_110862# VSS 16.5225f $ **FLOATING
C1903 a_19914_110862# VSS 43.9107f $ **FLOATING
C1904 a_16558_110912# VSS 2.88389f $ **FLOATING
C1905 a_16310_110912# VSS 9.72397f $ **FLOATING
C1906 a_92184_118168# VSS 0.1558f $ **FLOATING
C1907 a_91556_118168# VSS 0.36469f $ **FLOATING
C1908 a_88370_111852# VSS 4.59356f $ **FLOATING
C1909 a_87742_111502# VSS 7.32871f $ **FLOATING
C1910 a_86480_118168# VSS 4.47168f $ **FLOATING
C1911 VMEM_4 VSS 34.4696f $ **FLOATING
C1912 a_17058_110704# VSS 9.83445f $ **FLOATING
C1913 a_62978_118260# VSS 16.3413f $ **FLOATING
C1914 a_67078_123924# VSS 11.867f $ **FLOATING
C1915 a_34614_125050# VSS 5.10168f $ **FLOATING
C1916 a_26214_125050# VSS 9.33535f $ **FLOATING
C1917 a_22014_125050# VSS 16.5225f $ **FLOATING
C1918 a_19914_125050# VSS 43.9107f $ **FLOATING
C1919 a_16558_125100# VSS 2.88389f $ **FLOATING
C1920 a_16310_125100# VSS 9.72397f $ **FLOATING
C1921 a_17058_124892# VSS 9.87246f $ **FLOATING
C1922 DPI_4__VT VSS 89.3944f $ **FLOATING
C1923 DPI_4__Vthr VSS 92.6866f $ **FLOATING
C1924 bias_0__VT_inh VSS 26.1252f $ **FLOATING
C1925 neuron_4__Vlk VSS 60.1831f $ **FLOATING
C1926 neuron_4__VNA VSS 36.0027f $ **FLOATING
C1927 neuron_4__VKup VSS 44.235f $ **FLOATING
C1928 neuron_4__VIp VSS 44.8429f $ **FLOATING
C1929 neuron_4__Vamp_bias VSS 51.6641f $ **FLOATING
C1930 neuron_4__VK VSS 83.3456f $ **FLOATING
C1931 DAC_7__Vb VSS 0.70925p $ **FLOATING
C1932 neuron_4__VKdn VSS 49.7001f $ **FLOATING
C1933 a_21486_142736# VSS 14.7302f $ **FLOATING
C1934 DAC_7__Isum_e VSS 14.2922f $ **FLOATING
C1935 DAC_6__Isum_e VSS 12.8726f $ **FLOATING
C1936 DAC_5__Isum_e VSS 18.5179f $ **FLOATING
C1937 DAC_5__Isum_i VSS 25.4226f $ **FLOATING
C1938 DAC_3__Isum_e VSS 18.7497f $ **FLOATING
C1939 DAC_3__Isum_i VSS 25.5356f $ **FLOATING
C1940 DAC_1__Isum_e VSS 18.5614f $ **FLOATING
C1941 DAC_1__Isum_i VSS 25.9034f $ **FLOATING
.ends
