* Extracted by KLayout with GF180MCU LVS runset on : 18/11/2026 04:08

.SUBCKT SNN_signed
X$1 spike[3] s[7] \$55 w[29] w[28] VDD w[30] w[31] \$73 \$74 VSS
+ DAC_signed_binary
X$2 \$53 VT \$56 \$57 \$58 \$59 VDD \$54 spike[0] \$63 \$62 VSS neuron_glayout
X$3 \$53 VT \$56 \$57 \$58 \$59 VDD \$72 spike[4] \$63 \$62 VSS neuron_glayout
X$4 \$53 VT \$56 \$57 \$58 \$59 VDD \$64 spike[1] \$63 \$62 VSS neuron_glayout
X$5 \$53 VT \$56 \$57 \$58 \$59 VDD \$69 spike[3] \$63 \$62 VSS neuron_glayout
X$6 \$53 VT \$56 \$57 \$58 \$59 VDD \$66 spike[2] \$63 \$62 VSS neuron_glayout
X$7 spike[2] s[6] \$55 w[25] w[24] VDD w[26] w[27] \$73 \$74 VSS
+ DAC_signed_binary
X$8 spike[0] s[4] \$55 w[17] w[16] VDD w[18] w[19] \$70 \$71 VSS
+ DAC_signed_binary
X$9 spike[0] s[2] \$55 w[9] w[8] VDD w[10] w[11] \$67 \$68 VSS DAC_signed_binary
X$10 spike[1] s[5] \$55 w[21] w[20] VDD w[22] w[23] \$70 \$71 VSS
+ DAC_signed_binary
X$11 spike[1] s[3] \$55 w[13] w[12] VDD w[14] w[15] \$67 \$68 VSS
+ DAC_signed_binary
X$12 pulse[1] s[1] \$55 w[5] w[4] VDD w[6] w[7] \$65 VDD VSS DAC_signed_binary
X$13 pulse[0] s[0] \$55 w[1] w[0] VDD w[2] w[3] \$60 VDD VSS DAC_signed_binary
X$14 \$61 VDD \$60 \$54 \$52 VSS DPI
X$15 \$61 VDD \$68 \$66 \$52 VSS DPI_inh_min
X$16 \$53 \$57 Iref \$63 \$55 \$59 \$56 \$58 VDD \$62 \$61 \$52 \$75 VSS
+ bias_cell
X$17 \$61 VDD \$71 \$69 \$52 VSS DPI_inh_min
X$18 \$61 VDD \$74 \$72 \$52 VSS DPI_inh_min
X$19 \$61 VDD \$65 \$64 \$52 VSS DPI
X$20 \$61 VDD \$67 \$66 \$52 VSS DPI
X$21 \$61 VDD \$70 \$69 \$52 VSS DPI
X$22 \$61 VDD \$73 \$72 \$52 VSS DPI
.ENDS SNN_signed

.SUBCKT bias_cell Vamp_bias VIp Iref VKup Vb Vlk VKdn VK VDD VNA Vthr VT_dpi
+ VT_inh VSS
M$1 VDD VDD VDD VDD pfet_03v3 L=2U W=0.5U AS=0.3P AD=0.14P PS=2.2U PD=1.06U
M$2 VDD VDD VDD VDD pfet_03v3 L=2U W=0.5U AS=0.14P AD=0.14P PS=1.06U PD=1.06U
M$3 VDD VDD VDD VDD pfet_03v3 L=2U W=0.5U AS=0.14P AD=0.14P PS=1.06U PD=1.06U
M$4 VDD VDD VDD VDD pfet_03v3 L=2U W=0.5U AS=0.14P AD=0.14P PS=1.06U PD=1.06U
M$5 VDD VDD VDD VDD pfet_03v3 L=2U W=0.5U AS=0.14P AD=0.14P PS=1.06U PD=1.06U
M$6 VDD VDD VDD VDD pfet_03v3 L=2U W=0.5U AS=0.14P AD=0.14P PS=1.06U PD=1.06U
M$7 VDD VDD VDD VDD pfet_03v3 L=2U W=0.5U AS=0.14P AD=0.14P PS=1.06U PD=1.06U
M$8 VDD VDD VDD VDD pfet_03v3 L=2U W=0.5U AS=0.14P AD=0.14P PS=1.06U PD=1.06U
M$9 VDD VDD VDD VDD pfet_03v3 L=2U W=0.5U AS=0.14P AD=0.14P PS=1.06U PD=1.06U
M$10 VDD VDD VDD VDD pfet_03v3 L=2U W=0.5U AS=0.14P AD=0.14P PS=1.06U PD=1.06U
M$11 VDD VDD VDD VDD pfet_03v3 L=2U W=0.5U AS=0.14P AD=0.14P PS=1.06U PD=1.06U
M$12 VDD VDD VDD VDD pfet_03v3 L=2U W=0.5U AS=0.14P AD=0.14P PS=1.06U PD=1.06U
M$13 VDD VDD VDD VDD pfet_03v3 L=2U W=0.5U AS=0.14P AD=0.14P PS=1.06U PD=1.06U
M$14 VDD VDD VDD VDD pfet_03v3 L=2U W=0.5U AS=0.14P AD=0.14P PS=1.06U PD=1.06U
M$15 VDD VDD VDD VDD pfet_03v3 L=2U W=0.5U AS=0.14P AD=0.14P PS=1.06U PD=1.06U
M$16 VDD VDD VDD VDD pfet_03v3 L=2U W=0.5U AS=0.14P AD=0.14P PS=1.06U PD=1.06U
M$17 VDD VDD VDD VDD pfet_03v3 L=2U W=0.5U AS=0.14P AD=0.14P PS=1.06U PD=1.06U
M$18 VDD VDD VDD VDD pfet_03v3 L=2U W=0.5U AS=0.14P AD=0.14P PS=1.06U PD=1.06U
M$19 VDD VDD VDD VDD pfet_03v3 L=2U W=0.5U AS=0.14P AD=0.14P PS=1.06U PD=1.06U
M$20 VDD VDD VDD VDD pfet_03v3 L=2U W=0.5U AS=0.14P AD=0.14P PS=1.06U PD=1.06U
M$21 VDD VDD VDD VDD pfet_03v3 L=2U W=0.5U AS=0.14P AD=0.14P PS=1.06U PD=1.06U
M$22 VDD VDD VDD VDD pfet_03v3 L=2U W=0.5U AS=0.14P AD=0.14P PS=1.06U PD=1.06U
M$23 VDD VDD VDD VDD pfet_03v3 L=2U W=0.5U AS=0.14P AD=0.14P PS=1.06U PD=1.06U
M$24 VDD VDD VDD VDD pfet_03v3 L=2U W=0.5U AS=0.14P AD=0.14P PS=1.06U PD=1.06U
M$25 VDD VDD VDD VDD pfet_03v3 L=2U W=0.5U AS=0.14P AD=0.14P PS=1.06U PD=1.06U
M$26 VDD VDD VDD VDD pfet_03v3 L=2U W=0.5U AS=0.14P AD=0.14P PS=1.06U PD=1.06U
M$27 VDD VDD VDD VDD pfet_03v3 L=2U W=0.5U AS=0.14P AD=0.14P PS=1.06U PD=1.06U
M$28 VDD VDD VDD VDD pfet_03v3 L=2U W=0.5U AS=0.14P AD=0.14P PS=1.06U PD=1.06U
M$29 VDD VDD VDD VDD pfet_03v3 L=2U W=0.5U AS=0.14P AD=0.14P PS=1.06U PD=1.06U
M$30 VDD VDD VDD VDD pfet_03v3 L=2U W=0.5U AS=0.14P AD=0.14P PS=1.06U PD=1.06U
M$31 VDD VDD VDD VDD pfet_03v3 L=2U W=0.5U AS=0.14P AD=0.14P PS=1.06U PD=1.06U
M$32 VDD VDD VDD VDD pfet_03v3 L=2U W=0.5U AS=0.14P AD=0.14P PS=1.06U PD=1.06U
M$33 VDD VDD VDD VDD pfet_03v3 L=2U W=0.5U AS=0.14P AD=0.14P PS=1.06U PD=1.06U
M$34 VDD VDD VDD VDD pfet_03v3 L=2U W=0.5U AS=0.14P AD=0.14P PS=1.06U PD=1.06U
M$35 VDD VDD VDD VDD pfet_03v3 L=2U W=0.5U AS=0.14P AD=0.14P PS=1.06U PD=1.06U
M$36 VDD VDD VDD VDD pfet_03v3 L=2U W=0.5U AS=0.14P AD=0.14P PS=1.06U PD=1.06U
M$37 VDD VDD VDD VDD pfet_03v3 L=2U W=0.5U AS=0.14P AD=0.14P PS=1.06U PD=1.06U
M$38 VDD VDD VDD VDD pfet_03v3 L=2U W=0.5U AS=0.14P AD=0.14P PS=1.06U PD=1.06U
M$39 VDD VDD VDD VDD pfet_03v3 L=2U W=0.5U AS=0.14P AD=0.14P PS=1.06U PD=1.06U
M$40 VDD VDD VDD VDD pfet_03v3 L=2U W=0.5U AS=0.14P AD=0.14P PS=1.06U PD=1.06U
M$41 VDD VDD VDD VDD pfet_03v3 L=2U W=0.5U AS=0.14P AD=0.14P PS=1.06U PD=1.06U
M$42 VDD VDD VDD VDD pfet_03v3 L=2U W=0.5U AS=0.14P AD=0.14P PS=1.06U PD=1.06U
M$43 VDD VDD VDD VDD pfet_03v3 L=2U W=0.5U AS=0.14P AD=0.14P PS=1.06U PD=1.06U
M$44 VDD VDD VDD VDD pfet_03v3 L=2U W=0.5U AS=0.14P AD=0.14P PS=1.06U PD=1.06U
M$45 VDD VDD VDD VDD pfet_03v3 L=2U W=0.5U AS=0.14P AD=0.14P PS=1.06U PD=1.06U
M$46 VDD VDD VDD VDD pfet_03v3 L=2U W=0.5U AS=0.14P AD=0.14P PS=1.06U PD=1.06U
M$47 VDD VDD VDD VDD pfet_03v3 L=2U W=0.5U AS=0.14P AD=0.14P PS=1.06U PD=1.06U
M$48 VDD VDD VDD VDD pfet_03v3 L=2U W=0.5U AS=0.14P AD=0.14P PS=1.06U PD=1.06U
M$49 VDD VDD VDD VDD pfet_03v3 L=2U W=0.5U AS=0.14P AD=0.14P PS=1.06U PD=1.06U
M$50 VDD VDD VDD VDD pfet_03v3 L=2U W=0.5U AS=0.14P AD=0.14P PS=1.06U PD=1.06U
M$51 VDD VDD VDD VDD pfet_03v3 L=2U W=0.5U AS=0.14P AD=0.14P PS=1.06U PD=1.06U
M$52 VDD VDD VDD VDD pfet_03v3 L=2U W=0.5U AS=0.14P AD=0.14P PS=1.06U PD=1.06U
M$53 VDD VDD VDD VDD pfet_03v3 L=2U W=0.5U AS=0.14P AD=0.14P PS=1.06U PD=1.06U
M$54 VDD VDD VDD VDD pfet_03v3 L=2U W=0.5U AS=0.14P AD=0.14P PS=1.06U PD=1.06U
M$55 VDD VDD VDD VDD pfet_03v3 L=2U W=0.5U AS=0.14P AD=0.14P PS=1.06U PD=1.06U
M$56 VDD VDD VDD VDD pfet_03v3 L=2U W=0.5U AS=0.14P AD=0.14P PS=1.06U PD=1.06U
M$57 VDD VDD VDD VDD pfet_03v3 L=2U W=0.5U AS=0.14P AD=0.14P PS=1.06U PD=1.06U
M$58 VDD VDD VDD VDD pfet_03v3 L=2U W=0.5U AS=0.14P AD=0.14P PS=1.06U PD=1.06U
M$59 VDD VDD VDD VDD pfet_03v3 L=2U W=0.5U AS=0.14P AD=0.14P PS=1.06U PD=1.06U
M$60 VDD VDD VDD VDD pfet_03v3 L=2U W=0.5U AS=0.14P AD=0.14P PS=1.06U PD=1.06U
M$61 VDD VDD VDD VDD pfet_03v3 L=2U W=0.5U AS=0.14P AD=0.14P PS=1.06U PD=1.06U
M$62 VDD VDD VDD VDD pfet_03v3 L=2U W=0.5U AS=0.14P AD=0.14P PS=1.06U PD=1.06U
M$63 VDD VDD VDD VDD pfet_03v3 L=2U W=0.5U AS=0.14P AD=0.14P PS=1.06U PD=1.06U
M$64 VDD VDD VDD VDD pfet_03v3 L=2U W=0.5U AS=0.14P AD=0.14P PS=1.06U PD=1.06U
M$65 VDD VDD VDD VDD pfet_03v3 L=2U W=0.5U AS=0.14P AD=0.14P PS=1.06U PD=1.06U
M$66 VDD VDD VDD VDD pfet_03v3 L=2U W=0.5U AS=0.14P AD=0.14P PS=1.06U PD=1.06U
M$67 VDD VDD VDD VDD pfet_03v3 L=2U W=0.5U AS=0.14P AD=0.14P PS=1.06U PD=1.06U
M$68 VDD VDD VDD VDD pfet_03v3 L=2U W=0.5U AS=0.14P AD=0.14P PS=1.06U PD=1.06U
M$69 VDD VDD VDD VDD pfet_03v3 L=2U W=0.5U AS=0.14P AD=0.14P PS=1.06U PD=1.06U
M$70 VDD VDD VDD VDD pfet_03v3 L=2U W=0.5U AS=0.14P AD=0.14P PS=1.06U PD=1.06U
M$71 VDD VDD VDD VDD pfet_03v3 L=2U W=0.5U AS=0.14P AD=0.14P PS=1.06U PD=1.06U
M$72 VDD VDD VDD VDD pfet_03v3 L=2U W=0.5U AS=0.14P AD=0.14P PS=1.06U PD=1.06U
M$73 VDD VDD VDD VDD pfet_03v3 L=2U W=0.5U AS=0.14P AD=0.14P PS=1.06U PD=1.06U
M$74 VDD VDD VDD VDD pfet_03v3 L=2U W=0.5U AS=0.14P AD=0.14P PS=1.06U PD=1.06U
M$75 VDD VDD VDD VDD pfet_03v3 L=2U W=0.5U AS=0.14P AD=0.14P PS=1.06U PD=1.06U
M$76 VDD VDD VDD VDD pfet_03v3 L=2U W=0.5U AS=0.14P AD=0.14P PS=1.06U PD=1.06U
M$77 VDD VDD VDD VDD pfet_03v3 L=2U W=0.5U AS=0.14P AD=0.14P PS=1.06U PD=1.06U
M$78 VDD VDD VDD VDD pfet_03v3 L=2U W=0.5U AS=0.14P AD=0.14P PS=1.06U PD=1.06U
M$79 VDD VDD VDD VDD pfet_03v3 L=2U W=0.5U AS=0.14P AD=0.14P PS=1.06U PD=1.06U
M$80 VDD VDD VDD VDD pfet_03v3 L=2U W=0.5U AS=0.14P AD=0.14P PS=1.06U PD=1.06U
M$81 VDD VDD VDD VDD pfet_03v3 L=2U W=0.5U AS=0.14P AD=0.14P PS=1.06U PD=1.06U
M$82 VDD VDD VDD VDD pfet_03v3 L=2U W=0.5U AS=0.14P AD=0.14P PS=1.06U PD=1.06U
M$83 VDD VDD VDD VDD pfet_03v3 L=2U W=0.5U AS=0.14P AD=0.14P PS=1.06U PD=1.06U
M$84 VDD VDD VDD VDD pfet_03v3 L=2U W=0.5U AS=0.14P AD=0.14P PS=1.06U PD=1.06U
M$85 VDD VDD VDD VDD pfet_03v3 L=2U W=0.5U AS=0.14P AD=0.14P PS=1.06U PD=1.06U
M$86 VDD VDD VDD VDD pfet_03v3 L=2U W=0.5U AS=0.14P AD=0.14P PS=1.06U PD=1.06U
M$87 VDD VDD VDD VDD pfet_03v3 L=2U W=0.5U AS=0.14P AD=0.14P PS=1.06U PD=1.06U
M$88 VDD VDD VDD VDD pfet_03v3 L=2U W=0.5U AS=0.14P AD=0.14P PS=1.06U PD=1.06U
M$89 VDD VDD VDD VDD pfet_03v3 L=2U W=0.5U AS=0.14P AD=0.14P PS=1.06U PD=1.06U
M$90 VDD VDD VDD VDD pfet_03v3 L=2U W=0.5U AS=0.14P AD=0.14P PS=1.06U PD=1.06U
M$91 VDD VDD VDD VDD pfet_03v3 L=2U W=0.5U AS=0.14P AD=0.14P PS=1.06U PD=1.06U
M$92 VDD VDD VDD VDD pfet_03v3 L=2U W=0.5U AS=0.14P AD=0.14P PS=1.06U PD=1.06U
M$93 VDD VDD VDD VDD pfet_03v3 L=2U W=0.5U AS=0.14P AD=0.14P PS=1.06U PD=1.06U
M$94 VDD VDD VDD VDD pfet_03v3 L=2U W=0.5U AS=0.14P AD=0.14P PS=1.06U PD=1.06U
M$95 VDD VDD VDD VDD pfet_03v3 L=2U W=0.5U AS=0.14P AD=0.14P PS=1.06U PD=1.06U
M$96 VDD VDD VDD VDD pfet_03v3 L=2U W=0.5U AS=0.14P AD=0.14P PS=1.06U PD=1.06U
M$97 VDD VDD VDD VDD pfet_03v3 L=2U W=0.5U AS=0.14P AD=0.14P PS=1.06U PD=1.06U
M$98 VDD VDD VDD VDD pfet_03v3 L=2U W=0.5U AS=0.14P AD=0.14P PS=1.06U PD=1.06U
M$99 VDD VDD VDD VDD pfet_03v3 L=2U W=0.5U AS=0.14P AD=0.14P PS=1.06U PD=1.06U
M$100 VDD VDD VDD VDD pfet_03v3 L=2U W=0.5U AS=0.14P AD=0.3P PS=1.06U PD=2.2U
M$101 VDD VDD VDD VDD pfet_03v3 L=2U W=12.94U AS=7.764P AD=7.764P PS=27.08U
+ PD=27.08U
M$102 VDD VDD VDD VDD pfet_03v3 L=2U W=0.5U AS=0.3P AD=0.14P PS=2.2U PD=1.06U
M$103 VDD VDD VDD VDD pfet_03v3 L=2U W=0.5U AS=0.14P AD=0.14P PS=1.06U PD=1.06U
M$104 VDD VDD VDD VDD pfet_03v3 L=2U W=0.5U AS=0.14P AD=0.14P PS=1.06U PD=1.06U
M$105 VDD VDD VDD VDD pfet_03v3 L=2U W=0.5U AS=0.14P AD=0.14P PS=1.06U PD=1.06U
M$106 VDD VDD VDD VDD pfet_03v3 L=2U W=0.5U AS=0.14P AD=0.14P PS=1.06U PD=1.06U
M$107 VDD VDD VDD VDD pfet_03v3 L=2U W=0.5U AS=0.14P AD=0.14P PS=1.06U PD=1.06U
M$108 VDD VDD VDD VDD pfet_03v3 L=2U W=0.5U AS=0.14P AD=0.14P PS=1.06U PD=1.06U
M$109 VDD VDD VDD VDD pfet_03v3 L=2U W=0.5U AS=0.14P AD=0.14P PS=1.06U PD=1.06U
M$110 VDD VDD VDD VDD pfet_03v3 L=2U W=0.5U AS=0.14P AD=0.14P PS=1.06U PD=1.06U
M$111 VDD VDD VDD VDD pfet_03v3 L=2U W=0.5U AS=0.14P AD=0.14P PS=1.06U PD=1.06U
M$112 VDD VDD VDD VDD pfet_03v3 L=2U W=0.5U AS=0.14P AD=0.14P PS=1.06U PD=1.06U
M$113 VDD VDD VDD VDD pfet_03v3 L=2U W=0.5U AS=0.14P AD=0.14P PS=1.06U PD=1.06U
M$114 VDD VDD VDD VDD pfet_03v3 L=2U W=0.5U AS=0.14P AD=0.14P PS=1.06U PD=1.06U
M$115 VDD VDD VDD VDD pfet_03v3 L=2U W=0.5U AS=0.14P AD=0.14P PS=1.06U PD=1.06U
M$116 VDD VDD VDD VDD pfet_03v3 L=2U W=0.5U AS=0.14P AD=0.14P PS=1.06U PD=1.06U
M$117 VDD VDD VDD VDD pfet_03v3 L=2U W=0.5U AS=0.14P AD=0.14P PS=1.06U PD=1.06U
M$118 VDD VDD VDD VDD pfet_03v3 L=2U W=0.5U AS=0.14P AD=0.14P PS=1.06U PD=1.06U
M$119 VDD VDD VDD VDD pfet_03v3 L=2U W=0.5U AS=0.14P AD=0.14P PS=1.06U PD=1.06U
M$120 VDD VDD VDD VDD pfet_03v3 L=2U W=0.5U AS=0.14P AD=0.14P PS=1.06U PD=1.06U
M$121 VDD VDD VDD VDD pfet_03v3 L=2U W=0.5U AS=0.14P AD=0.14P PS=1.06U PD=1.06U
M$122 VDD VDD VDD VDD pfet_03v3 L=2U W=0.5U AS=0.14P AD=0.14P PS=1.06U PD=1.06U
M$123 VDD VDD VDD VDD pfet_03v3 L=2U W=0.5U AS=0.14P AD=0.14P PS=1.06U PD=1.06U
M$124 VDD VDD VDD VDD pfet_03v3 L=2U W=0.5U AS=0.14P AD=0.14P PS=1.06U PD=1.06U
M$125 VDD VDD VDD VDD pfet_03v3 L=2U W=0.5U AS=0.14P AD=0.14P PS=1.06U PD=1.06U
M$126 VDD VDD VDD VDD pfet_03v3 L=2U W=0.5U AS=0.14P AD=0.14P PS=1.06U PD=1.06U
M$127 VDD VDD VDD VDD pfet_03v3 L=2U W=0.5U AS=0.14P AD=0.14P PS=1.06U PD=1.06U
M$128 VDD VDD VDD VDD pfet_03v3 L=2U W=0.5U AS=0.14P AD=0.14P PS=1.06U PD=1.06U
M$129 VDD VDD VDD VDD pfet_03v3 L=2U W=0.5U AS=0.14P AD=0.14P PS=1.06U PD=1.06U
M$130 VDD VDD VDD VDD pfet_03v3 L=2U W=0.5U AS=0.14P AD=0.14P PS=1.06U PD=1.06U
M$131 VDD VDD VDD VDD pfet_03v3 L=2U W=0.5U AS=0.14P AD=0.14P PS=1.06U PD=1.06U
M$132 VDD VDD VDD VDD pfet_03v3 L=2U W=0.5U AS=0.14P AD=0.14P PS=1.06U PD=1.06U
M$133 VDD VDD VDD VDD pfet_03v3 L=2U W=0.5U AS=0.14P AD=0.14P PS=1.06U PD=1.06U
M$134 VDD VDD VDD VDD pfet_03v3 L=2U W=0.5U AS=0.14P AD=0.14P PS=1.06U PD=1.06U
M$135 VDD VDD VDD VDD pfet_03v3 L=2U W=0.5U AS=0.14P AD=0.14P PS=1.06U PD=1.06U
M$136 VDD VDD VDD VDD pfet_03v3 L=2U W=0.5U AS=0.14P AD=0.14P PS=1.06U PD=1.06U
M$137 VDD VDD VDD VDD pfet_03v3 L=2U W=0.5U AS=0.14P AD=0.14P PS=1.06U PD=1.06U
M$138 VDD VDD VDD VDD pfet_03v3 L=2U W=0.5U AS=0.14P AD=0.14P PS=1.06U PD=1.06U
M$139 VDD VDD VDD VDD pfet_03v3 L=2U W=0.5U AS=0.14P AD=0.14P PS=1.06U PD=1.06U
M$140 VDD VDD VDD VDD pfet_03v3 L=2U W=0.5U AS=0.14P AD=0.14P PS=1.06U PD=1.06U
M$141 VDD VDD VDD VDD pfet_03v3 L=2U W=0.5U AS=0.14P AD=0.14P PS=1.06U PD=1.06U
M$142 VDD VDD VDD VDD pfet_03v3 L=2U W=0.5U AS=0.14P AD=0.14P PS=1.06U PD=1.06U
M$143 VDD VDD VDD VDD pfet_03v3 L=2U W=0.5U AS=0.14P AD=0.14P PS=1.06U PD=1.06U
M$144 VDD VDD VDD VDD pfet_03v3 L=2U W=0.5U AS=0.14P AD=0.14P PS=1.06U PD=1.06U
M$145 VDD VDD VDD VDD pfet_03v3 L=2U W=0.5U AS=0.14P AD=0.14P PS=1.06U PD=1.06U
M$146 VDD VDD VDD VDD pfet_03v3 L=2U W=0.5U AS=0.14P AD=0.14P PS=1.06U PD=1.06U
M$147 VDD VDD VDD VDD pfet_03v3 L=2U W=0.5U AS=0.14P AD=0.14P PS=1.06U PD=1.06U
M$148 VDD VDD VDD VDD pfet_03v3 L=2U W=0.5U AS=0.14P AD=0.14P PS=1.06U PD=1.06U
M$149 VDD VDD VDD VDD pfet_03v3 L=2U W=0.5U AS=0.14P AD=0.14P PS=1.06U PD=1.06U
M$150 VDD VDD VDD VDD pfet_03v3 L=2U W=0.5U AS=0.14P AD=0.14P PS=1.06U PD=1.06U
M$151 VDD VDD VDD VDD pfet_03v3 L=2U W=0.5U AS=0.14P AD=0.14P PS=1.06U PD=1.06U
M$152 VDD VDD VDD VDD pfet_03v3 L=2U W=0.5U AS=0.14P AD=0.14P PS=1.06U PD=1.06U
M$153 VDD VDD VDD VDD pfet_03v3 L=2U W=0.5U AS=0.14P AD=0.14P PS=1.06U PD=1.06U
M$154 VDD VDD VDD VDD pfet_03v3 L=2U W=0.5U AS=0.14P AD=0.14P PS=1.06U PD=1.06U
M$155 VDD VDD VDD VDD pfet_03v3 L=2U W=0.5U AS=0.14P AD=0.14P PS=1.06U PD=1.06U
M$156 VDD VDD VDD VDD pfet_03v3 L=2U W=0.5U AS=0.14P AD=0.14P PS=1.06U PD=1.06U
M$157 VDD VDD VDD VDD pfet_03v3 L=2U W=0.5U AS=0.14P AD=0.14P PS=1.06U PD=1.06U
M$158 VDD VDD VDD VDD pfet_03v3 L=2U W=0.5U AS=0.14P AD=0.14P PS=1.06U PD=1.06U
M$159 VDD VDD VDD VDD pfet_03v3 L=2U W=0.5U AS=0.14P AD=0.14P PS=1.06U PD=1.06U
M$160 VDD VDD VDD VDD pfet_03v3 L=2U W=0.5U AS=0.14P AD=0.14P PS=1.06U PD=1.06U
M$161 VDD VDD VDD VDD pfet_03v3 L=2U W=0.5U AS=0.14P AD=0.14P PS=1.06U PD=1.06U
M$162 VDD VDD VDD VDD pfet_03v3 L=2U W=0.5U AS=0.14P AD=0.14P PS=1.06U PD=1.06U
M$163 VDD VDD VDD VDD pfet_03v3 L=2U W=0.5U AS=0.14P AD=0.14P PS=1.06U PD=1.06U
M$164 VDD VDD VDD VDD pfet_03v3 L=2U W=0.5U AS=0.14P AD=0.14P PS=1.06U PD=1.06U
M$165 VDD VDD VDD VDD pfet_03v3 L=2U W=0.5U AS=0.14P AD=0.14P PS=1.06U PD=1.06U
M$166 VDD VDD VDD VDD pfet_03v3 L=2U W=0.5U AS=0.14P AD=0.14P PS=1.06U PD=1.06U
M$167 VDD VDD VDD VDD pfet_03v3 L=2U W=0.5U AS=0.14P AD=0.14P PS=1.06U PD=1.06U
M$168 VDD VDD VDD VDD pfet_03v3 L=2U W=0.5U AS=0.14P AD=0.14P PS=1.06U PD=1.06U
M$169 VDD VDD VDD VDD pfet_03v3 L=2U W=0.5U AS=0.14P AD=0.14P PS=1.06U PD=1.06U
M$170 VDD VDD VDD VDD pfet_03v3 L=2U W=0.5U AS=0.14P AD=0.14P PS=1.06U PD=1.06U
M$171 VDD VDD VDD VDD pfet_03v3 L=2U W=0.5U AS=0.14P AD=0.14P PS=1.06U PD=1.06U
M$172 VDD VDD VDD VDD pfet_03v3 L=2U W=0.5U AS=0.14P AD=0.14P PS=1.06U PD=1.06U
M$173 VDD VDD VDD VDD pfet_03v3 L=2U W=0.5U AS=0.14P AD=0.14P PS=1.06U PD=1.06U
M$174 VDD VDD VDD VDD pfet_03v3 L=2U W=0.5U AS=0.14P AD=0.14P PS=1.06U PD=1.06U
M$175 VDD VDD VDD VDD pfet_03v3 L=2U W=0.5U AS=0.14P AD=0.14P PS=1.06U PD=1.06U
M$176 VDD VDD VDD VDD pfet_03v3 L=2U W=0.5U AS=0.14P AD=0.14P PS=1.06U PD=1.06U
M$177 VDD VDD VDD VDD pfet_03v3 L=2U W=0.5U AS=0.14P AD=0.14P PS=1.06U PD=1.06U
M$178 VDD VDD VDD VDD pfet_03v3 L=2U W=0.5U AS=0.14P AD=0.14P PS=1.06U PD=1.06U
M$179 VDD VDD VDD VDD pfet_03v3 L=2U W=0.5U AS=0.14P AD=0.14P PS=1.06U PD=1.06U
M$180 VDD VDD VDD VDD pfet_03v3 L=2U W=0.5U AS=0.14P AD=0.14P PS=1.06U PD=1.06U
M$181 VDD VDD VDD VDD pfet_03v3 L=2U W=0.5U AS=0.14P AD=0.14P PS=1.06U PD=1.06U
M$182 VDD VDD VDD VDD pfet_03v3 L=2U W=0.5U AS=0.14P AD=0.14P PS=1.06U PD=1.06U
M$183 VDD VDD VDD VDD pfet_03v3 L=2U W=0.5U AS=0.14P AD=0.14P PS=1.06U PD=1.06U
M$184 VDD VDD VDD VDD pfet_03v3 L=2U W=0.5U AS=0.14P AD=0.14P PS=1.06U PD=1.06U
M$185 VDD VDD VDD VDD pfet_03v3 L=2U W=0.5U AS=0.14P AD=0.14P PS=1.06U PD=1.06U
M$186 VDD VDD VDD VDD pfet_03v3 L=2U W=0.5U AS=0.14P AD=0.14P PS=1.06U PD=1.06U
M$187 VDD VDD VDD VDD pfet_03v3 L=2U W=0.5U AS=0.14P AD=0.14P PS=1.06U PD=1.06U
M$188 VDD VDD VDD VDD pfet_03v3 L=2U W=0.5U AS=0.14P AD=0.14P PS=1.06U PD=1.06U
M$189 VDD VDD VDD VDD pfet_03v3 L=2U W=0.5U AS=0.14P AD=0.14P PS=1.06U PD=1.06U
M$190 VDD VDD VDD VDD pfet_03v3 L=2U W=0.5U AS=0.14P AD=0.14P PS=1.06U PD=1.06U
M$191 VDD VDD VDD VDD pfet_03v3 L=2U W=0.5U AS=0.14P AD=0.14P PS=1.06U PD=1.06U
M$192 VDD VDD VDD VDD pfet_03v3 L=2U W=0.5U AS=0.14P AD=0.14P PS=1.06U PD=1.06U
M$193 VDD VDD VDD VDD pfet_03v3 L=2U W=0.5U AS=0.14P AD=0.14P PS=1.06U PD=1.06U
M$194 VDD VDD VDD VDD pfet_03v3 L=2U W=0.5U AS=0.14P AD=0.14P PS=1.06U PD=1.06U
M$195 VDD VDD VDD VDD pfet_03v3 L=2U W=0.5U AS=0.14P AD=0.14P PS=1.06U PD=1.06U
M$196 VDD VDD VDD VDD pfet_03v3 L=2U W=0.5U AS=0.14P AD=0.14P PS=1.06U PD=1.06U
M$197 VDD VDD VDD VDD pfet_03v3 L=2U W=0.5U AS=0.14P AD=0.14P PS=1.06U PD=1.06U
M$198 VDD VDD VDD VDD pfet_03v3 L=2U W=0.5U AS=0.14P AD=0.14P PS=1.06U PD=1.06U
M$199 VDD VDD VDD VDD pfet_03v3 L=2U W=0.5U AS=0.14P AD=0.14P PS=1.06U PD=1.06U
M$200 VDD VDD VDD VDD pfet_03v3 L=2U W=0.5U AS=0.14P AD=0.14P PS=1.06U PD=1.06U
M$201 VDD VDD VDD VDD pfet_03v3 L=2U W=0.5U AS=0.14P AD=0.3P PS=1.06U PD=2.2U
M$202 VDD \$62 Vb VDD pfet_03v3 L=8U W=1.44U AS=0.864P AD=0.864P PS=4.08U
+ PD=4.08U
M$203 VDD \$62 VKdn VDD pfet_03v3 L=8U W=12.94U AS=7.764P AD=7.764P PS=27.08U
+ PD=27.08U
M$204 VDD \$62 \$62 VDD pfet_03v3 L=8U W=10U AS=6P AD=6P PS=21.2U PD=21.2U
M$205 VDD \$62 VIp VDD pfet_03v3 L=8U W=2.34U AS=1.404P AD=1.404P PS=5.88U
+ PD=5.88U
M$206 VDD \$62 Vamp_bias VDD pfet_03v3 L=8U W=9.14U AS=5.484P AD=5.484P
+ PS=19.48U PD=19.48U
M$207 VDD \$62 VK VDD pfet_03v3 L=8U W=10.45U AS=6.27P AD=6.27P PS=22.1U
+ PD=22.1U
M$208 VDD \$62 Vlk VDD pfet_03v3 L=16U W=0.84U AS=0.504P AD=0.504P PS=2.88U
+ PD=2.88U
M$209 VDD VNA VNA VDD pfet_03v3 L=45.45U W=0.5U AS=0.3P AD=0.3P PS=2.2U PD=2.2U
M$210 VDD VKup VKup VDD pfet_03v3 L=8U W=1U AS=0.6P AD=0.6P PS=3.2U PD=3.2U
M$211 Vthr Vthr VDD VDD pfet_03v3 L=0.64U W=0.5U AS=0.3P AD=0.14P PS=2.2U
+ PD=1.06U
M$212 VDD Vthr Vthr VDD pfet_03v3 L=0.64U W=0.5U AS=0.14P AD=0.14P PS=1.06U
+ PD=1.06U
M$213 Vthr Vthr VDD VDD pfet_03v3 L=0.64U W=0.5U AS=0.14P AD=0.14P PS=1.06U
+ PD=1.06U
M$214 VDD Vthr Vthr VDD pfet_03v3 L=0.64U W=0.5U AS=0.14P AD=0.14P PS=1.06U
+ PD=1.06U
M$215 Vthr Vthr VDD VDD pfet_03v3 L=0.64U W=0.5U AS=0.14P AD=0.14P PS=1.06U
+ PD=1.06U
M$216 VDD Vthr Vthr VDD pfet_03v3 L=0.64U W=0.5U AS=0.14P AD=0.14P PS=1.06U
+ PD=1.06U
M$217 Vthr Vthr VDD VDD pfet_03v3 L=0.64U W=0.5U AS=0.14P AD=0.14P PS=1.06U
+ PD=1.06U
M$218 VDD Vthr Vthr VDD pfet_03v3 L=0.64U W=0.5U AS=0.14P AD=0.14P PS=1.06U
+ PD=1.06U
M$219 Vthr Vthr VDD VDD pfet_03v3 L=0.64U W=0.5U AS=0.14P AD=0.14P PS=1.06U
+ PD=1.06U
M$220 VDD Vthr Vthr VDD pfet_03v3 L=0.64U W=0.5U AS=0.14P AD=0.14P PS=1.06U
+ PD=1.06U
M$221 Vthr Vthr VDD VDD pfet_03v3 L=0.64U W=0.5U AS=0.14P AD=0.14P PS=1.06U
+ PD=1.06U
M$222 VDD Vthr Vthr VDD pfet_03v3 L=0.64U W=0.5U AS=0.14P AD=0.14P PS=1.06U
+ PD=1.06U
M$223 Vthr Vthr VDD VDD pfet_03v3 L=0.64U W=0.5U AS=0.14P AD=0.14P PS=1.06U
+ PD=1.06U
M$224 VDD Vthr Vthr VDD pfet_03v3 L=0.64U W=0.5U AS=0.14P AD=0.14P PS=1.06U
+ PD=1.06U
M$225 Vthr Vthr VDD VDD pfet_03v3 L=0.64U W=0.5U AS=0.14P AD=0.14P PS=1.06U
+ PD=1.06U
M$226 VDD Vthr Vthr VDD pfet_03v3 L=0.64U W=0.5U AS=0.14P AD=0.14P PS=1.06U
+ PD=1.06U
M$227 Vthr Vthr VDD VDD pfet_03v3 L=0.64U W=0.5U AS=0.14P AD=0.14P PS=1.06U
+ PD=1.06U
M$228 VDD Vthr Vthr VDD pfet_03v3 L=0.64U W=0.5U AS=0.14P AD=0.14P PS=1.06U
+ PD=1.06U
M$229 Vthr Vthr VDD VDD pfet_03v3 L=0.64U W=0.5U AS=0.14P AD=0.14P PS=1.06U
+ PD=1.06U
M$230 VDD Vthr Vthr VDD pfet_03v3 L=0.64U W=0.5U AS=0.14P AD=0.14P PS=1.06U
+ PD=1.06U
M$231 Vthr Vthr VDD VDD pfet_03v3 L=0.64U W=0.5U AS=0.14P AD=0.14P PS=1.06U
+ PD=1.06U
M$232 VDD Vthr Vthr VDD pfet_03v3 L=0.64U W=0.5U AS=0.14P AD=0.14P PS=1.06U
+ PD=1.06U
M$233 Vthr Vthr VDD VDD pfet_03v3 L=0.64U W=0.5U AS=0.14P AD=0.14P PS=1.06U
+ PD=1.06U
M$234 VDD Vthr Vthr VDD pfet_03v3 L=0.64U W=0.5U AS=0.14P AD=0.14P PS=1.06U
+ PD=1.06U
M$235 Vthr Vthr VDD VDD pfet_03v3 L=0.64U W=0.5U AS=0.14P AD=0.14P PS=1.06U
+ PD=1.06U
M$236 VDD Vthr Vthr VDD pfet_03v3 L=0.64U W=0.5U AS=0.14P AD=0.14P PS=1.06U
+ PD=1.06U
M$237 Vthr Vthr VDD VDD pfet_03v3 L=0.64U W=0.5U AS=0.14P AD=0.14P PS=1.06U
+ PD=1.06U
M$238 VDD Vthr Vthr VDD pfet_03v3 L=0.64U W=0.5U AS=0.14P AD=0.14P PS=1.06U
+ PD=1.06U
M$239 Vthr Vthr VDD VDD pfet_03v3 L=0.64U W=0.5U AS=0.14P AD=0.14P PS=1.06U
+ PD=1.06U
M$240 VDD Vthr Vthr VDD pfet_03v3 L=0.64U W=0.5U AS=0.14P AD=0.14P PS=1.06U
+ PD=1.06U
M$241 Vthr Vthr VDD VDD pfet_03v3 L=0.64U W=0.5U AS=0.14P AD=0.14P PS=1.06U
+ PD=1.06U
M$242 VDD Vthr Vthr VDD pfet_03v3 L=0.64U W=0.5U AS=0.14P AD=0.3P PS=1.06U
+ PD=2.2U
M$243 VT_dpi VT_dpi VDD VDD pfet_03v3 L=0.64U W=0.5U AS=0.3P AD=0.14P PS=2.2U
+ PD=1.06U
M$244 VDD VT_dpi VT_dpi VDD pfet_03v3 L=0.64U W=0.5U AS=0.14P AD=0.14P PS=1.06U
+ PD=1.06U
M$245 VT_dpi VT_dpi VDD VDD pfet_03v3 L=0.64U W=0.5U AS=0.14P AD=0.14P PS=1.06U
+ PD=1.06U
M$246 VDD VT_dpi VT_dpi VDD pfet_03v3 L=0.64U W=0.5U AS=0.14P AD=0.14P PS=1.06U
+ PD=1.06U
M$247 VT_dpi VT_dpi VDD VDD pfet_03v3 L=0.64U W=0.5U AS=0.14P AD=0.14P PS=1.06U
+ PD=1.06U
M$248 VDD VT_dpi VT_dpi VDD pfet_03v3 L=0.64U W=0.5U AS=0.14P AD=0.14P PS=1.06U
+ PD=1.06U
M$249 VT_dpi VT_dpi VDD VDD pfet_03v3 L=0.64U W=0.5U AS=0.14P AD=0.14P PS=1.06U
+ PD=1.06U
M$250 VDD VT_dpi VT_dpi VDD pfet_03v3 L=0.64U W=0.5U AS=0.14P AD=0.14P PS=1.06U
+ PD=1.06U
M$251 VT_dpi VT_dpi VDD VDD pfet_03v3 L=0.64U W=0.5U AS=0.14P AD=0.14P PS=1.06U
+ PD=1.06U
M$252 VDD VT_dpi VT_dpi VDD pfet_03v3 L=0.64U W=0.5U AS=0.14P AD=0.14P PS=1.06U
+ PD=1.06U
M$253 VT_dpi VT_dpi VDD VDD pfet_03v3 L=0.64U W=0.5U AS=0.14P AD=0.14P PS=1.06U
+ PD=1.06U
M$254 VDD VT_dpi VT_dpi VDD pfet_03v3 L=0.64U W=0.5U AS=0.14P AD=0.14P PS=1.06U
+ PD=1.06U
M$255 VT_dpi VT_dpi VDD VDD pfet_03v3 L=0.64U W=0.5U AS=0.14P AD=0.14P PS=1.06U
+ PD=1.06U
M$256 VDD VT_dpi VT_dpi VDD pfet_03v3 L=0.64U W=0.5U AS=0.14P AD=0.14P PS=1.06U
+ PD=1.06U
M$257 VT_dpi VT_dpi VDD VDD pfet_03v3 L=0.64U W=0.5U AS=0.14P AD=0.14P PS=1.06U
+ PD=1.06U
M$258 VDD VT_dpi VT_dpi VDD pfet_03v3 L=0.64U W=0.5U AS=0.14P AD=0.14P PS=1.06U
+ PD=1.06U
M$259 VT_dpi VT_dpi VDD VDD pfet_03v3 L=0.64U W=0.5U AS=0.14P AD=0.14P PS=1.06U
+ PD=1.06U
M$260 VDD VT_dpi VT_dpi VDD pfet_03v3 L=0.64U W=0.5U AS=0.14P AD=0.14P PS=1.06U
+ PD=1.06U
M$261 VT_dpi VT_dpi VDD VDD pfet_03v3 L=0.64U W=0.5U AS=0.14P AD=0.14P PS=1.06U
+ PD=1.06U
M$262 VDD VT_dpi VT_dpi VDD pfet_03v3 L=0.64U W=0.5U AS=0.14P AD=0.14P PS=1.06U
+ PD=1.06U
M$263 VT_dpi VT_dpi VDD VDD pfet_03v3 L=0.64U W=0.5U AS=0.14P AD=0.14P PS=1.06U
+ PD=1.06U
M$264 VDD VT_dpi VT_dpi VDD pfet_03v3 L=0.64U W=0.5U AS=0.14P AD=0.14P PS=1.06U
+ PD=1.06U
M$265 VT_dpi VT_dpi VDD VDD pfet_03v3 L=0.64U W=0.5U AS=0.14P AD=0.14P PS=1.06U
+ PD=1.06U
M$266 VDD VT_dpi VT_dpi VDD pfet_03v3 L=0.64U W=0.5U AS=0.14P AD=0.14P PS=1.06U
+ PD=1.06U
M$267 VT_dpi VT_dpi VDD VDD pfet_03v3 L=0.64U W=0.5U AS=0.14P AD=0.14P PS=1.06U
+ PD=1.06U
M$268 VDD VT_dpi VT_dpi VDD pfet_03v3 L=0.64U W=0.5U AS=0.14P AD=0.14P PS=1.06U
+ PD=1.06U
M$269 VT_dpi VT_dpi VDD VDD pfet_03v3 L=0.64U W=0.5U AS=0.14P AD=0.14P PS=1.06U
+ PD=1.06U
M$270 VDD VT_dpi VT_dpi VDD pfet_03v3 L=0.64U W=0.5U AS=0.14P AD=0.14P PS=1.06U
+ PD=1.06U
M$271 VT_dpi VT_dpi VDD VDD pfet_03v3 L=0.64U W=0.5U AS=0.14P AD=0.14P PS=1.06U
+ PD=1.06U
M$272 VDD VT_dpi VT_dpi VDD pfet_03v3 L=0.64U W=0.5U AS=0.14P AD=0.14P PS=1.06U
+ PD=1.06U
M$273 VT_dpi VT_dpi VDD VDD pfet_03v3 L=0.64U W=0.5U AS=0.14P AD=0.14P PS=1.06U
+ PD=1.06U
M$274 VDD VT_dpi VT_dpi VDD pfet_03v3 L=0.64U W=0.5U AS=0.14P AD=0.3P PS=1.06U
+ PD=2.2U
M$275 VT_inh VT_inh VDD VDD pfet_03v3 L=1.12U W=0.88U AS=0.528P AD=0.2464P
+ PS=2.96U PD=1.44U
M$276 VDD VT_inh VT_inh VDD pfet_03v3 L=1.12U W=0.88U AS=0.2464P AD=0.2464P
+ PS=1.44U PD=1.44U
M$277 VT_inh VT_inh VDD VDD pfet_03v3 L=1.12U W=0.88U AS=0.2464P AD=0.2464P
+ PS=1.44U PD=1.44U
M$278 VDD VT_inh VT_inh VDD pfet_03v3 L=1.12U W=0.88U AS=0.2464P AD=0.2464P
+ PS=1.44U PD=1.44U
M$279 VT_inh VT_inh VDD VDD pfet_03v3 L=1.12U W=0.88U AS=0.2464P AD=0.2464P
+ PS=1.44U PD=1.44U
M$280 VDD VT_inh VT_inh VDD pfet_03v3 L=1.12U W=0.88U AS=0.2464P AD=0.2464P
+ PS=1.44U PD=1.44U
M$281 VT_inh VT_inh VDD VDD pfet_03v3 L=1.12U W=0.88U AS=0.2464P AD=0.2464P
+ PS=1.44U PD=1.44U
M$282 VDD VT_inh VT_inh VDD pfet_03v3 L=1.12U W=0.88U AS=0.2464P AD=0.2464P
+ PS=1.44U PD=1.44U
M$283 VT_inh VT_inh VDD VDD pfet_03v3 L=1.12U W=0.88U AS=0.2464P AD=0.2464P
+ PS=1.44U PD=1.44U
M$284 VDD VT_inh VT_inh VDD pfet_03v3 L=1.12U W=0.88U AS=0.2464P AD=0.2464P
+ PS=1.44U PD=1.44U
M$285 VT_inh VT_inh VDD VDD pfet_03v3 L=1.12U W=0.88U AS=0.2464P AD=0.2464P
+ PS=1.44U PD=1.44U
M$286 VDD VT_inh VT_inh VDD pfet_03v3 L=1.12U W=0.88U AS=0.2464P AD=0.2464P
+ PS=1.44U PD=1.44U
M$287 VT_inh VT_inh VDD VDD pfet_03v3 L=1.12U W=0.88U AS=0.2464P AD=0.2464P
+ PS=1.44U PD=1.44U
M$288 VDD VT_inh VT_inh VDD pfet_03v3 L=1.12U W=0.88U AS=0.2464P AD=0.2464P
+ PS=1.44U PD=1.44U
M$289 VT_inh VT_inh VDD VDD pfet_03v3 L=1.12U W=0.88U AS=0.2464P AD=0.2464P
+ PS=1.44U PD=1.44U
M$290 VDD VT_inh VT_inh VDD pfet_03v3 L=1.12U W=0.88U AS=0.2464P AD=0.528P
+ PS=1.44U PD=2.96U
M$291 VDD VDD VDD VDD pfet_03v3 L=2U W=12.94U AS=7.764P AD=7.764P PS=27.08U
+ PD=27.08U
M$292 VSS VSS VSS VSS nfet_03v3 L=2U W=0.5U AS=0.14P AD=0.14P PS=1.06U PD=1.06U
M$293 VSS VSS VSS VSS nfet_03v3 L=2U W=0.5U AS=0.14P AD=0.14P PS=1.06U PD=1.06U
M$294 VSS VSS VSS VSS nfet_03v3 L=2U W=0.5U AS=0.14P AD=0.14P PS=1.06U PD=1.06U
M$295 VSS VSS VSS VSS nfet_03v3 L=2U W=0.5U AS=0.14P AD=0.14P PS=1.06U PD=1.06U
M$296 VSS VSS VSS VSS nfet_03v3 L=2U W=0.5U AS=0.14P AD=0.14P PS=1.06U PD=1.06U
M$297 VSS VSS VSS VSS nfet_03v3 L=2U W=0.5U AS=0.14P AD=0.14P PS=1.06U PD=1.06U
M$298 VSS VSS VSS VSS nfet_03v3 L=2U W=0.5U AS=0.14P AD=0.14P PS=1.06U PD=1.06U
M$299 VSS VSS VSS VSS nfet_03v3 L=2U W=0.5U AS=0.14P AD=0.14P PS=1.06U PD=1.06U
M$300 VSS VSS VSS VSS nfet_03v3 L=2U W=0.5U AS=0.14P AD=0.14P PS=1.06U PD=1.06U
M$301 VSS VSS VSS VSS nfet_03v3 L=2U W=0.5U AS=0.14P AD=0.14P PS=1.06U PD=1.06U
M$302 VSS VSS VSS VSS nfet_03v3 L=2U W=0.5U AS=0.14P AD=0.14P PS=1.06U PD=1.06U
M$303 VSS VSS VSS VSS nfet_03v3 L=2U W=0.5U AS=0.14P AD=0.14P PS=1.06U PD=1.06U
M$304 VSS VSS VSS VSS nfet_03v3 L=2U W=0.5U AS=0.14P AD=0.14P PS=1.06U PD=1.06U
M$305 VSS VSS VSS VSS nfet_03v3 L=2U W=0.5U AS=0.14P AD=0.14P PS=1.06U PD=1.06U
M$306 VSS VSS VSS VSS nfet_03v3 L=2U W=0.5U AS=0.14P AD=0.14P PS=1.06U PD=1.06U
M$307 VSS VSS VSS VSS nfet_03v3 L=2U W=0.5U AS=0.14P AD=0.14P PS=1.06U PD=1.06U
M$308 VSS VSS VSS VSS nfet_03v3 L=2U W=0.5U AS=0.14P AD=0.14P PS=1.06U PD=1.06U
M$309 VSS VSS VSS VSS nfet_03v3 L=2U W=0.5U AS=0.14P AD=0.14P PS=1.06U PD=1.06U
M$310 VSS VSS VSS VSS nfet_03v3 L=2U W=0.5U AS=0.14P AD=0.14P PS=1.06U PD=1.06U
M$311 VSS VSS VSS VSS nfet_03v3 L=2U W=0.5U AS=0.14P AD=0.14P PS=1.06U PD=1.06U
M$312 VSS VSS VSS VSS nfet_03v3 L=2U W=0.5U AS=0.14P AD=0.14P PS=1.06U PD=1.06U
M$313 VSS VSS VSS VSS nfet_03v3 L=2U W=0.5U AS=0.14P AD=0.14P PS=1.06U PD=1.06U
M$314 VSS VSS VSS VSS nfet_03v3 L=2U W=0.5U AS=0.14P AD=0.14P PS=1.06U PD=1.06U
M$315 VSS VSS VSS VSS nfet_03v3 L=2U W=0.5U AS=0.14P AD=0.14P PS=1.06U PD=1.06U
M$316 VSS VSS VSS VSS nfet_03v3 L=2U W=0.5U AS=0.14P AD=0.14P PS=1.06U PD=1.06U
M$317 VSS VSS VSS VSS nfet_03v3 L=2U W=0.5U AS=0.14P AD=0.14P PS=1.06U PD=1.06U
M$318 VSS VSS VSS VSS nfet_03v3 L=2U W=0.5U AS=0.14P AD=0.14P PS=1.06U PD=1.06U
M$319 VSS VSS VSS VSS nfet_03v3 L=2U W=0.5U AS=0.14P AD=0.14P PS=1.06U PD=1.06U
M$320 VSS VSS VSS VSS nfet_03v3 L=2U W=0.5U AS=0.14P AD=0.14P PS=1.06U PD=1.06U
M$321 VSS VSS VSS VSS nfet_03v3 L=2U W=0.5U AS=0.14P AD=0.14P PS=1.06U PD=1.06U
M$322 VSS VSS VSS VSS nfet_03v3 L=2U W=0.5U AS=0.14P AD=0.14P PS=1.06U PD=1.06U
M$323 VSS VSS VSS VSS nfet_03v3 L=2U W=0.5U AS=0.14P AD=0.14P PS=1.06U PD=1.06U
M$324 VSS VSS VSS VSS nfet_03v3 L=2U W=0.5U AS=0.14P AD=0.14P PS=1.06U PD=1.06U
M$325 VSS VSS VSS VSS nfet_03v3 L=2U W=0.5U AS=0.14P AD=0.14P PS=1.06U PD=1.06U
M$326 VSS VSS VSS VSS nfet_03v3 L=2U W=0.5U AS=0.14P AD=0.14P PS=1.06U PD=1.06U
M$327 VSS VSS VSS VSS nfet_03v3 L=2U W=0.5U AS=0.14P AD=0.14P PS=1.06U PD=1.06U
M$328 VSS VSS VSS VSS nfet_03v3 L=2U W=0.5U AS=0.14P AD=0.14P PS=1.06U PD=1.06U
M$329 VSS VSS VSS VSS nfet_03v3 L=2U W=0.5U AS=0.14P AD=0.14P PS=1.06U PD=1.06U
M$330 VSS VSS VSS VSS nfet_03v3 L=2U W=0.5U AS=0.14P AD=0.14P PS=1.06U PD=1.06U
M$331 VSS VSS VSS VSS nfet_03v3 L=2U W=0.5U AS=0.14P AD=0.14P PS=1.06U PD=1.06U
M$332 VSS VSS VSS VSS nfet_03v3 L=2U W=0.5U AS=0.14P AD=0.14P PS=1.06U PD=1.06U
M$333 VSS VSS VSS VSS nfet_03v3 L=2U W=0.5U AS=0.14P AD=0.14P PS=1.06U PD=1.06U
M$334 VSS VSS VSS VSS nfet_03v3 L=2U W=0.5U AS=0.14P AD=0.14P PS=1.06U PD=1.06U
M$335 VSS VSS VSS VSS nfet_03v3 L=2U W=0.5U AS=0.14P AD=0.14P PS=1.06U PD=1.06U
M$336 VSS VSS VSS VSS nfet_03v3 L=2U W=0.5U AS=0.14P AD=0.14P PS=1.06U PD=1.06U
M$337 VSS VSS VSS VSS nfet_03v3 L=2U W=0.5U AS=0.14P AD=0.14P PS=1.06U PD=1.06U
M$338 VSS VSS VSS VSS nfet_03v3 L=2U W=0.5U AS=0.14P AD=0.14P PS=1.06U PD=1.06U
M$339 VSS VSS VSS VSS nfet_03v3 L=2U W=0.5U AS=0.14P AD=0.14P PS=1.06U PD=1.06U
M$340 VSS VSS VSS VSS nfet_03v3 L=2U W=0.5U AS=0.14P AD=0.14P PS=1.06U PD=1.06U
M$341 VSS VSS VSS VSS nfet_03v3 L=2U W=0.5U AS=0.14P AD=0.14P PS=1.06U PD=1.06U
M$342 VSS VSS VSS VSS nfet_03v3 L=2U W=0.5U AS=0.14P AD=0.14P PS=1.06U PD=1.06U
M$343 VSS VSS VSS VSS nfet_03v3 L=2U W=0.5U AS=0.14P AD=0.14P PS=1.06U PD=1.06U
M$344 VSS VSS VSS VSS nfet_03v3 L=2U W=0.5U AS=0.14P AD=0.14P PS=1.06U PD=1.06U
M$345 VSS VSS VSS VSS nfet_03v3 L=2U W=0.5U AS=0.14P AD=0.14P PS=1.06U PD=1.06U
M$346 VSS VSS VSS VSS nfet_03v3 L=2U W=0.5U AS=0.14P AD=0.14P PS=1.06U PD=1.06U
M$347 VSS VSS VSS VSS nfet_03v3 L=2U W=0.5U AS=0.14P AD=0.3P PS=1.06U PD=2.2U
M$348 VSS VSS VSS VSS nfet_03v3 L=2U W=0.5U AS=0.14P AD=0.14P PS=1.06U PD=1.06U
M$349 VSS VSS VSS VSS nfet_03v3 L=2U W=0.5U AS=0.14P AD=0.14P PS=1.06U PD=1.06U
M$350 VSS VSS VSS VSS nfet_03v3 L=2U W=0.5U AS=0.14P AD=0.14P PS=1.06U PD=1.06U
M$351 VSS VSS VSS VSS nfet_03v3 L=2U W=0.5U AS=0.14P AD=0.14P PS=1.06U PD=1.06U
M$352 VSS VSS VSS VSS nfet_03v3 L=2U W=0.5U AS=0.14P AD=0.14P PS=1.06U PD=1.06U
M$353 VSS VSS VSS VSS nfet_03v3 L=2U W=0.5U AS=0.14P AD=0.14P PS=1.06U PD=1.06U
M$354 VSS VSS VSS VSS nfet_03v3 L=2U W=0.5U AS=0.14P AD=0.14P PS=1.06U PD=1.06U
M$355 VSS VSS VSS VSS nfet_03v3 L=2U W=0.5U AS=0.14P AD=0.14P PS=1.06U PD=1.06U
M$356 VSS VSS VSS VSS nfet_03v3 L=2U W=0.5U AS=0.14P AD=0.14P PS=1.06U PD=1.06U
M$357 VSS VSS VSS VSS nfet_03v3 L=2U W=0.5U AS=0.14P AD=0.14P PS=1.06U PD=1.06U
M$358 VSS VSS VSS VSS nfet_03v3 L=2U W=0.5U AS=0.14P AD=0.14P PS=1.06U PD=1.06U
M$359 VSS VSS VSS VSS nfet_03v3 L=2U W=0.5U AS=0.14P AD=0.14P PS=1.06U PD=1.06U
M$360 VSS VSS VSS VSS nfet_03v3 L=2U W=0.5U AS=0.14P AD=0.14P PS=1.06U PD=1.06U
M$361 VSS VSS VSS VSS nfet_03v3 L=2U W=0.5U AS=0.14P AD=0.14P PS=1.06U PD=1.06U
M$362 VSS VSS VSS VSS nfet_03v3 L=2U W=0.5U AS=0.14P AD=0.14P PS=1.06U PD=1.06U
M$363 VSS VSS VSS VSS nfet_03v3 L=2U W=0.5U AS=0.14P AD=0.14P PS=1.06U PD=1.06U
M$364 VSS VSS VSS VSS nfet_03v3 L=2U W=0.5U AS=0.14P AD=0.14P PS=1.06U PD=1.06U
M$365 VSS VSS VSS VSS nfet_03v3 L=2U W=0.5U AS=0.14P AD=0.14P PS=1.06U PD=1.06U
M$366 VSS VSS VSS VSS nfet_03v3 L=2U W=0.5U AS=0.14P AD=0.14P PS=1.06U PD=1.06U
M$367 VSS VSS VSS VSS nfet_03v3 L=2U W=0.5U AS=0.14P AD=0.14P PS=1.06U PD=1.06U
M$368 VSS VSS VSS VSS nfet_03v3 L=2U W=0.5U AS=0.14P AD=0.14P PS=1.06U PD=1.06U
M$369 VSS VSS VSS VSS nfet_03v3 L=2U W=0.5U AS=0.14P AD=0.14P PS=1.06U PD=1.06U
M$370 VSS VSS VSS VSS nfet_03v3 L=2U W=0.5U AS=0.14P AD=0.14P PS=1.06U PD=1.06U
M$371 VSS VSS VSS VSS nfet_03v3 L=2U W=0.5U AS=0.14P AD=0.14P PS=1.06U PD=1.06U
M$372 VSS VSS VSS VSS nfet_03v3 L=2U W=0.5U AS=0.14P AD=0.14P PS=1.06U PD=1.06U
M$373 VSS VSS VSS VSS nfet_03v3 L=2U W=0.5U AS=0.14P AD=0.14P PS=1.06U PD=1.06U
M$374 VSS VSS VSS VSS nfet_03v3 L=2U W=0.5U AS=0.14P AD=0.14P PS=1.06U PD=1.06U
M$375 VSS VSS VSS VSS nfet_03v3 L=2U W=0.5U AS=0.14P AD=0.14P PS=1.06U PD=1.06U
M$376 VSS VSS VSS VSS nfet_03v3 L=2U W=0.5U AS=0.14P AD=0.14P PS=1.06U PD=1.06U
M$377 VSS VSS VSS VSS nfet_03v3 L=2U W=0.5U AS=0.14P AD=0.14P PS=1.06U PD=1.06U
M$378 VSS VSS VSS VSS nfet_03v3 L=2U W=0.5U AS=0.14P AD=0.14P PS=1.06U PD=1.06U
M$379 VSS VSS VSS VSS nfet_03v3 L=2U W=0.5U AS=0.14P AD=0.14P PS=1.06U PD=1.06U
M$380 VSS VSS VSS VSS nfet_03v3 L=2U W=0.5U AS=0.14P AD=0.14P PS=1.06U PD=1.06U
M$381 VSS VSS VSS VSS nfet_03v3 L=2U W=0.5U AS=0.14P AD=0.14P PS=1.06U PD=1.06U
M$382 VSS VSS VSS VSS nfet_03v3 L=2U W=0.5U AS=0.14P AD=0.14P PS=1.06U PD=1.06U
M$383 VSS VSS VSS VSS nfet_03v3 L=2U W=0.5U AS=0.14P AD=0.14P PS=1.06U PD=1.06U
M$384 VSS VSS VSS VSS nfet_03v3 L=2U W=0.5U AS=0.14P AD=0.14P PS=1.06U PD=1.06U
M$385 VSS VSS VSS VSS nfet_03v3 L=2U W=0.5U AS=0.14P AD=0.14P PS=1.06U PD=1.06U
M$386 VSS VSS VSS VSS nfet_03v3 L=2U W=0.5U AS=0.14P AD=0.14P PS=1.06U PD=1.06U
M$387 VSS VSS VSS VSS nfet_03v3 L=2U W=0.5U AS=0.14P AD=0.14P PS=1.06U PD=1.06U
M$388 VSS VSS VSS VSS nfet_03v3 L=2U W=0.5U AS=0.14P AD=0.14P PS=1.06U PD=1.06U
M$389 VSS VSS VSS VSS nfet_03v3 L=2U W=0.5U AS=0.14P AD=0.14P PS=1.06U PD=1.06U
M$390 VSS VSS VSS VSS nfet_03v3 L=2U W=0.5U AS=0.14P AD=0.14P PS=1.06U PD=1.06U
M$391 VSS VSS VSS VSS nfet_03v3 L=2U W=0.5U AS=0.14P AD=0.14P PS=1.06U PD=1.06U
M$392 VSS VSS VSS VSS nfet_03v3 L=2U W=0.5U AS=0.14P AD=0.14P PS=1.06U PD=1.06U
M$393 VSS VSS VSS VSS nfet_03v3 L=2U W=0.5U AS=0.14P AD=0.14P PS=1.06U PD=1.06U
M$394 VSS VSS VSS VSS nfet_03v3 L=2U W=0.5U AS=0.14P AD=0.14P PS=1.06U PD=1.06U
M$395 VSS VSS VSS VSS nfet_03v3 L=2U W=0.5U AS=0.14P AD=0.14P PS=1.06U PD=1.06U
M$396 VSS VSS VSS VSS nfet_03v3 L=2U W=0.5U AS=0.14P AD=0.14P PS=1.06U PD=1.06U
M$397 VSS VSS VSS VSS nfet_03v3 L=2U W=0.5U AS=0.14P AD=0.14P PS=1.06U PD=1.06U
M$398 VSS VSS VSS VSS nfet_03v3 L=2U W=0.5U AS=0.14P AD=0.14P PS=1.06U PD=1.06U
M$399 VSS VSS VSS VSS nfet_03v3 L=2U W=0.5U AS=0.14P AD=0.14P PS=1.06U PD=1.06U
M$400 VSS VSS VSS VSS nfet_03v3 L=2U W=0.5U AS=0.14P AD=0.14P PS=1.06U PD=1.06U
M$401 VSS VSS VSS VSS nfet_03v3 L=2U W=0.5U AS=0.14P AD=0.14P PS=1.06U PD=1.06U
M$402 VSS VSS VSS VSS nfet_03v3 L=2U W=0.5U AS=0.3P AD=0.14P PS=2.2U PD=1.06U
M$403 VSS VSS VSS VSS nfet_03v3 L=2U W=10U AS=6P AD=6P PS=21.2U PD=21.2U
M$404 VSS VSS VSS VSS nfet_03v3 L=2U W=0.5U AS=0.14P AD=0.14P PS=1.06U PD=1.06U
M$405 VSS VSS VSS VSS nfet_03v3 L=2U W=0.5U AS=0.14P AD=0.14P PS=1.06U PD=1.06U
M$406 VSS VSS VSS VSS nfet_03v3 L=2U W=0.5U AS=0.14P AD=0.14P PS=1.06U PD=1.06U
M$407 VSS VSS VSS VSS nfet_03v3 L=2U W=0.5U AS=0.14P AD=0.14P PS=1.06U PD=1.06U
M$408 VSS VSS VSS VSS nfet_03v3 L=2U W=0.5U AS=0.14P AD=0.14P PS=1.06U PD=1.06U
M$409 VSS VSS VSS VSS nfet_03v3 L=2U W=0.5U AS=0.14P AD=0.14P PS=1.06U PD=1.06U
M$410 VSS VSS VSS VSS nfet_03v3 L=2U W=0.5U AS=0.14P AD=0.14P PS=1.06U PD=1.06U
M$411 VSS VSS VSS VSS nfet_03v3 L=2U W=0.5U AS=0.14P AD=0.14P PS=1.06U PD=1.06U
M$412 VSS VSS VSS VSS nfet_03v3 L=2U W=0.5U AS=0.14P AD=0.14P PS=1.06U PD=1.06U
M$413 VSS VSS VSS VSS nfet_03v3 L=2U W=0.5U AS=0.14P AD=0.14P PS=1.06U PD=1.06U
M$414 VSS VSS VSS VSS nfet_03v3 L=2U W=0.5U AS=0.14P AD=0.14P PS=1.06U PD=1.06U
M$415 VSS VSS VSS VSS nfet_03v3 L=2U W=0.5U AS=0.14P AD=0.14P PS=1.06U PD=1.06U
M$416 VSS VSS VSS VSS nfet_03v3 L=2U W=0.5U AS=0.14P AD=0.14P PS=1.06U PD=1.06U
M$417 VSS VSS VSS VSS nfet_03v3 L=2U W=0.5U AS=0.14P AD=0.14P PS=1.06U PD=1.06U
M$418 VSS VSS VSS VSS nfet_03v3 L=2U W=0.5U AS=0.14P AD=0.14P PS=1.06U PD=1.06U
M$419 VSS VSS VSS VSS nfet_03v3 L=2U W=0.5U AS=0.14P AD=0.14P PS=1.06U PD=1.06U
M$420 VSS VSS VSS VSS nfet_03v3 L=2U W=0.5U AS=0.14P AD=0.14P PS=1.06U PD=1.06U
M$421 VSS VSS VSS VSS nfet_03v3 L=2U W=0.5U AS=0.14P AD=0.14P PS=1.06U PD=1.06U
M$422 VSS VSS VSS VSS nfet_03v3 L=2U W=0.5U AS=0.14P AD=0.14P PS=1.06U PD=1.06U
M$423 VSS VSS VSS VSS nfet_03v3 L=2U W=0.5U AS=0.14P AD=0.14P PS=1.06U PD=1.06U
M$424 VSS VSS VSS VSS nfet_03v3 L=2U W=0.5U AS=0.14P AD=0.14P PS=1.06U PD=1.06U
M$425 VSS VSS VSS VSS nfet_03v3 L=2U W=0.5U AS=0.14P AD=0.14P PS=1.06U PD=1.06U
M$426 VSS VSS VSS VSS nfet_03v3 L=2U W=0.5U AS=0.14P AD=0.14P PS=1.06U PD=1.06U
M$427 VSS VSS VSS VSS nfet_03v3 L=2U W=0.5U AS=0.14P AD=0.14P PS=1.06U PD=1.06U
M$428 VSS VSS VSS VSS nfet_03v3 L=2U W=0.5U AS=0.14P AD=0.14P PS=1.06U PD=1.06U
M$429 VSS VSS VSS VSS nfet_03v3 L=2U W=0.5U AS=0.14P AD=0.14P PS=1.06U PD=1.06U
M$430 VSS VSS VSS VSS nfet_03v3 L=2U W=0.5U AS=0.14P AD=0.14P PS=1.06U PD=1.06U
M$431 VSS VSS VSS VSS nfet_03v3 L=2U W=0.5U AS=0.14P AD=0.14P PS=1.06U PD=1.06U
M$432 VSS VSS VSS VSS nfet_03v3 L=2U W=0.5U AS=0.14P AD=0.14P PS=1.06U PD=1.06U
M$433 VSS VSS VSS VSS nfet_03v3 L=2U W=0.5U AS=0.14P AD=0.14P PS=1.06U PD=1.06U
M$434 VSS VSS VSS VSS nfet_03v3 L=2U W=0.5U AS=0.14P AD=0.14P PS=1.06U PD=1.06U
M$435 VSS VSS VSS VSS nfet_03v3 L=2U W=0.5U AS=0.14P AD=0.14P PS=1.06U PD=1.06U
M$436 VSS VSS VSS VSS nfet_03v3 L=2U W=0.5U AS=0.14P AD=0.14P PS=1.06U PD=1.06U
M$437 VSS VSS VSS VSS nfet_03v3 L=2U W=0.5U AS=0.14P AD=0.14P PS=1.06U PD=1.06U
M$438 VSS VSS VSS VSS nfet_03v3 L=2U W=0.5U AS=0.14P AD=0.14P PS=1.06U PD=1.06U
M$439 VSS VSS VSS VSS nfet_03v3 L=2U W=0.5U AS=0.14P AD=0.14P PS=1.06U PD=1.06U
M$440 VSS VSS VSS VSS nfet_03v3 L=2U W=0.5U AS=0.14P AD=0.14P PS=1.06U PD=1.06U
M$441 VSS VSS VSS VSS nfet_03v3 L=2U W=0.5U AS=0.14P AD=0.14P PS=1.06U PD=1.06U
M$442 VSS VSS VSS VSS nfet_03v3 L=2U W=0.5U AS=0.14P AD=0.14P PS=1.06U PD=1.06U
M$443 VSS VSS VSS VSS nfet_03v3 L=2U W=0.5U AS=0.14P AD=0.14P PS=1.06U PD=1.06U
M$444 VSS VSS VSS VSS nfet_03v3 L=2U W=0.5U AS=0.14P AD=0.14P PS=1.06U PD=1.06U
M$445 VSS VSS VSS VSS nfet_03v3 L=2U W=0.5U AS=0.14P AD=0.14P PS=1.06U PD=1.06U
M$446 VSS VSS VSS VSS nfet_03v3 L=2U W=0.5U AS=0.14P AD=0.14P PS=1.06U PD=1.06U
M$447 VSS VSS VSS VSS nfet_03v3 L=2U W=0.5U AS=0.14P AD=0.14P PS=1.06U PD=1.06U
M$448 VSS VSS VSS VSS nfet_03v3 L=2U W=0.5U AS=0.14P AD=0.14P PS=1.06U PD=1.06U
M$449 VSS VSS VSS VSS nfet_03v3 L=2U W=0.5U AS=0.14P AD=0.14P PS=1.06U PD=1.06U
M$450 VSS VSS VSS VSS nfet_03v3 L=2U W=0.5U AS=0.14P AD=0.14P PS=1.06U PD=1.06U
M$451 VSS VSS VSS VSS nfet_03v3 L=2U W=0.5U AS=0.14P AD=0.14P PS=1.06U PD=1.06U
M$452 VSS VSS VSS VSS nfet_03v3 L=2U W=0.5U AS=0.14P AD=0.14P PS=1.06U PD=1.06U
M$453 VSS VSS VSS VSS nfet_03v3 L=2U W=0.5U AS=0.14P AD=0.14P PS=1.06U PD=1.06U
M$454 VSS VSS VSS VSS nfet_03v3 L=2U W=0.5U AS=0.14P AD=0.14P PS=1.06U PD=1.06U
M$455 VSS VSS VSS VSS nfet_03v3 L=2U W=0.5U AS=0.14P AD=0.14P PS=1.06U PD=1.06U
M$456 VSS VSS VSS VSS nfet_03v3 L=2U W=0.5U AS=0.14P AD=0.14P PS=1.06U PD=1.06U
M$457 VSS VSS VSS VSS nfet_03v3 L=2U W=0.5U AS=0.14P AD=0.14P PS=1.06U PD=1.06U
M$458 VSS VSS VSS VSS nfet_03v3 L=2U W=0.5U AS=0.14P AD=0.14P PS=1.06U PD=1.06U
M$459 VSS VSS VSS VSS nfet_03v3 L=2U W=0.5U AS=0.14P AD=0.3P PS=1.06U PD=2.2U
M$460 VSS VSS VSS VSS nfet_03v3 L=2U W=0.5U AS=0.14P AD=0.14P PS=1.06U PD=1.06U
M$461 VSS VSS VSS VSS nfet_03v3 L=2U W=0.5U AS=0.14P AD=0.14P PS=1.06U PD=1.06U
M$462 VSS VSS VSS VSS nfet_03v3 L=2U W=0.5U AS=0.14P AD=0.14P PS=1.06U PD=1.06U
M$463 VSS VSS VSS VSS nfet_03v3 L=2U W=0.5U AS=0.14P AD=0.14P PS=1.06U PD=1.06U
M$464 VSS VSS VSS VSS nfet_03v3 L=2U W=0.5U AS=0.14P AD=0.14P PS=1.06U PD=1.06U
M$465 VSS VSS VSS VSS nfet_03v3 L=2U W=0.5U AS=0.14P AD=0.14P PS=1.06U PD=1.06U
M$466 VSS VSS VSS VSS nfet_03v3 L=2U W=0.5U AS=0.14P AD=0.14P PS=1.06U PD=1.06U
M$467 VSS VSS VSS VSS nfet_03v3 L=2U W=0.5U AS=0.14P AD=0.14P PS=1.06U PD=1.06U
M$468 VSS VSS VSS VSS nfet_03v3 L=2U W=0.5U AS=0.14P AD=0.14P PS=1.06U PD=1.06U
M$469 VSS VSS VSS VSS nfet_03v3 L=2U W=0.5U AS=0.14P AD=0.14P PS=1.06U PD=1.06U
M$470 VSS VSS VSS VSS nfet_03v3 L=2U W=0.5U AS=0.14P AD=0.14P PS=1.06U PD=1.06U
M$471 VSS VSS VSS VSS nfet_03v3 L=2U W=0.5U AS=0.14P AD=0.14P PS=1.06U PD=1.06U
M$472 VSS VSS VSS VSS nfet_03v3 L=2U W=0.5U AS=0.14P AD=0.14P PS=1.06U PD=1.06U
M$473 VSS VSS VSS VSS nfet_03v3 L=2U W=0.5U AS=0.14P AD=0.14P PS=1.06U PD=1.06U
M$474 VSS VSS VSS VSS nfet_03v3 L=2U W=0.5U AS=0.14P AD=0.14P PS=1.06U PD=1.06U
M$475 VSS VSS VSS VSS nfet_03v3 L=2U W=0.5U AS=0.14P AD=0.14P PS=1.06U PD=1.06U
M$476 VSS VSS VSS VSS nfet_03v3 L=2U W=0.5U AS=0.14P AD=0.14P PS=1.06U PD=1.06U
M$477 VSS VSS VSS VSS nfet_03v3 L=2U W=0.5U AS=0.14P AD=0.14P PS=1.06U PD=1.06U
M$478 VSS VSS VSS VSS nfet_03v3 L=2U W=0.5U AS=0.14P AD=0.14P PS=1.06U PD=1.06U
M$479 VSS VSS VSS VSS nfet_03v3 L=2U W=0.5U AS=0.14P AD=0.14P PS=1.06U PD=1.06U
M$480 VSS VSS VSS VSS nfet_03v3 L=2U W=0.5U AS=0.14P AD=0.14P PS=1.06U PD=1.06U
M$481 VSS VSS VSS VSS nfet_03v3 L=2U W=0.5U AS=0.14P AD=0.14P PS=1.06U PD=1.06U
M$482 VSS VSS VSS VSS nfet_03v3 L=2U W=0.5U AS=0.14P AD=0.14P PS=1.06U PD=1.06U
M$483 VSS VSS VSS VSS nfet_03v3 L=2U W=0.5U AS=0.14P AD=0.14P PS=1.06U PD=1.06U
M$484 VSS VSS VSS VSS nfet_03v3 L=2U W=0.5U AS=0.14P AD=0.14P PS=1.06U PD=1.06U
M$485 VSS VSS VSS VSS nfet_03v3 L=2U W=0.5U AS=0.14P AD=0.14P PS=1.06U PD=1.06U
M$486 VSS VSS VSS VSS nfet_03v3 L=2U W=0.5U AS=0.14P AD=0.14P PS=1.06U PD=1.06U
M$487 VSS VSS VSS VSS nfet_03v3 L=2U W=0.5U AS=0.14P AD=0.14P PS=1.06U PD=1.06U
M$488 VSS VSS VSS VSS nfet_03v3 L=2U W=0.5U AS=0.14P AD=0.14P PS=1.06U PD=1.06U
M$489 VSS VSS VSS VSS nfet_03v3 L=2U W=0.5U AS=0.14P AD=0.14P PS=1.06U PD=1.06U
M$490 VSS VSS VSS VSS nfet_03v3 L=2U W=0.5U AS=0.14P AD=0.14P PS=1.06U PD=1.06U
M$491 VSS VSS VSS VSS nfet_03v3 L=2U W=0.5U AS=0.14P AD=0.14P PS=1.06U PD=1.06U
M$492 VSS VSS VSS VSS nfet_03v3 L=2U W=0.5U AS=0.14P AD=0.14P PS=1.06U PD=1.06U
M$493 VSS VSS VSS VSS nfet_03v3 L=2U W=0.5U AS=0.14P AD=0.14P PS=1.06U PD=1.06U
M$494 VSS VSS VSS VSS nfet_03v3 L=2U W=0.5U AS=0.14P AD=0.14P PS=1.06U PD=1.06U
M$495 VSS VSS VSS VSS nfet_03v3 L=2U W=0.5U AS=0.14P AD=0.14P PS=1.06U PD=1.06U
M$496 VSS VSS VSS VSS nfet_03v3 L=2U W=0.5U AS=0.14P AD=0.14P PS=1.06U PD=1.06U
M$497 VSS VSS VSS VSS nfet_03v3 L=2U W=0.5U AS=0.14P AD=0.14P PS=1.06U PD=1.06U
M$498 VSS VSS VSS VSS nfet_03v3 L=2U W=0.5U AS=0.14P AD=0.14P PS=1.06U PD=1.06U
M$499 VSS VSS VSS VSS nfet_03v3 L=2U W=0.5U AS=0.14P AD=0.14P PS=1.06U PD=1.06U
M$500 VSS VSS VSS VSS nfet_03v3 L=2U W=0.5U AS=0.14P AD=0.14P PS=1.06U PD=1.06U
M$501 VSS VSS VSS VSS nfet_03v3 L=2U W=0.5U AS=0.14P AD=0.14P PS=1.06U PD=1.06U
M$502 VSS VSS VSS VSS nfet_03v3 L=2U W=0.5U AS=0.14P AD=0.14P PS=1.06U PD=1.06U
M$503 VSS VSS VSS VSS nfet_03v3 L=2U W=0.5U AS=0.14P AD=0.14P PS=1.06U PD=1.06U
M$504 VSS VSS VSS VSS nfet_03v3 L=2U W=0.5U AS=0.14P AD=0.14P PS=1.06U PD=1.06U
M$505 VSS VSS VSS VSS nfet_03v3 L=2U W=0.5U AS=0.14P AD=0.14P PS=1.06U PD=1.06U
M$506 VSS VSS VSS VSS nfet_03v3 L=2U W=0.5U AS=0.14P AD=0.14P PS=1.06U PD=1.06U
M$507 VSS VSS VSS VSS nfet_03v3 L=2U W=0.5U AS=0.14P AD=0.14P PS=1.06U PD=1.06U
M$508 VSS VSS VSS VSS nfet_03v3 L=2U W=0.5U AS=0.14P AD=0.14P PS=1.06U PD=1.06U
M$509 VSS VSS VSS VSS nfet_03v3 L=2U W=0.5U AS=0.14P AD=0.14P PS=1.06U PD=1.06U
M$510 VSS VSS VSS VSS nfet_03v3 L=2U W=0.5U AS=0.14P AD=0.14P PS=1.06U PD=1.06U
M$511 VSS VSS VSS VSS nfet_03v3 L=2U W=0.5U AS=0.14P AD=0.14P PS=1.06U PD=1.06U
M$512 VSS VSS VSS VSS nfet_03v3 L=2U W=0.5U AS=0.14P AD=0.14P PS=1.06U PD=1.06U
M$513 VSS VSS VSS VSS nfet_03v3 L=2U W=0.5U AS=0.14P AD=0.14P PS=1.06U PD=1.06U
M$514 VSS VSS VSS VSS nfet_03v3 L=2U W=0.5U AS=0.3P AD=0.14P PS=2.2U PD=1.06U
M$515 \$62 Iref VSS VSS nfet_03v3 L=8U W=10U AS=6P AD=6P PS=21.2U PD=21.2U
M$516 Iref Iref VSS VSS nfet_03v3 L=8U W=10U AS=6P AD=6P PS=21.2U PD=21.2U
M$517 VNA Iref VSS VSS nfet_03v3 L=8U W=5.76U AS=3.456P AD=3.456P PS=12.72U
+ PD=12.72U
M$518 VKup Iref VSS VSS nfet_03v3 L=8U W=6.01U AS=3.606P AD=3.606P PS=13.22U
+ PD=13.22U
M$519 Vthr Iref VSS VSS nfet_03v3 L=32U W=0.91U AS=0.546P AD=0.546P PS=3.02U
+ PD=3.02U
M$520 VT_dpi Iref VSS VSS nfet_03v3 L=32U W=1.17U AS=0.702P AD=0.702P PS=3.54U
+ PD=3.54U
M$521 VT_inh Iref VSS VSS nfet_03v3 L=32U W=0.63U AS=0.378P AD=0.378P PS=2.46U
+ PD=2.46U
M$522 Vb Vb VSS VSS nfet_03v3 L=8U W=1U AS=0.6P AD=0.6P PS=3.2U PD=3.2U
M$523 Vlk Vlk VSS VSS nfet_03v3 L=1U W=1U AS=0.6P AD=0.28P PS=3.2U PD=1.56U
M$524 VSS Vlk Vlk VSS nfet_03v3 L=1U W=1U AS=0.28P AD=0.28P PS=1.56U PD=1.56U
M$525 Vlk Vlk VSS VSS nfet_03v3 L=1U W=1U AS=0.28P AD=0.28P PS=1.56U PD=1.56U
M$526 VSS Vlk Vlk VSS nfet_03v3 L=1U W=1U AS=0.28P AD=0.28P PS=1.56U PD=1.56U
M$527 Vlk Vlk VSS VSS nfet_03v3 L=1U W=1U AS=0.28P AD=0.28P PS=1.56U PD=1.56U
M$528 VSS Vlk Vlk VSS nfet_03v3 L=1U W=1U AS=0.28P AD=0.28P PS=1.56U PD=1.56U
M$529 Vlk Vlk VSS VSS nfet_03v3 L=1U W=1U AS=0.28P AD=0.28P PS=1.56U PD=1.56U
M$530 VSS Vlk Vlk VSS nfet_03v3 L=1U W=1U AS=0.28P AD=0.6P PS=1.56U PD=3.2U
M$531 VKdn VKdn VSS VSS nfet_03v3 L=1U W=1U AS=0.6P AD=0.28P PS=3.2U PD=1.56U
M$532 VSS VKdn VKdn VSS nfet_03v3 L=1U W=1U AS=0.28P AD=0.28P PS=1.56U PD=1.56U
M$533 VKdn VKdn VSS VSS nfet_03v3 L=1U W=1U AS=0.28P AD=0.28P PS=1.56U PD=1.56U
M$534 VSS VKdn VKdn VSS nfet_03v3 L=1U W=1U AS=0.28P AD=0.6P PS=1.56U PD=3.2U
M$535 VIp VIp VSS VSS nfet_03v3 L=1U W=1U AS=0.6P AD=0.6P PS=3.2U PD=3.2U
M$536 Vamp_bias Vamp_bias VSS VSS nfet_03v3 L=0.64U W=0.5U AS=0.3P AD=0.3P
+ PS=2.2U PD=2.2U
M$537 VK VK VSS VSS nfet_03v3 L=90.91U W=0.5U AS=0.3P AD=0.3P PS=2.2U PD=2.2U
M$538 VSS VSS VSS VSS nfet_03v3 L=2U W=10U AS=6P AD=6P PS=21.2U PD=21.2U
.ENDS bias_cell

.SUBCKT DPI_inh_min Vthr VDD Isum Iout VT VSS
M$1 VDD VDD VDD VDD pfet_03v3 L=2U W=0.5U AS=0.3P AD=0.14P PS=2.2U PD=1.06U
M$2 VDD VDD VDD VDD pfet_03v3 L=2U W=0.5U AS=0.14P AD=0.14P PS=1.06U PD=1.06U
M$3 VDD VDD VDD VDD pfet_03v3 L=2U W=0.5U AS=0.14P AD=0.14P PS=1.06U PD=1.06U
M$4 VDD VDD VDD VDD pfet_03v3 L=2U W=0.5U AS=0.14P AD=0.14P PS=1.06U PD=1.06U
M$5 VDD VDD VDD VDD pfet_03v3 L=2U W=0.5U AS=0.14P AD=0.3P PS=1.06U PD=2.2U
M$6 VDD \$1 \$223 VDD pfet_03v3 L=0.64U W=0.5U AS=0.3P AD=0.3P PS=2.2U PD=2.2U
M$7 VDD VDD VDD VDD pfet_03v3 L=2U W=0.5U AS=0.3P AD=0.3P PS=2.2U PD=2.2U
M$8 VDD VDD VDD VDD pfet_03v3 L=2U W=0.5U AS=0.3P AD=0.14P PS=2.2U PD=1.06U
M$9 VDD VDD VDD VDD pfet_03v3 L=2U W=0.5U AS=0.14P AD=0.14P PS=1.06U PD=1.06U
M$10 VDD VDD VDD VDD pfet_03v3 L=2U W=0.5U AS=0.14P AD=0.14P PS=1.06U PD=1.06U
M$11 VDD VDD VDD VDD pfet_03v3 L=2U W=0.5U AS=0.14P AD=0.14P PS=1.06U PD=1.06U
M$12 VDD VDD VDD VDD pfet_03v3 L=2U W=0.5U AS=0.14P AD=0.3P PS=1.06U PD=2.2U
M$13 VDD VT \$1 VDD pfet_03v3 L=0.64U W=0.5U AS=0.3P AD=0.3P PS=2.2U PD=2.2U
M$14 VDD VDD VDD VDD pfet_03v3 L=2U W=0.5U AS=0.3P AD=0.3P PS=2.2U PD=2.2U
M$15 VSS VSS VSS VSS nfet_03v3 L=2U W=0.5U AS=0.3P AD=0.14P PS=2.2U PD=1.06U
M$16 VSS VSS VSS VSS nfet_03v3 L=2U W=0.5U AS=0.14P AD=0.14P PS=1.06U PD=1.06U
M$17 VSS VSS VSS VSS nfet_03v3 L=2U W=0.5U AS=0.14P AD=0.14P PS=1.06U PD=1.06U
M$18 VSS VSS VSS VSS nfet_03v3 L=2U W=0.5U AS=0.14P AD=0.14P PS=1.06U PD=1.06U
M$19 VSS VSS VSS VSS nfet_03v3 L=2U W=0.5U AS=0.14P AD=0.14P PS=1.06U PD=1.06U
M$20 VSS VSS VSS VSS nfet_03v3 L=2U W=0.5U AS=0.14P AD=0.14P PS=1.06U PD=1.06U
M$21 VSS VSS VSS VSS nfet_03v3 L=2U W=0.5U AS=0.14P AD=0.14P PS=1.06U PD=1.06U
M$22 VSS VSS VSS VSS nfet_03v3 L=2U W=0.5U AS=0.14P AD=0.14P PS=1.06U PD=1.06U
M$23 VSS VSS VSS VSS nfet_03v3 L=2U W=0.5U AS=0.14P AD=0.14P PS=1.06U PD=1.06U
M$24 VSS VSS VSS VSS nfet_03v3 L=2U W=0.5U AS=0.14P AD=0.3P PS=1.06U PD=2.2U
M$25 Isum Isum Isum Isum nfet_03v3 L=2U W=0.5U AS=0.3P AD=0.14P PS=2.2U PD=1.06U
M$26 Isum Isum Isum Isum nfet_03v3 L=2U W=0.5U AS=0.14P AD=0.14P PS=1.06U
+ PD=1.06U
M$27 Isum Isum Isum Isum nfet_03v3 L=2U W=0.5U AS=0.14P AD=0.14P PS=1.06U
+ PD=1.06U
M$28 Isum Isum Isum Isum nfet_03v3 L=2U W=0.5U AS=0.14P AD=0.14P PS=1.06U
+ PD=1.06U
M$29 Isum Isum Isum Isum nfet_03v3 L=2U W=0.5U AS=0.14P AD=0.3P PS=1.06U PD=2.2U
M$30 VSS VSS VSS VSS nfet_03v3 L=2U W=2U AS=1.2P AD=1.2P PS=5.2U PD=5.2U
M$31 Iout \$223 VSS VSS nfet_03v3 L=8U W=2U AS=1.2P AD=1.2P PS=5.2U PD=5.2U
M$32 VSS VSS VSS VSS nfet_03v3 L=2U W=0.5U AS=0.3P AD=0.14P PS=2.2U PD=1.06U
M$33 VSS VSS VSS VSS nfet_03v3 L=2U W=0.5U AS=0.14P AD=0.14P PS=1.06U PD=1.06U
M$34 VSS VSS VSS VSS nfet_03v3 L=2U W=0.5U AS=0.14P AD=0.14P PS=1.06U PD=1.06U
M$35 VSS VSS VSS VSS nfet_03v3 L=2U W=0.5U AS=0.14P AD=0.14P PS=1.06U PD=1.06U
M$36 VSS VSS VSS VSS nfet_03v3 L=2U W=0.5U AS=0.14P AD=0.14P PS=1.06U PD=1.06U
M$37 VSS VSS VSS VSS nfet_03v3 L=2U W=0.5U AS=0.14P AD=0.14P PS=1.06U PD=1.06U
M$38 VSS VSS VSS VSS nfet_03v3 L=2U W=0.5U AS=0.14P AD=0.14P PS=1.06U PD=1.06U
M$39 VSS VSS VSS VSS nfet_03v3 L=2U W=0.5U AS=0.14P AD=0.14P PS=1.06U PD=1.06U
M$40 VSS VSS VSS VSS nfet_03v3 L=2U W=0.5U AS=0.14P AD=0.14P PS=1.06U PD=1.06U
M$41 VSS VSS VSS VSS nfet_03v3 L=2U W=0.5U AS=0.14P AD=0.3P PS=1.06U PD=2.2U
M$42 Isum Isum Isum Isum nfet_03v3 L=2U W=0.5U AS=0.3P AD=0.14P PS=2.2U PD=1.06U
M$43 Isum Isum Isum Isum nfet_03v3 L=2U W=0.5U AS=0.14P AD=0.14P PS=1.06U
+ PD=1.06U
M$44 Isum Isum Isum Isum nfet_03v3 L=2U W=0.5U AS=0.14P AD=0.14P PS=1.06U
+ PD=1.06U
M$45 Isum Isum Isum Isum nfet_03v3 L=2U W=0.5U AS=0.14P AD=0.14P PS=1.06U
+ PD=1.06U
M$46 Isum Isum Isum Isum nfet_03v3 L=2U W=0.5U AS=0.14P AD=0.3P PS=1.06U PD=2.2U
M$47 Isum Isum Isum Isum nfet_03v3 L=2U W=0.5U AS=0.3P AD=0.3P PS=2.2U PD=2.2U
M$48 VSS VSS VSS VSS nfet_03v3 L=2U W=2U AS=1.2P AD=1.2P PS=5.2U PD=5.2U
M$49 \$1 \$1 Isum Isum nfet_03v3 L=0.64U W=0.5U AS=0.3P AD=0.3P PS=2.2U PD=2.2U
M$50 VDD Vthr Isum Isum nfet_03v3 L=0.64U W=0.5U AS=0.3P AD=0.3P PS=2.2U PD=2.2U
M$51 Isum Isum Isum Isum nfet_03v3 L=2U W=0.5U AS=0.3P AD=0.3P PS=2.2U PD=2.2U
M$52 \$223 \$223 VSS VSS nfet_03v3 L=8U W=2U AS=1.2P AD=1.2P PS=5.2U PD=5.2U
C$53 \$1 VDD 9.839048e-13 cap_mim_2f0fF A=491.9524P P=88.72U
.ENDS DPI_inh_min

.SUBCKT neuron_glayout Vamp_bias VT VKdn VIp VK Vlk VDD VMEM spike VKup VNA VSS
M$1 VDD VDD VDD VDD pfet_03v3 L=2U W=0.5U AS=0.3P AD=0.14P PS=2.2U PD=1.06U
M$2 VDD VDD VDD VDD pfet_03v3 L=2U W=0.5U AS=0.14P AD=0.14P PS=1.06U PD=1.06U
M$3 VDD VDD VDD VDD pfet_03v3 L=2U W=0.5U AS=0.14P AD=0.14P PS=1.06U PD=1.06U
M$4 VDD VDD VDD VDD pfet_03v3 L=2U W=0.5U AS=0.14P AD=0.14P PS=1.06U PD=1.06U
M$5 VDD VDD VDD VDD pfet_03v3 L=2U W=0.5U AS=0.14P AD=0.14P PS=1.06U PD=1.06U
M$6 VDD VDD VDD VDD pfet_03v3 L=2U W=0.5U AS=0.14P AD=0.14P PS=1.06U PD=1.06U
M$7 VDD VDD VDD VDD pfet_03v3 L=2U W=0.5U AS=0.14P AD=0.14P PS=1.06U PD=1.06U
M$8 VDD VDD VDD VDD pfet_03v3 L=2U W=0.5U AS=0.14P AD=0.14P PS=1.06U PD=1.06U
M$9 VDD VDD VDD VDD pfet_03v3 L=2U W=0.5U AS=0.14P AD=0.14P PS=1.06U PD=1.06U
M$10 VDD VDD VDD VDD pfet_03v3 L=2U W=0.5U AS=0.14P AD=0.14P PS=1.06U PD=1.06U
M$11 VDD VDD VDD VDD pfet_03v3 L=2U W=0.5U AS=0.14P AD=0.14P PS=1.06U PD=1.06U
M$12 VDD VDD VDD VDD pfet_03v3 L=2U W=0.5U AS=0.14P AD=0.14P PS=1.06U PD=1.06U
M$13 VDD VDD VDD VDD pfet_03v3 L=2U W=0.5U AS=0.14P AD=0.14P PS=1.06U PD=1.06U
M$14 VDD VDD VDD VDD pfet_03v3 L=2U W=0.5U AS=0.14P AD=0.14P PS=1.06U PD=1.06U
M$15 VDD VDD VDD VDD pfet_03v3 L=2U W=0.5U AS=0.14P AD=0.14P PS=1.06U PD=1.06U
M$16 VDD VDD VDD VDD pfet_03v3 L=2U W=0.5U AS=0.14P AD=0.14P PS=1.06U PD=1.06U
M$17 VDD VDD VDD VDD pfet_03v3 L=2U W=0.5U AS=0.14P AD=0.3P PS=1.06U PD=2.2U
M$18 \$766 \$7 spike VDD pfet_03v3 L=0.64U W=0.5U AS=0.3P AD=0.3P PS=2.2U
+ PD=2.2U
M$19 VDD VDD VDD VDD pfet_03v3 L=2U W=0.5U AS=0.3P AD=0.14P PS=2.2U PD=1.06U
M$20 VDD VDD VDD VDD pfet_03v3 L=2U W=0.5U AS=0.14P AD=0.14P PS=1.06U PD=1.06U
M$21 VDD VDD VDD VDD pfet_03v3 L=2U W=0.5U AS=0.14P AD=0.14P PS=1.06U PD=1.06U
M$22 VDD VDD VDD VDD pfet_03v3 L=2U W=0.5U AS=0.14P AD=0.14P PS=1.06U PD=1.06U
M$23 VDD VDD VDD VDD pfet_03v3 L=2U W=0.5U AS=0.14P AD=0.14P PS=1.06U PD=1.06U
M$24 VDD VDD VDD VDD pfet_03v3 L=2U W=0.5U AS=0.14P AD=0.14P PS=1.06U PD=1.06U
M$25 VDD VDD VDD VDD pfet_03v3 L=2U W=0.5U AS=0.14P AD=0.14P PS=1.06U PD=1.06U
M$26 VDD VDD VDD VDD pfet_03v3 L=2U W=0.5U AS=0.14P AD=0.14P PS=1.06U PD=1.06U
M$27 VDD VDD VDD VDD pfet_03v3 L=2U W=0.5U AS=0.14P AD=0.14P PS=1.06U PD=1.06U
M$28 VDD VDD VDD VDD pfet_03v3 L=2U W=0.5U AS=0.14P AD=0.14P PS=1.06U PD=1.06U
M$29 VDD VDD VDD VDD pfet_03v3 L=2U W=0.5U AS=0.14P AD=0.14P PS=1.06U PD=1.06U
M$30 VDD VDD VDD VDD pfet_03v3 L=2U W=0.5U AS=0.14P AD=0.14P PS=1.06U PD=1.06U
M$31 VDD VDD VDD VDD pfet_03v3 L=2U W=0.5U AS=0.14P AD=0.14P PS=1.06U PD=1.06U
M$32 VDD VDD VDD VDD pfet_03v3 L=2U W=0.5U AS=0.14P AD=0.14P PS=1.06U PD=1.06U
M$33 VDD VDD VDD VDD pfet_03v3 L=2U W=0.5U AS=0.14P AD=0.14P PS=1.06U PD=1.06U
M$34 VDD VDD VDD VDD pfet_03v3 L=2U W=0.5U AS=0.14P AD=0.14P PS=1.06U PD=1.06U
M$35 VDD VDD VDD VDD pfet_03v3 L=2U W=0.5U AS=0.14P AD=0.3P PS=1.06U PD=2.2U
M$36 \$768 \$7 VMEM VDD pfet_03v3 L=0.64U W=0.5U AS=0.3P AD=0.3P PS=2.2U PD=2.2U
M$37 VDD \$217 \$217 VDD pfet_03v3 L=8U W=0.5U AS=0.3P AD=0.3P PS=2.2U PD=2.2U
M$38 VDD VNA \$768 VDD pfet_03v3 L=1U W=1U AS=0.6P AD=0.6P PS=3.2U PD=3.2U
M$39 VDD \$218 \$7 VDD pfet_03v3 L=0.64U W=0.5U AS=0.3P AD=0.3P PS=2.2U PD=2.2U
M$40 VDD VKup \$766 VDD pfet_03v3 L=1U W=1U AS=0.6P AD=0.6P PS=3.2U PD=3.2U
M$41 VDD VDD VDD VDD pfet_03v3 L=2U W=1U AS=0.6P AD=0.6P PS=3.2U PD=3.2U
M$42 VDD \$217 \$218 VDD pfet_03v3 L=8U W=0.5U AS=0.3P AD=0.3P PS=2.2U PD=2.2U
M$43 VDD VDD VDD VDD pfet_03v3 L=2U W=1U AS=0.6P AD=0.6P PS=3.2U PD=3.2U
M$44 VSS VSS VSS VSS nfet_03v3 L=2U W=0.5U AS=0.3P AD=0.14P PS=2.2U PD=1.06U
M$45 VSS VSS VSS VSS nfet_03v3 L=2U W=0.5U AS=0.14P AD=0.14P PS=1.06U PD=1.06U
M$46 VSS VSS VSS VSS nfet_03v3 L=2U W=0.5U AS=0.14P AD=0.14P PS=1.06U PD=1.06U
M$47 VSS VSS VSS VSS nfet_03v3 L=2U W=0.5U AS=0.14P AD=0.14P PS=1.06U PD=1.06U
M$48 VSS VSS VSS VSS nfet_03v3 L=2U W=0.5U AS=0.14P AD=0.14P PS=1.06U PD=1.06U
M$49 VSS VSS VSS VSS nfet_03v3 L=2U W=0.5U AS=0.14P AD=0.14P PS=1.06U PD=1.06U
M$50 VSS VSS VSS VSS nfet_03v3 L=2U W=0.5U AS=0.14P AD=0.14P PS=1.06U PD=1.06U
M$51 VSS VSS VSS VSS nfet_03v3 L=2U W=0.5U AS=0.14P AD=0.14P PS=1.06U PD=1.06U
M$52 VSS VSS VSS VSS nfet_03v3 L=2U W=0.5U AS=0.14P AD=0.14P PS=1.06U PD=1.06U
M$53 VSS VSS VSS VSS nfet_03v3 L=2U W=0.5U AS=0.14P AD=0.14P PS=1.06U PD=1.06U
M$54 VSS VSS VSS VSS nfet_03v3 L=2U W=0.5U AS=0.14P AD=0.14P PS=1.06U PD=1.06U
M$55 VSS VSS VSS VSS nfet_03v3 L=2U W=0.5U AS=0.14P AD=0.14P PS=1.06U PD=1.06U
M$56 VSS VSS VSS VSS nfet_03v3 L=2U W=0.5U AS=0.14P AD=0.14P PS=1.06U PD=1.06U
M$57 VSS VSS VSS VSS nfet_03v3 L=2U W=0.5U AS=0.14P AD=0.14P PS=1.06U PD=1.06U
M$58 VSS VSS VSS VSS nfet_03v3 L=2U W=0.5U AS=0.14P AD=0.14P PS=1.06U PD=1.06U
M$59 VSS VSS VSS VSS nfet_03v3 L=2U W=0.5U AS=0.14P AD=0.14P PS=1.06U PD=1.06U
M$60 VSS VSS VSS VSS nfet_03v3 L=2U W=0.5U AS=0.14P AD=0.14P PS=1.06U PD=1.06U
M$61 VSS VSS VSS VSS nfet_03v3 L=2U W=0.5U AS=0.14P AD=0.14P PS=1.06U PD=1.06U
M$62 VSS VSS VSS VSS nfet_03v3 L=2U W=0.5U AS=0.14P AD=0.14P PS=1.06U PD=1.06U
M$63 VSS VSS VSS VSS nfet_03v3 L=2U W=0.5U AS=0.14P AD=0.3P PS=1.06U PD=2.2U
M$64 VSS VSS VSS VSS nfet_03v3 L=2U W=4U AS=2.4P AD=2.4P PS=9.2U PD=9.2U
M$65 VSS VSS VSS VSS nfet_03v3 L=2U W=0.5U AS=0.3P AD=0.14P PS=2.2U PD=1.06U
M$66 VSS VSS VSS VSS nfet_03v3 L=2U W=0.5U AS=0.14P AD=0.14P PS=1.06U PD=1.06U
M$67 VSS VSS VSS VSS nfet_03v3 L=2U W=0.5U AS=0.14P AD=0.14P PS=1.06U PD=1.06U
M$68 VSS VSS VSS VSS nfet_03v3 L=2U W=0.5U AS=0.14P AD=0.14P PS=1.06U PD=1.06U
M$69 VSS VSS VSS VSS nfet_03v3 L=2U W=0.5U AS=0.14P AD=0.14P PS=1.06U PD=1.06U
M$70 VSS VSS VSS VSS nfet_03v3 L=2U W=0.5U AS=0.14P AD=0.14P PS=1.06U PD=1.06U
M$71 VSS VSS VSS VSS nfet_03v3 L=2U W=0.5U AS=0.14P AD=0.14P PS=1.06U PD=1.06U
M$72 VSS VSS VSS VSS nfet_03v3 L=2U W=0.5U AS=0.14P AD=0.14P PS=1.06U PD=1.06U
M$73 VSS VSS VSS VSS nfet_03v3 L=2U W=0.5U AS=0.14P AD=0.14P PS=1.06U PD=1.06U
M$74 VSS VSS VSS VSS nfet_03v3 L=2U W=0.5U AS=0.14P AD=0.14P PS=1.06U PD=1.06U
M$75 VSS VSS VSS VSS nfet_03v3 L=2U W=0.5U AS=0.14P AD=0.14P PS=1.06U PD=1.06U
M$76 VSS VSS VSS VSS nfet_03v3 L=2U W=0.5U AS=0.14P AD=0.14P PS=1.06U PD=1.06U
M$77 VSS VSS VSS VSS nfet_03v3 L=2U W=0.5U AS=0.14P AD=0.14P PS=1.06U PD=1.06U
M$78 VSS VSS VSS VSS nfet_03v3 L=2U W=0.5U AS=0.14P AD=0.14P PS=1.06U PD=1.06U
M$79 VSS VSS VSS VSS nfet_03v3 L=2U W=0.5U AS=0.14P AD=0.14P PS=1.06U PD=1.06U
M$80 VSS VSS VSS VSS nfet_03v3 L=2U W=0.5U AS=0.14P AD=0.14P PS=1.06U PD=1.06U
M$81 VSS VSS VSS VSS nfet_03v3 L=2U W=0.5U AS=0.14P AD=0.14P PS=1.06U PD=1.06U
M$82 VSS VSS VSS VSS nfet_03v3 L=2U W=0.5U AS=0.14P AD=0.14P PS=1.06U PD=1.06U
M$83 VSS VSS VSS VSS nfet_03v3 L=2U W=0.5U AS=0.14P AD=0.14P PS=1.06U PD=1.06U
M$84 VSS VSS VSS VSS nfet_03v3 L=2U W=0.5U AS=0.14P AD=0.3P PS=1.06U PD=2.2U
M$85 \$216 Vamp_bias VSS VSS nfet_03v3 L=0.64U W=0.5U AS=0.3P AD=0.3P PS=2.2U
+ PD=2.2U
M$86 \$217 VMEM \$216 VSS nfet_03v3 L=2U W=4U AS=2.4P AD=2.4P PS=9.2U PD=9.2U
M$87 \$218 VT \$216 VSS nfet_03v3 L=2U W=4U AS=2.4P AD=2.4P PS=9.2U PD=9.2U
M$88 \$7 \$218 \$272 VSS nfet_03v3 L=0.64U W=0.5U AS=0.3P AD=0.3P PS=2.2U
+ PD=2.2U
M$89 spike \$7 \$273 VSS nfet_03v3 L=0.64U W=0.5U AS=0.3P AD=0.3P PS=2.2U
+ PD=2.2U
M$90 VMEM spike \$274 VSS nfet_03v3 L=11.36U W=0.5U AS=0.3P AD=0.3P PS=2.2U
+ PD=2.2U
M$91 \$273 VKdn VSS VSS nfet_03v3 L=1U W=1U AS=0.6P AD=0.6P PS=3.2U PD=3.2U
M$92 \$272 VIp VSS VSS nfet_03v3 L=1U W=1U AS=0.6P AD=0.6P PS=3.2U PD=3.2U
M$93 \$274 VK VSS VSS nfet_03v3 L=1U W=1U AS=0.6P AD=0.6P PS=3.2U PD=3.2U
M$94 VMEM Vlk VSS VSS nfet_03v3 L=1U W=1U AS=0.6P AD=0.6P PS=3.2U PD=3.2U
M$95 VSS VSS VSS VSS nfet_03v3 L=2U W=4U AS=2.4P AD=2.4P PS=9.2U PD=9.2U
C$96 VSS VMEM 9.839048e-13 cap_mim_2f0fF A=491.9524P P=88.72U
C$97 VSS spike 2e-13 cap_mim_2f0fF A=100P P=40U
.ENDS neuron_glayout

.SUBCKT DPI Vthr VDD Isum Isyn VT VSS
M$1 VDD VDD VDD VDD pfet_03v3 L=0.64U W=0.5U AS=0.3P AD=0.14P PS=2.2U PD=1.06U
M$2 VDD VDD VDD VDD pfet_03v3 L=0.64U W=0.5U AS=0.14P AD=0.14P PS=1.06U PD=1.06U
M$3 VDD VDD VDD VDD pfet_03v3 L=0.64U W=0.5U AS=0.14P AD=0.14P PS=1.06U PD=1.06U
M$4 VDD VDD VDD VDD pfet_03v3 L=0.64U W=0.5U AS=0.14P AD=0.14P PS=1.06U PD=1.06U
M$5 VDD VDD VDD VDD pfet_03v3 L=0.64U W=0.5U AS=0.14P AD=0.14P PS=1.06U PD=1.06U
M$6 VDD VDD VDD VDD pfet_03v3 L=0.64U W=0.5U AS=0.14P AD=0.14P PS=1.06U PD=1.06U
M$7 VDD VDD VDD VDD pfet_03v3 L=0.64U W=0.5U AS=0.14P AD=0.14P PS=1.06U PD=1.06U
M$8 VDD VDD VDD VDD pfet_03v3 L=0.64U W=0.5U AS=0.14P AD=0.3P PS=1.06U PD=2.2U
M$9 VDD \$1 Isyn VDD pfet_03v3 L=0.64U W=0.5U AS=0.3P AD=0.3P PS=2.2U PD=2.2U
M$10 VDD VT \$1 VDD pfet_03v3 L=0.64U W=0.5U AS=0.3P AD=0.3P PS=2.2U PD=2.2U
M$11 VDD VDD VDD VDD pfet_03v3 L=0.64U W=0.5U AS=0.3P AD=0.14P PS=2.2U PD=1.06U
M$12 VDD VDD VDD VDD pfet_03v3 L=0.64U W=0.5U AS=0.14P AD=0.14P PS=1.06U
+ PD=1.06U
M$13 VDD VDD VDD VDD pfet_03v3 L=0.64U W=0.5U AS=0.14P AD=0.14P PS=1.06U
+ PD=1.06U
M$14 VDD VDD VDD VDD pfet_03v3 L=0.64U W=0.5U AS=0.14P AD=0.14P PS=1.06U
+ PD=1.06U
M$15 VDD VDD VDD VDD pfet_03v3 L=0.64U W=0.5U AS=0.14P AD=0.14P PS=1.06U
+ PD=1.06U
M$16 VDD VDD VDD VDD pfet_03v3 L=0.64U W=0.5U AS=0.14P AD=0.14P PS=1.06U
+ PD=1.06U
M$17 VDD VDD VDD VDD pfet_03v3 L=0.64U W=0.5U AS=0.14P AD=0.14P PS=1.06U
+ PD=1.06U
M$18 VDD VDD VDD VDD pfet_03v3 L=0.64U W=0.5U AS=0.14P AD=0.3P PS=1.06U PD=2.2U
M$19 VDD VDD VDD VDD pfet_03v3 L=0.64U W=0.5U AS=0.3P AD=0.3P PS=2.2U PD=2.2U
M$20 VDD VDD VDD VDD pfet_03v3 L=0.64U W=0.5U AS=0.3P AD=0.3P PS=2.2U PD=2.2U
M$21 Isum Isum Isum Isum nfet_03v3 L=0.64U W=0.5U AS=0.3P AD=0.14P PS=2.2U
+ PD=1.06U
M$22 Isum Isum Isum Isum nfet_03v3 L=0.64U W=0.5U AS=0.14P AD=0.14P PS=1.06U
+ PD=1.06U
M$23 Isum Isum Isum Isum nfet_03v3 L=0.64U W=0.5U AS=0.14P AD=0.14P PS=1.06U
+ PD=1.06U
M$24 Isum Isum Isum Isum nfet_03v3 L=0.64U W=0.5U AS=0.14P AD=0.14P PS=1.06U
+ PD=1.06U
M$25 Isum Isum Isum Isum nfet_03v3 L=0.64U W=0.5U AS=0.14P AD=0.14P PS=1.06U
+ PD=1.06U
M$26 Isum Isum Isum Isum nfet_03v3 L=0.64U W=0.5U AS=0.14P AD=0.14P PS=1.06U
+ PD=1.06U
M$27 Isum Isum Isum Isum nfet_03v3 L=0.64U W=0.5U AS=0.14P AD=0.14P PS=1.06U
+ PD=1.06U
M$28 Isum Isum Isum Isum nfet_03v3 L=0.64U W=0.5U AS=0.14P AD=0.3P PS=1.06U
+ PD=2.2U
M$29 Isum Isum Isum Isum nfet_03v3 L=0.64U W=0.5U AS=0.3P AD=0.14P PS=2.2U
+ PD=1.06U
M$30 Isum Isum Isum Isum nfet_03v3 L=0.64U W=0.5U AS=0.14P AD=0.14P PS=1.06U
+ PD=1.06U
M$31 Isum Isum Isum Isum nfet_03v3 L=0.64U W=0.5U AS=0.14P AD=0.14P PS=1.06U
+ PD=1.06U
M$32 Isum Isum Isum Isum nfet_03v3 L=0.64U W=0.5U AS=0.14P AD=0.14P PS=1.06U
+ PD=1.06U
M$33 Isum Isum Isum Isum nfet_03v3 L=0.64U W=0.5U AS=0.14P AD=0.14P PS=1.06U
+ PD=1.06U
M$34 Isum Isum Isum Isum nfet_03v3 L=0.64U W=0.5U AS=0.14P AD=0.14P PS=1.06U
+ PD=1.06U
M$35 Isum Isum Isum Isum nfet_03v3 L=0.64U W=0.5U AS=0.14P AD=0.14P PS=1.06U
+ PD=1.06U
M$36 Isum Isum Isum Isum nfet_03v3 L=0.64U W=0.5U AS=0.14P AD=0.3P PS=1.06U
+ PD=2.2U
M$37 VDD Vthr Isum Isum nfet_03v3 L=0.64U W=0.5U AS=0.3P AD=0.3P PS=2.2U PD=2.2U
M$38 Isum Isum Isum Isum nfet_03v3 L=0.64U W=0.5U AS=0.3P AD=0.3P PS=2.2U
+ PD=2.2U
M$39 \$1 \$1 Isum Isum nfet_03v3 L=0.64U W=0.5U AS=0.3P AD=0.3P PS=2.2U PD=2.2U
M$40 Isum Isum Isum Isum nfet_03v3 L=0.64U W=0.5U AS=0.3P AD=0.3P PS=2.2U
+ PD=2.2U
C$41 \$1 VDD 9.839048e-13 cap_mim_2f0fF A=491.9524P P=88.72U
.ENDS DPI

.SUBCKT DAC_signed_binary en s Vb w[1] w[0] VDD w[2] w[3] Isum_e Isum_i VSS
M$1 VDD s \$6 VDD pfet_03v3 L=0.32U W=0.5U AS=0.3P AD=0.3P PS=2.2U PD=2.2U
M$2 VDD VDD VDD VDD pfet_03v3 L=2U W=0.5U AS=0.3P AD=0.14P PS=2.2U PD=1.06U
M$3 VDD VDD VDD VDD pfet_03v3 L=2U W=0.5U AS=0.14P AD=0.14P PS=1.06U PD=1.06U
M$4 VDD VDD VDD VDD pfet_03v3 L=2U W=0.5U AS=0.14P AD=0.3P PS=1.06U PD=2.2U
M$5 VDD VDD VDD VDD pfet_03v3 L=2U W=0.5U AS=0.3P AD=0.14P PS=2.2U PD=1.06U
M$6 VDD VDD VDD VDD pfet_03v3 L=2U W=0.5U AS=0.14P AD=0.14P PS=1.06U PD=1.06U
M$7 VDD VDD VDD VDD pfet_03v3 L=2U W=0.5U AS=0.14P AD=0.3P PS=1.06U PD=2.2U
M$8 VDD VDD VDD VDD pfet_03v3 L=2U W=0.5U AS=0.3P AD=0.3P PS=2.2U PD=2.2U
M$9 VDD VDD VDD VDD pfet_03v3 L=2U W=0.5U AS=0.3P AD=0.3P PS=2.2U PD=2.2U
M$10 VSS VSS VSS VSS nfet_03v3 L=2U W=0.5U AS=0.3P AD=0.14P PS=2.2U PD=1.06U
M$11 VSS VSS VSS VSS nfet_03v3 L=2U W=0.5U AS=0.14P AD=0.14P PS=1.06U PD=1.06U
M$12 VSS VSS VSS VSS nfet_03v3 L=2U W=0.5U AS=0.14P AD=0.14P PS=1.06U PD=1.06U
M$13 VSS VSS VSS VSS nfet_03v3 L=2U W=0.5U AS=0.14P AD=0.14P PS=1.06U PD=1.06U
M$14 VSS VSS VSS VSS nfet_03v3 L=2U W=0.5U AS=0.14P AD=0.14P PS=1.06U PD=1.06U
M$15 VSS VSS VSS VSS nfet_03v3 L=2U W=0.5U AS=0.14P AD=0.14P PS=1.06U PD=1.06U
M$16 VSS VSS VSS VSS nfet_03v3 L=2U W=0.5U AS=0.14P AD=0.14P PS=1.06U PD=1.06U
M$17 VSS VSS VSS VSS nfet_03v3 L=2U W=0.5U AS=0.14P AD=0.14P PS=1.06U PD=1.06U
M$18 VSS VSS VSS VSS nfet_03v3 L=2U W=0.5U AS=0.14P AD=0.14P PS=1.06U PD=1.06U
M$19 VSS VSS VSS VSS nfet_03v3 L=2U W=0.5U AS=0.14P AD=0.14P PS=1.06U PD=1.06U
M$20 VSS VSS VSS VSS nfet_03v3 L=2U W=0.5U AS=0.14P AD=0.14P PS=1.06U PD=1.06U
M$21 VSS VSS VSS VSS nfet_03v3 L=2U W=0.5U AS=0.14P AD=0.14P PS=1.06U PD=1.06U
M$22 VSS VSS VSS VSS nfet_03v3 L=2U W=0.5U AS=0.14P AD=0.14P PS=1.06U PD=1.06U
M$23 VSS VSS VSS VSS nfet_03v3 L=2U W=0.5U AS=0.14P AD=0.14P PS=1.06U PD=1.06U
M$24 VSS VSS VSS VSS nfet_03v3 L=2U W=0.5U AS=0.14P AD=0.14P PS=1.06U PD=1.06U
M$25 VSS VSS VSS VSS nfet_03v3 L=2U W=0.5U AS=0.14P AD=0.14P PS=1.06U PD=1.06U
M$26 VSS VSS VSS VSS nfet_03v3 L=2U W=0.5U AS=0.14P AD=0.14P PS=1.06U PD=1.06U
M$27 VSS VSS VSS VSS nfet_03v3 L=2U W=0.5U AS=0.14P AD=0.14P PS=1.06U PD=1.06U
M$28 VSS VSS VSS VSS nfet_03v3 L=2U W=0.5U AS=0.14P AD=0.14P PS=1.06U PD=1.06U
M$29 VSS VSS VSS VSS nfet_03v3 L=2U W=0.5U AS=0.14P AD=0.14P PS=1.06U PD=1.06U
M$30 VSS VSS VSS VSS nfet_03v3 L=2U W=0.5U AS=0.14P AD=0.14P PS=1.06U PD=1.06U
M$31 VSS VSS VSS VSS nfet_03v3 L=2U W=0.5U AS=0.14P AD=0.14P PS=1.06U PD=1.06U
M$32 VSS VSS VSS VSS nfet_03v3 L=2U W=0.5U AS=0.14P AD=0.14P PS=1.06U PD=1.06U
M$33 VSS VSS VSS VSS nfet_03v3 L=2U W=0.5U AS=0.14P AD=0.14P PS=1.06U PD=1.06U
M$34 VSS VSS VSS VSS nfet_03v3 L=2U W=0.5U AS=0.14P AD=0.14P PS=1.06U PD=1.06U
M$35 VSS VSS VSS VSS nfet_03v3 L=2U W=0.5U AS=0.14P AD=0.14P PS=1.06U PD=1.06U
M$36 VSS VSS VSS VSS nfet_03v3 L=2U W=0.5U AS=0.14P AD=0.14P PS=1.06U PD=1.06U
M$37 VSS VSS VSS VSS nfet_03v3 L=2U W=0.5U AS=0.14P AD=0.14P PS=1.06U PD=1.06U
M$38 VSS VSS VSS VSS nfet_03v3 L=2U W=0.5U AS=0.14P AD=0.14P PS=1.06U PD=1.06U
M$39 VSS VSS VSS VSS nfet_03v3 L=2U W=0.5U AS=0.14P AD=0.14P PS=1.06U PD=1.06U
M$40 VSS VSS VSS VSS nfet_03v3 L=2U W=0.5U AS=0.14P AD=0.14P PS=1.06U PD=1.06U
M$41 VSS VSS VSS VSS nfet_03v3 L=2U W=0.5U AS=0.14P AD=0.14P PS=1.06U PD=1.06U
M$42 VSS VSS VSS VSS nfet_03v3 L=2U W=0.5U AS=0.14P AD=0.14P PS=1.06U PD=1.06U
M$43 VSS VSS VSS VSS nfet_03v3 L=2U W=0.5U AS=0.14P AD=0.14P PS=1.06U PD=1.06U
M$44 VSS VSS VSS VSS nfet_03v3 L=2U W=0.5U AS=0.14P AD=0.14P PS=1.06U PD=1.06U
M$45 VSS VSS VSS VSS nfet_03v3 L=2U W=0.5U AS=0.14P AD=0.14P PS=1.06U PD=1.06U
M$46 VSS VSS VSS VSS nfet_03v3 L=2U W=0.5U AS=0.14P AD=0.14P PS=1.06U PD=1.06U
M$47 VSS VSS VSS VSS nfet_03v3 L=2U W=0.5U AS=0.14P AD=0.14P PS=1.06U PD=1.06U
M$48 VSS VSS VSS VSS nfet_03v3 L=2U W=0.5U AS=0.14P AD=0.14P PS=1.06U PD=1.06U
M$49 VSS VSS VSS VSS nfet_03v3 L=2U W=0.5U AS=0.14P AD=0.14P PS=1.06U PD=1.06U
M$50 VSS VSS VSS VSS nfet_03v3 L=2U W=0.5U AS=0.14P AD=0.14P PS=1.06U PD=1.06U
M$51 VSS VSS VSS VSS nfet_03v3 L=2U W=0.5U AS=0.14P AD=0.14P PS=1.06U PD=1.06U
M$52 VSS VSS VSS VSS nfet_03v3 L=2U W=0.5U AS=0.14P AD=0.14P PS=1.06U PD=1.06U
M$53 VSS VSS VSS VSS nfet_03v3 L=2U W=0.5U AS=0.14P AD=0.14P PS=1.06U PD=1.06U
M$54 VSS VSS VSS VSS nfet_03v3 L=2U W=0.5U AS=0.14P AD=0.14P PS=1.06U PD=1.06U
M$55 VSS VSS VSS VSS nfet_03v3 L=2U W=0.5U AS=0.14P AD=0.14P PS=1.06U PD=1.06U
M$56 VSS VSS VSS VSS nfet_03v3 L=2U W=0.5U AS=0.14P AD=0.14P PS=1.06U PD=1.06U
M$57 VSS VSS VSS VSS nfet_03v3 L=2U W=0.5U AS=0.14P AD=0.14P PS=1.06U PD=1.06U
M$58 VSS VSS VSS VSS nfet_03v3 L=2U W=0.5U AS=0.14P AD=0.14P PS=1.06U PD=1.06U
M$59 VSS VSS VSS VSS nfet_03v3 L=2U W=0.5U AS=0.14P AD=0.14P PS=1.06U PD=1.06U
M$60 VSS VSS VSS VSS nfet_03v3 L=2U W=0.5U AS=0.14P AD=0.14P PS=1.06U PD=1.06U
M$61 VSS VSS VSS VSS nfet_03v3 L=2U W=0.5U AS=0.14P AD=0.14P PS=1.06U PD=1.06U
M$62 VSS VSS VSS VSS nfet_03v3 L=2U W=0.5U AS=0.14P AD=0.14P PS=1.06U PD=1.06U
M$63 VSS VSS VSS VSS nfet_03v3 L=2U W=0.5U AS=0.14P AD=0.14P PS=1.06U PD=1.06U
M$64 VSS VSS VSS VSS nfet_03v3 L=2U W=0.5U AS=0.14P AD=0.14P PS=1.06U PD=1.06U
M$65 VSS VSS VSS VSS nfet_03v3 L=2U W=0.5U AS=0.14P AD=0.14P PS=1.06U PD=1.06U
M$66 VSS VSS VSS VSS nfet_03v3 L=2U W=0.5U AS=0.14P AD=0.14P PS=1.06U PD=1.06U
M$67 VSS VSS VSS VSS nfet_03v3 L=2U W=0.5U AS=0.14P AD=0.14P PS=1.06U PD=1.06U
M$68 VSS VSS VSS VSS nfet_03v3 L=2U W=0.5U AS=0.14P AD=0.14P PS=1.06U PD=1.06U
M$69 VSS VSS VSS VSS nfet_03v3 L=2U W=0.5U AS=0.14P AD=0.14P PS=1.06U PD=1.06U
M$70 VSS VSS VSS VSS nfet_03v3 L=2U W=0.5U AS=0.14P AD=0.14P PS=1.06U PD=1.06U
M$71 VSS VSS VSS VSS nfet_03v3 L=2U W=0.5U AS=0.14P AD=0.14P PS=1.06U PD=1.06U
M$72 VSS VSS VSS VSS nfet_03v3 L=2U W=0.5U AS=0.14P AD=0.14P PS=1.06U PD=1.06U
M$73 VSS VSS VSS VSS nfet_03v3 L=2U W=0.5U AS=0.14P AD=0.14P PS=1.06U PD=1.06U
M$74 VSS VSS VSS VSS nfet_03v3 L=2U W=0.5U AS=0.14P AD=0.14P PS=1.06U PD=1.06U
M$75 VSS VSS VSS VSS nfet_03v3 L=2U W=0.5U AS=0.14P AD=0.14P PS=1.06U PD=1.06U
M$76 VSS VSS VSS VSS nfet_03v3 L=2U W=0.5U AS=0.14P AD=0.14P PS=1.06U PD=1.06U
M$77 VSS VSS VSS VSS nfet_03v3 L=2U W=0.5U AS=0.14P AD=0.14P PS=1.06U PD=1.06U
M$78 VSS VSS VSS VSS nfet_03v3 L=2U W=0.5U AS=0.14P AD=0.3P PS=1.06U PD=2.2U
M$79 VSS VSS VSS VSS nfet_03v3 L=2U W=1U AS=0.6P AD=0.6P PS=3.2U PD=3.2U
M$80 \$114 en \$113 VSS nfet_03v3 L=0.64U W=0.5U AS=0.3P AD=0.3P PS=2.2U PD=2.2U
M$81 Isum_e \$6 \$114 VSS nfet_03v3 L=0.64U W=0.5U AS=0.3P AD=0.3P PS=2.2U
+ PD=2.2U
M$82 Isum_i s \$114 VSS nfet_03v3 L=0.64U W=0.5U AS=0.3P AD=0.3P PS=2.2U PD=2.2U
M$83 \$17 Vb VSS VSS nfet_03v3 L=8U W=1U AS=0.6P AD=0.6P PS=3.2U PD=3.2U
M$84 \$16 Vb VSS VSS nfet_03v3 L=8U W=1U AS=0.6P AD=0.6P PS=3.2U PD=3.2U
M$85 \$17 Vb VSS VSS nfet_03v3 L=8U W=1U AS=0.6P AD=0.6P PS=3.2U PD=3.2U
M$86 \$15 Vb VSS VSS nfet_03v3 L=8U W=1U AS=0.6P AD=0.6P PS=3.2U PD=3.2U
M$87 \$17 Vb VSS VSS nfet_03v3 L=8U W=1U AS=0.6P AD=0.6P PS=3.2U PD=3.2U
M$88 \$16 Vb VSS VSS nfet_03v3 L=8U W=1U AS=0.6P AD=0.6P PS=3.2U PD=3.2U
M$89 \$17 Vb VSS VSS nfet_03v3 L=8U W=1U AS=0.6P AD=0.6P PS=3.2U PD=3.2U
M$90 \$14 Vb VSS VSS nfet_03v3 L=8U W=1U AS=0.6P AD=0.6P PS=3.2U PD=3.2U
M$91 \$17 Vb VSS VSS nfet_03v3 L=8U W=1U AS=0.6P AD=0.6P PS=3.2U PD=3.2U
M$92 \$16 Vb VSS VSS nfet_03v3 L=8U W=1U AS=0.6P AD=0.6P PS=3.2U PD=3.2U
M$93 \$17 Vb VSS VSS nfet_03v3 L=8U W=1U AS=0.6P AD=0.6P PS=3.2U PD=3.2U
M$94 \$15 Vb VSS VSS nfet_03v3 L=8U W=1U AS=0.6P AD=0.6P PS=3.2U PD=3.2U
M$95 \$17 Vb VSS VSS nfet_03v3 L=8U W=1U AS=0.6P AD=0.6P PS=3.2U PD=3.2U
M$96 \$16 Vb VSS VSS nfet_03v3 L=8U W=1U AS=0.6P AD=0.6P PS=3.2U PD=3.2U
M$97 \$17 Vb VSS VSS nfet_03v3 L=8U W=1U AS=0.6P AD=0.6P PS=3.2U PD=3.2U
M$98 \$6 s VSS VSS nfet_03v3 L=0.64U W=0.5U AS=0.3P AD=0.3P PS=2.2U PD=2.2U
M$99 VSS VSS VSS VSS nfet_03v3 L=2U W=1U AS=0.6P AD=0.6P PS=3.2U PD=3.2U
M$100 \$14 \$14 \$14 \$14 nfet_03v3 L=2U W=0.5U AS=0.3P AD=0.3P PS=2.2U PD=2.2U
M$101 \$14 \$14 \$14 \$14 nfet_03v3 L=2U W=0.5U AS=0.3P AD=0.14P PS=2.2U
+ PD=1.06U
M$102 \$14 \$14 \$14 \$14 nfet_03v3 L=2U W=0.5U AS=0.14P AD=0.14P PS=1.06U
+ PD=1.06U
M$103 \$14 \$14 \$14 \$14 nfet_03v3 L=2U W=0.5U AS=0.14P AD=0.3P PS=1.06U
+ PD=2.2U
M$104 \$113 w[0] \$14 \$14 nfet_03v3 L=0.64U W=0.5U AS=0.3P AD=0.3P PS=2.2U
+ PD=2.2U
M$105 \$14 \$14 \$14 \$14 nfet_03v3 L=2U W=0.5U AS=0.3P AD=0.3P PS=2.2U PD=2.2U
M$106 \$15 \$15 \$15 \$15 nfet_03v3 L=2U W=0.5U AS=0.3P AD=0.3P PS=2.2U PD=2.2U
M$107 \$15 \$15 \$15 \$15 nfet_03v3 L=2U W=0.5U AS=0.3P AD=0.14P PS=2.2U
+ PD=1.06U
M$108 \$15 \$15 \$15 \$15 nfet_03v3 L=2U W=0.5U AS=0.14P AD=0.14P PS=1.06U
+ PD=1.06U
M$109 \$15 \$15 \$15 \$15 nfet_03v3 L=2U W=0.5U AS=0.14P AD=0.14P PS=1.06U
+ PD=1.06U
M$110 \$15 \$15 \$15 \$15 nfet_03v3 L=2U W=0.5U AS=0.14P AD=0.3P PS=1.06U
+ PD=2.2U
M$111 \$113 w[1] \$15 \$15 nfet_03v3 L=0.64U W=0.5U AS=0.3P AD=0.14P PS=2.2U
+ PD=1.06U
M$112 \$15 w[1] \$113 \$15 nfet_03v3 L=0.64U W=0.5U AS=0.14P AD=0.3P PS=1.06U
+ PD=2.2U
M$113 \$15 \$15 \$15 \$15 nfet_03v3 L=2U W=0.5U AS=0.3P AD=0.3P PS=2.2U PD=2.2U
M$114 \$16 \$16 \$16 \$16 nfet_03v3 L=2U W=0.5U AS=0.3P AD=0.3P PS=2.2U PD=2.2U
M$115 \$16 \$16 \$16 \$16 nfet_03v3 L=2U W=0.5U AS=0.3P AD=0.14P PS=2.2U
+ PD=1.06U
M$116 \$16 \$16 \$16 \$16 nfet_03v3 L=2U W=0.5U AS=0.14P AD=0.14P PS=1.06U
+ PD=1.06U
M$117 \$16 \$16 \$16 \$16 nfet_03v3 L=2U W=0.5U AS=0.14P AD=0.14P PS=1.06U
+ PD=1.06U
M$118 \$16 \$16 \$16 \$16 nfet_03v3 L=2U W=0.5U AS=0.14P AD=0.14P PS=1.06U
+ PD=1.06U
M$119 \$16 \$16 \$16 \$16 nfet_03v3 L=2U W=0.5U AS=0.14P AD=0.3P PS=1.06U
+ PD=2.2U
M$120 \$113 w[2] \$16 \$16 nfet_03v3 L=0.64U W=0.5U AS=0.3P AD=0.14P PS=2.2U
+ PD=1.06U
M$121 \$16 w[2] \$113 \$16 nfet_03v3 L=0.64U W=0.5U AS=0.14P AD=0.14P PS=1.06U
+ PD=1.06U
M$122 \$113 w[2] \$16 \$16 nfet_03v3 L=0.64U W=0.5U AS=0.14P AD=0.14P PS=1.06U
+ PD=1.06U
M$123 \$16 w[2] \$113 \$16 nfet_03v3 L=0.64U W=0.5U AS=0.14P AD=0.3P PS=1.06U
+ PD=2.2U
M$124 \$16 \$16 \$16 \$16 nfet_03v3 L=2U W=0.5U AS=0.3P AD=0.3P PS=2.2U PD=2.2U
M$125 \$17 \$17 \$17 \$17 nfet_03v3 L=2U W=0.5U AS=0.3P AD=0.3P PS=2.2U PD=2.2U
M$126 \$17 \$17 \$17 \$17 nfet_03v3 L=2U W=0.5U AS=0.3P AD=0.14P PS=2.2U
+ PD=1.06U
M$127 \$17 \$17 \$17 \$17 nfet_03v3 L=2U W=0.5U AS=0.14P AD=0.14P PS=1.06U
+ PD=1.06U
M$128 \$17 \$17 \$17 \$17 nfet_03v3 L=2U W=0.5U AS=0.14P AD=0.14P PS=1.06U
+ PD=1.06U
M$129 \$17 \$17 \$17 \$17 nfet_03v3 L=2U W=0.5U AS=0.14P AD=0.14P PS=1.06U
+ PD=1.06U
M$130 \$17 \$17 \$17 \$17 nfet_03v3 L=2U W=0.5U AS=0.14P AD=0.14P PS=1.06U
+ PD=1.06U
M$131 \$17 \$17 \$17 \$17 nfet_03v3 L=2U W=0.5U AS=0.14P AD=0.14P PS=1.06U
+ PD=1.06U
M$132 \$17 \$17 \$17 \$17 nfet_03v3 L=2U W=0.5U AS=0.14P AD=0.3P PS=1.06U
+ PD=2.2U
M$133 \$113 w[3] \$17 \$17 nfet_03v3 L=0.64U W=0.5U AS=0.3P AD=0.14P PS=2.2U
+ PD=1.06U
M$134 \$17 w[3] \$113 \$17 nfet_03v3 L=0.64U W=0.5U AS=0.14P AD=0.14P PS=1.06U
+ PD=1.06U
M$135 \$113 w[3] \$17 \$17 nfet_03v3 L=0.64U W=0.5U AS=0.14P AD=0.14P PS=1.06U
+ PD=1.06U
M$136 \$17 w[3] \$113 \$17 nfet_03v3 L=0.64U W=0.5U AS=0.14P AD=0.14P PS=1.06U
+ PD=1.06U
M$137 \$113 w[3] \$17 \$17 nfet_03v3 L=0.64U W=0.5U AS=0.14P AD=0.14P PS=1.06U
+ PD=1.06U
M$138 \$17 w[3] \$113 \$17 nfet_03v3 L=0.64U W=0.5U AS=0.14P AD=0.14P PS=1.06U
+ PD=1.06U
M$139 \$113 w[3] \$17 \$17 nfet_03v3 L=0.64U W=0.5U AS=0.14P AD=0.14P PS=1.06U
+ PD=1.06U
M$140 \$17 w[3] \$113 \$17 nfet_03v3 L=0.64U W=0.5U AS=0.14P AD=0.3P PS=1.06U
+ PD=2.2U
M$141 \$17 \$17 \$17 \$17 nfet_03v3 L=2U W=0.5U AS=0.3P AD=0.3P PS=2.2U PD=2.2U
M$142 VSS VSS VSS VSS nfet_03v3 L=2U W=0.5U AS=0.3P AD=0.14P PS=2.2U PD=1.06U
M$143 VSS VSS VSS VSS nfet_03v3 L=2U W=0.5U AS=0.14P AD=0.14P PS=1.06U PD=1.06U
M$144 VSS VSS VSS VSS nfet_03v3 L=2U W=0.5U AS=0.14P AD=0.14P PS=1.06U PD=1.06U
M$145 VSS VSS VSS VSS nfet_03v3 L=2U W=0.5U AS=0.14P AD=0.14P PS=1.06U PD=1.06U
M$146 VSS VSS VSS VSS nfet_03v3 L=2U W=0.5U AS=0.14P AD=0.14P PS=1.06U PD=1.06U
M$147 VSS VSS VSS VSS nfet_03v3 L=2U W=0.5U AS=0.14P AD=0.14P PS=1.06U PD=1.06U
M$148 VSS VSS VSS VSS nfet_03v3 L=2U W=0.5U AS=0.14P AD=0.14P PS=1.06U PD=1.06U
M$149 VSS VSS VSS VSS nfet_03v3 L=2U W=0.5U AS=0.14P AD=0.14P PS=1.06U PD=1.06U
M$150 VSS VSS VSS VSS nfet_03v3 L=2U W=0.5U AS=0.14P AD=0.14P PS=1.06U PD=1.06U
M$151 VSS VSS VSS VSS nfet_03v3 L=2U W=0.5U AS=0.14P AD=0.14P PS=1.06U PD=1.06U
M$152 VSS VSS VSS VSS nfet_03v3 L=2U W=0.5U AS=0.14P AD=0.14P PS=1.06U PD=1.06U
M$153 VSS VSS VSS VSS nfet_03v3 L=2U W=0.5U AS=0.14P AD=0.14P PS=1.06U PD=1.06U
M$154 VSS VSS VSS VSS nfet_03v3 L=2U W=0.5U AS=0.14P AD=0.14P PS=1.06U PD=1.06U
M$155 VSS VSS VSS VSS nfet_03v3 L=2U W=0.5U AS=0.14P AD=0.14P PS=1.06U PD=1.06U
M$156 VSS VSS VSS VSS nfet_03v3 L=2U W=0.5U AS=0.14P AD=0.14P PS=1.06U PD=1.06U
M$157 VSS VSS VSS VSS nfet_03v3 L=2U W=0.5U AS=0.14P AD=0.14P PS=1.06U PD=1.06U
M$158 VSS VSS VSS VSS nfet_03v3 L=2U W=0.5U AS=0.14P AD=0.14P PS=1.06U PD=1.06U
M$159 VSS VSS VSS VSS nfet_03v3 L=2U W=0.5U AS=0.14P AD=0.14P PS=1.06U PD=1.06U
M$160 VSS VSS VSS VSS nfet_03v3 L=2U W=0.5U AS=0.14P AD=0.14P PS=1.06U PD=1.06U
M$161 VSS VSS VSS VSS nfet_03v3 L=2U W=0.5U AS=0.14P AD=0.14P PS=1.06U PD=1.06U
M$162 VSS VSS VSS VSS nfet_03v3 L=2U W=0.5U AS=0.14P AD=0.14P PS=1.06U PD=1.06U
M$163 VSS VSS VSS VSS nfet_03v3 L=2U W=0.5U AS=0.14P AD=0.14P PS=1.06U PD=1.06U
M$164 VSS VSS VSS VSS nfet_03v3 L=2U W=0.5U AS=0.14P AD=0.14P PS=1.06U PD=1.06U
M$165 VSS VSS VSS VSS nfet_03v3 L=2U W=0.5U AS=0.14P AD=0.14P PS=1.06U PD=1.06U
M$166 VSS VSS VSS VSS nfet_03v3 L=2U W=0.5U AS=0.14P AD=0.14P PS=1.06U PD=1.06U
M$167 VSS VSS VSS VSS nfet_03v3 L=2U W=0.5U AS=0.14P AD=0.14P PS=1.06U PD=1.06U
M$168 VSS VSS VSS VSS nfet_03v3 L=2U W=0.5U AS=0.14P AD=0.14P PS=1.06U PD=1.06U
M$169 VSS VSS VSS VSS nfet_03v3 L=2U W=0.5U AS=0.14P AD=0.14P PS=1.06U PD=1.06U
M$170 VSS VSS VSS VSS nfet_03v3 L=2U W=0.5U AS=0.14P AD=0.14P PS=1.06U PD=1.06U
M$171 VSS VSS VSS VSS nfet_03v3 L=2U W=0.5U AS=0.14P AD=0.14P PS=1.06U PD=1.06U
M$172 VSS VSS VSS VSS nfet_03v3 L=2U W=0.5U AS=0.14P AD=0.14P PS=1.06U PD=1.06U
M$173 VSS VSS VSS VSS nfet_03v3 L=2U W=0.5U AS=0.14P AD=0.14P PS=1.06U PD=1.06U
M$174 VSS VSS VSS VSS nfet_03v3 L=2U W=0.5U AS=0.14P AD=0.14P PS=1.06U PD=1.06U
M$175 VSS VSS VSS VSS nfet_03v3 L=2U W=0.5U AS=0.14P AD=0.14P PS=1.06U PD=1.06U
M$176 VSS VSS VSS VSS nfet_03v3 L=2U W=0.5U AS=0.14P AD=0.14P PS=1.06U PD=1.06U
M$177 VSS VSS VSS VSS nfet_03v3 L=2U W=0.5U AS=0.14P AD=0.14P PS=1.06U PD=1.06U
M$178 VSS VSS VSS VSS nfet_03v3 L=2U W=0.5U AS=0.14P AD=0.14P PS=1.06U PD=1.06U
M$179 VSS VSS VSS VSS nfet_03v3 L=2U W=0.5U AS=0.14P AD=0.14P PS=1.06U PD=1.06U
M$180 VSS VSS VSS VSS nfet_03v3 L=2U W=0.5U AS=0.14P AD=0.14P PS=1.06U PD=1.06U
M$181 VSS VSS VSS VSS nfet_03v3 L=2U W=0.5U AS=0.14P AD=0.14P PS=1.06U PD=1.06U
M$182 VSS VSS VSS VSS nfet_03v3 L=2U W=0.5U AS=0.14P AD=0.14P PS=1.06U PD=1.06U
M$183 VSS VSS VSS VSS nfet_03v3 L=2U W=0.5U AS=0.14P AD=0.14P PS=1.06U PD=1.06U
M$184 VSS VSS VSS VSS nfet_03v3 L=2U W=0.5U AS=0.14P AD=0.14P PS=1.06U PD=1.06U
M$185 VSS VSS VSS VSS nfet_03v3 L=2U W=0.5U AS=0.14P AD=0.14P PS=1.06U PD=1.06U
M$186 VSS VSS VSS VSS nfet_03v3 L=2U W=0.5U AS=0.14P AD=0.14P PS=1.06U PD=1.06U
M$187 VSS VSS VSS VSS nfet_03v3 L=2U W=0.5U AS=0.14P AD=0.14P PS=1.06U PD=1.06U
M$188 VSS VSS VSS VSS nfet_03v3 L=2U W=0.5U AS=0.14P AD=0.14P PS=1.06U PD=1.06U
M$189 VSS VSS VSS VSS nfet_03v3 L=2U W=0.5U AS=0.14P AD=0.14P PS=1.06U PD=1.06U
M$190 VSS VSS VSS VSS nfet_03v3 L=2U W=0.5U AS=0.14P AD=0.14P PS=1.06U PD=1.06U
M$191 VSS VSS VSS VSS nfet_03v3 L=2U W=0.5U AS=0.14P AD=0.14P PS=1.06U PD=1.06U
M$192 VSS VSS VSS VSS nfet_03v3 L=2U W=0.5U AS=0.14P AD=0.14P PS=1.06U PD=1.06U
M$193 VSS VSS VSS VSS nfet_03v3 L=2U W=0.5U AS=0.14P AD=0.14P PS=1.06U PD=1.06U
M$194 VSS VSS VSS VSS nfet_03v3 L=2U W=0.5U AS=0.14P AD=0.14P PS=1.06U PD=1.06U
M$195 VSS VSS VSS VSS nfet_03v3 L=2U W=0.5U AS=0.14P AD=0.14P PS=1.06U PD=1.06U
M$196 VSS VSS VSS VSS nfet_03v3 L=2U W=0.5U AS=0.14P AD=0.14P PS=1.06U PD=1.06U
M$197 VSS VSS VSS VSS nfet_03v3 L=2U W=0.5U AS=0.14P AD=0.14P PS=1.06U PD=1.06U
M$198 VSS VSS VSS VSS nfet_03v3 L=2U W=0.5U AS=0.14P AD=0.14P PS=1.06U PD=1.06U
M$199 VSS VSS VSS VSS nfet_03v3 L=2U W=0.5U AS=0.14P AD=0.14P PS=1.06U PD=1.06U
M$200 VSS VSS VSS VSS nfet_03v3 L=2U W=0.5U AS=0.14P AD=0.14P PS=1.06U PD=1.06U
M$201 VSS VSS VSS VSS nfet_03v3 L=2U W=0.5U AS=0.14P AD=0.14P PS=1.06U PD=1.06U
M$202 VSS VSS VSS VSS nfet_03v3 L=2U W=0.5U AS=0.14P AD=0.14P PS=1.06U PD=1.06U
M$203 VSS VSS VSS VSS nfet_03v3 L=2U W=0.5U AS=0.14P AD=0.14P PS=1.06U PD=1.06U
M$204 VSS VSS VSS VSS nfet_03v3 L=2U W=0.5U AS=0.14P AD=0.14P PS=1.06U PD=1.06U
M$205 VSS VSS VSS VSS nfet_03v3 L=2U W=0.5U AS=0.14P AD=0.14P PS=1.06U PD=1.06U
M$206 VSS VSS VSS VSS nfet_03v3 L=2U W=0.5U AS=0.14P AD=0.14P PS=1.06U PD=1.06U
M$207 VSS VSS VSS VSS nfet_03v3 L=2U W=0.5U AS=0.14P AD=0.14P PS=1.06U PD=1.06U
M$208 VSS VSS VSS VSS nfet_03v3 L=2U W=0.5U AS=0.14P AD=0.14P PS=1.06U PD=1.06U
M$209 VSS VSS VSS VSS nfet_03v3 L=2U W=0.5U AS=0.14P AD=0.14P PS=1.06U PD=1.06U
M$210 VSS VSS VSS VSS nfet_03v3 L=2U W=0.5U AS=0.14P AD=0.3P PS=1.06U PD=2.2U
M$211 \$14 \$14 \$14 \$14 nfet_03v3 L=2U W=0.5U AS=0.3P AD=0.14P PS=2.2U
+ PD=1.06U
M$212 \$14 \$14 \$14 \$14 nfet_03v3 L=2U W=0.5U AS=0.14P AD=0.14P PS=1.06U
+ PD=1.06U
M$213 \$14 \$14 \$14 \$14 nfet_03v3 L=2U W=0.5U AS=0.14P AD=0.3P PS=1.06U
+ PD=2.2U
M$214 \$15 \$15 \$15 \$15 nfet_03v3 L=2U W=0.5U AS=0.3P AD=0.14P PS=2.2U
+ PD=1.06U
M$215 \$15 \$15 \$15 \$15 nfet_03v3 L=2U W=0.5U AS=0.14P AD=0.14P PS=1.06U
+ PD=1.06U
M$216 \$15 \$15 \$15 \$15 nfet_03v3 L=2U W=0.5U AS=0.14P AD=0.14P PS=1.06U
+ PD=1.06U
M$217 \$15 \$15 \$15 \$15 nfet_03v3 L=2U W=0.5U AS=0.14P AD=0.3P PS=1.06U
+ PD=2.2U
M$218 \$16 \$16 \$16 \$16 nfet_03v3 L=2U W=0.5U AS=0.3P AD=0.14P PS=2.2U
+ PD=1.06U
M$219 \$16 \$16 \$16 \$16 nfet_03v3 L=2U W=0.5U AS=0.14P AD=0.14P PS=1.06U
+ PD=1.06U
M$220 \$16 \$16 \$16 \$16 nfet_03v3 L=2U W=0.5U AS=0.14P AD=0.14P PS=1.06U
+ PD=1.06U
M$221 \$16 \$16 \$16 \$16 nfet_03v3 L=2U W=0.5U AS=0.14P AD=0.14P PS=1.06U
+ PD=1.06U
M$222 \$16 \$16 \$16 \$16 nfet_03v3 L=2U W=0.5U AS=0.14P AD=0.3P PS=1.06U
+ PD=2.2U
M$223 \$17 \$17 \$17 \$17 nfet_03v3 L=2U W=0.5U AS=0.3P AD=0.14P PS=2.2U
+ PD=1.06U
M$224 \$17 \$17 \$17 \$17 nfet_03v3 L=2U W=0.5U AS=0.14P AD=0.14P PS=1.06U
+ PD=1.06U
M$225 \$17 \$17 \$17 \$17 nfet_03v3 L=2U W=0.5U AS=0.14P AD=0.14P PS=1.06U
+ PD=1.06U
M$226 \$17 \$17 \$17 \$17 nfet_03v3 L=2U W=0.5U AS=0.14P AD=0.14P PS=1.06U
+ PD=1.06U
M$227 \$17 \$17 \$17 \$17 nfet_03v3 L=2U W=0.5U AS=0.14P AD=0.14P PS=1.06U
+ PD=1.06U
M$228 \$17 \$17 \$17 \$17 nfet_03v3 L=2U W=0.5U AS=0.14P AD=0.14P PS=1.06U
+ PD=1.06U
M$229 \$17 \$17 \$17 \$17 nfet_03v3 L=2U W=0.5U AS=0.14P AD=0.3P PS=1.06U
+ PD=2.2U
.ENDS DAC_signed_binary
