* Extracted by KLayout with GF180MCU LVS runset on : 28/11/2026 05:12

.SUBCKT SNN_signed
X$1 spike[1] s[3] \$60 w[12] w[13] VDD \$72 \$73 w[14] w[15] VSS DAC
X$2 trim[0] trim[1] trim[2] cal trim[3] \$80 VDD \$82 VSS trim_steer
X$3 spike[3] s[7] \$60 w[28] w[29] VDD \$78 \$79 w[30] w[31] VSS DAC
X$4 spike[1] s[5] \$60 w[20] w[21] VDD \$75 \$76 w[22] w[23] VSS DAC
X$5 pulse[0] s[0] \$60 w[0] w[1] VDD \$65 VDD w[2] w[3] VSS DAC
X$6 \$58 VT \$61 \$62 \$63 \$64 VDD \$59 spike[0] \$67 \$68 VSS neuron
X$7 \$58 VT \$61 \$62 \$63 \$64 VDD \$77 spike[4] \$67 \$68 VSS neuron
X$8 \$58 VT \$61 \$62 \$63 \$64 VDD \$69 spike[1] \$67 \$68 VSS neuron
X$9 \$58 VT \$61 \$62 \$63 \$64 VDD \$74 spike[3] \$67 \$68 VSS neuron
X$10 \$58 VT \$61 \$62 \$63 \$64 VDD \$71 spike[2] \$67 \$68 VSS neuron
X$11 spike[0] s[4] \$60 w[16] w[17] VDD \$75 \$76 w[18] w[19] VSS DAC
X$12 spike[0] s[2] \$60 w[8] w[9] VDD \$72 \$73 w[10] w[11] VSS DAC
X$13 spike[2] s[6] \$60 w[24] w[25] VDD \$78 \$79 w[26] w[27] VSS DAC
X$14 pulse[1] s[1] \$60 w[4] w[5] VDD \$70 VDD w[6] w[7] VSS DAC
X$15 VDD \$65 \$66 \$59 \$57 VSS DPI
X$16 VDD \$73 \$66 \$71 \$57 VSS DPI_inh
X$17 \$58 \$62 \$80 Imon \$68 \$60 \$64 \$61 \$63 VDD \$67 \$81 \$66 \$57 VSS
+ bias
X$18 \$82 VDD VSS bias_master
X$19 VDD \$76 \$66 \$74 \$57 VSS DPI_inh
X$20 VDD \$79 \$66 \$77 \$57 VSS DPI_inh
X$21 VDD \$70 \$66 \$69 \$57 VSS DPI
X$22 VDD \$72 \$66 \$71 \$57 VSS DPI
X$23 VDD \$75 \$66 \$74 \$57 VSS DPI
X$24 VDD \$78 \$66 \$77 \$57 VSS DPI
.ENDS SNN_signed

.SUBCKT bias_master Iref VDD VSS
M$1 VDD VDD VDD VDD pfet_03v3 L=2U W=0.5U AS=0.14P AD=0.14P PS=1.06U PD=1.06U
M$2 VDD VDD VDD VDD pfet_03v3 L=2U W=0.5U AS=0.14P AD=0.14P PS=1.06U PD=1.06U
M$3 VDD VDD VDD VDD pfet_03v3 L=2U W=0.5U AS=0.14P AD=0.14P PS=1.06U PD=1.06U
M$4 VDD VDD VDD VDD pfet_03v3 L=2U W=0.5U AS=0.14P AD=0.14P PS=1.06U PD=1.06U
M$5 VDD VDD VDD VDD pfet_03v3 L=2U W=0.5U AS=0.14P AD=0.14P PS=1.06U PD=1.06U
M$6 VDD VDD VDD VDD pfet_03v3 L=2U W=0.5U AS=0.14P AD=0.14P PS=1.06U PD=1.06U
M$7 VDD VDD VDD VDD pfet_03v3 L=2U W=0.5U AS=0.14P AD=0.14P PS=1.06U PD=1.06U
M$8 VDD VDD VDD VDD pfet_03v3 L=2U W=0.5U AS=0.14P AD=0.14P PS=1.06U PD=1.06U
M$9 VDD VDD VDD VDD pfet_03v3 L=2U W=0.5U AS=0.14P AD=0.14P PS=1.06U PD=1.06U
M$10 VDD VDD VDD VDD pfet_03v3 L=2U W=0.5U AS=0.14P AD=0.14P PS=1.06U PD=1.06U
M$11 VDD VDD VDD VDD pfet_03v3 L=2U W=0.5U AS=0.14P AD=0.14P PS=1.06U PD=1.06U
M$12 VDD VDD VDD VDD pfet_03v3 L=2U W=0.5U AS=0.14P AD=0.14P PS=1.06U PD=1.06U
M$13 VDD VDD VDD VDD pfet_03v3 L=2U W=0.5U AS=0.14P AD=0.14P PS=1.06U PD=1.06U
M$14 VDD VDD VDD VDD pfet_03v3 L=2U W=0.5U AS=0.14P AD=0.14P PS=1.06U PD=1.06U
M$15 VDD VDD VDD VDD pfet_03v3 L=2U W=0.5U AS=0.14P AD=0.14P PS=1.06U PD=1.06U
M$16 VDD VDD VDD VDD pfet_03v3 L=2U W=0.5U AS=0.14P AD=0.14P PS=1.06U PD=1.06U
M$17 VDD VDD VDD VDD pfet_03v3 L=2U W=0.5U AS=0.14P AD=0.14P PS=1.06U PD=1.06U
M$18 VDD VDD VDD VDD pfet_03v3 L=2U W=0.5U AS=0.14P AD=0.14P PS=1.06U PD=1.06U
M$19 VDD VDD VDD VDD pfet_03v3 L=2U W=0.5U AS=0.14P AD=0.14P PS=1.06U PD=1.06U
M$20 VDD VDD VDD VDD pfet_03v3 L=2U W=0.5U AS=0.14P AD=0.14P PS=1.06U PD=1.06U
M$21 VDD VDD VDD VDD pfet_03v3 L=2U W=0.5U AS=0.14P AD=0.14P PS=1.06U PD=1.06U
M$22 VDD VDD VDD VDD pfet_03v3 L=2U W=0.5U AS=0.14P AD=0.14P PS=1.06U PD=1.06U
M$23 VDD VDD VDD VDD pfet_03v3 L=2U W=0.5U AS=0.14P AD=0.14P PS=1.06U PD=1.06U
M$24 VDD VDD VDD VDD pfet_03v3 L=2U W=0.5U AS=0.14P AD=0.14P PS=1.06U PD=1.06U
M$25 VDD VDD VDD VDD pfet_03v3 L=2U W=0.5U AS=0.14P AD=0.14P PS=1.06U PD=1.06U
M$26 VDD VDD VDD VDD pfet_03v3 L=2U W=0.5U AS=0.14P AD=0.14P PS=1.06U PD=1.06U
M$27 VDD VDD VDD VDD pfet_03v3 L=2U W=0.5U AS=0.14P AD=0.14P PS=1.06U PD=1.06U
M$28 VDD VDD VDD VDD pfet_03v3 L=2U W=0.5U AS=0.14P AD=0.14P PS=1.06U PD=1.06U
M$29 VDD VDD VDD VDD pfet_03v3 L=2U W=0.5U AS=0.14P AD=0.14P PS=1.06U PD=1.06U
M$30 VDD VDD VDD VDD pfet_03v3 L=2U W=0.5U AS=0.14P AD=0.14P PS=1.06U PD=1.06U
M$31 VDD VDD VDD VDD pfet_03v3 L=2U W=0.5U AS=0.14P AD=0.14P PS=1.06U PD=1.06U
M$32 VDD VDD VDD VDD pfet_03v3 L=2U W=0.5U AS=0.14P AD=0.14P PS=1.06U PD=1.06U
M$33 VDD VDD VDD VDD pfet_03v3 L=2U W=0.5U AS=0.14P AD=0.14P PS=1.06U PD=1.06U
M$34 VDD VDD VDD VDD pfet_03v3 L=2U W=0.5U AS=0.14P AD=0.14P PS=1.06U PD=1.06U
M$35 VDD VDD VDD VDD pfet_03v3 L=2U W=0.5U AS=0.14P AD=0.14P PS=1.06U PD=1.06U
M$36 VDD VDD VDD VDD pfet_03v3 L=2U W=0.5U AS=0.14P AD=0.14P PS=1.06U PD=1.06U
M$37 VDD VDD VDD VDD pfet_03v3 L=2U W=0.5U AS=0.14P AD=0.14P PS=1.06U PD=1.06U
M$38 VDD VDD VDD VDD pfet_03v3 L=2U W=0.5U AS=0.14P AD=0.14P PS=1.06U PD=1.06U
M$39 VDD VDD VDD VDD pfet_03v3 L=2U W=0.5U AS=0.14P AD=0.14P PS=1.06U PD=1.06U
M$40 VDD VDD VDD VDD pfet_03v3 L=2U W=0.5U AS=0.14P AD=0.14P PS=1.06U PD=1.06U
M$41 VDD VDD VDD VDD pfet_03v3 L=2U W=0.5U AS=0.14P AD=0.14P PS=1.06U PD=1.06U
M$42 VDD VDD VDD VDD pfet_03v3 L=2U W=0.5U AS=0.14P AD=0.14P PS=1.06U PD=1.06U
M$43 VDD VDD VDD VDD pfet_03v3 L=2U W=0.5U AS=0.14P AD=0.14P PS=1.06U PD=1.06U
M$44 VDD VDD VDD VDD pfet_03v3 L=2U W=0.5U AS=0.14P AD=0.14P PS=1.06U PD=1.06U
M$45 VDD VDD VDD VDD pfet_03v3 L=2U W=0.5U AS=0.14P AD=0.14P PS=1.06U PD=1.06U
M$46 VDD VDD VDD VDD pfet_03v3 L=2U W=0.5U AS=0.14P AD=0.14P PS=1.06U PD=1.06U
M$47 VDD VDD VDD VDD pfet_03v3 L=2U W=0.5U AS=0.14P AD=0.14P PS=1.06U PD=1.06U
M$48 VDD VDD VDD VDD pfet_03v3 L=2U W=0.5U AS=0.14P AD=0.14P PS=1.06U PD=1.06U
M$49 VDD VDD VDD VDD pfet_03v3 L=2U W=0.5U AS=0.14P AD=0.14P PS=1.06U PD=1.06U
M$50 VDD VDD VDD VDD pfet_03v3 L=2U W=0.5U AS=0.14P AD=0.14P PS=1.06U PD=1.06U
M$51 VDD VDD VDD VDD pfet_03v3 L=2U W=0.5U AS=0.14P AD=0.14P PS=1.06U PD=1.06U
M$52 VDD VDD VDD VDD pfet_03v3 L=2U W=0.5U AS=0.14P AD=0.14P PS=1.06U PD=1.06U
M$53 VDD VDD VDD VDD pfet_03v3 L=2U W=0.5U AS=0.14P AD=0.14P PS=1.06U PD=1.06U
M$54 VDD VDD VDD VDD pfet_03v3 L=2U W=0.5U AS=0.14P AD=0.3P PS=1.06U PD=2.2U
M$55 VDD VDD VDD VDD pfet_03v3 L=2U W=0.5U AS=0.14P AD=0.14P PS=1.06U PD=1.06U
M$56 VDD VDD VDD VDD pfet_03v3 L=2U W=0.5U AS=0.14P AD=0.14P PS=1.06U PD=1.06U
M$57 VDD VDD VDD VDD pfet_03v3 L=2U W=0.5U AS=0.14P AD=0.14P PS=1.06U PD=1.06U
M$58 VDD VDD VDD VDD pfet_03v3 L=2U W=0.5U AS=0.14P AD=0.14P PS=1.06U PD=1.06U
M$59 VDD VDD VDD VDD pfet_03v3 L=2U W=0.5U AS=0.14P AD=0.14P PS=1.06U PD=1.06U
M$60 VDD VDD VDD VDD pfet_03v3 L=2U W=0.5U AS=0.14P AD=0.14P PS=1.06U PD=1.06U
M$61 VDD VDD VDD VDD pfet_03v3 L=2U W=0.5U AS=0.14P AD=0.14P PS=1.06U PD=1.06U
M$62 VDD VDD VDD VDD pfet_03v3 L=2U W=0.5U AS=0.14P AD=0.14P PS=1.06U PD=1.06U
M$63 VDD VDD VDD VDD pfet_03v3 L=2U W=0.5U AS=0.14P AD=0.14P PS=1.06U PD=1.06U
M$64 VDD VDD VDD VDD pfet_03v3 L=2U W=0.5U AS=0.14P AD=0.14P PS=1.06U PD=1.06U
M$65 VDD VDD VDD VDD pfet_03v3 L=2U W=0.5U AS=0.14P AD=0.14P PS=1.06U PD=1.06U
M$66 VDD VDD VDD VDD pfet_03v3 L=2U W=0.5U AS=0.14P AD=0.14P PS=1.06U PD=1.06U
M$67 VDD VDD VDD VDD pfet_03v3 L=2U W=0.5U AS=0.14P AD=0.14P PS=1.06U PD=1.06U
M$68 VDD VDD VDD VDD pfet_03v3 L=2U W=0.5U AS=0.14P AD=0.14P PS=1.06U PD=1.06U
M$69 VDD VDD VDD VDD pfet_03v3 L=2U W=0.5U AS=0.14P AD=0.14P PS=1.06U PD=1.06U
M$70 VDD VDD VDD VDD pfet_03v3 L=2U W=0.5U AS=0.14P AD=0.14P PS=1.06U PD=1.06U
M$71 VDD VDD VDD VDD pfet_03v3 L=2U W=0.5U AS=0.14P AD=0.14P PS=1.06U PD=1.06U
M$72 VDD VDD VDD VDD pfet_03v3 L=2U W=0.5U AS=0.14P AD=0.14P PS=1.06U PD=1.06U
M$73 VDD VDD VDD VDD pfet_03v3 L=2U W=0.5U AS=0.14P AD=0.14P PS=1.06U PD=1.06U
M$74 VDD VDD VDD VDD pfet_03v3 L=2U W=0.5U AS=0.14P AD=0.14P PS=1.06U PD=1.06U
M$75 VDD VDD VDD VDD pfet_03v3 L=2U W=0.5U AS=0.14P AD=0.14P PS=1.06U PD=1.06U
M$76 VDD VDD VDD VDD pfet_03v3 L=2U W=0.5U AS=0.14P AD=0.14P PS=1.06U PD=1.06U
M$77 VDD VDD VDD VDD pfet_03v3 L=2U W=0.5U AS=0.14P AD=0.14P PS=1.06U PD=1.06U
M$78 VDD VDD VDD VDD pfet_03v3 L=2U W=0.5U AS=0.14P AD=0.14P PS=1.06U PD=1.06U
M$79 VDD VDD VDD VDD pfet_03v3 L=2U W=0.5U AS=0.14P AD=0.14P PS=1.06U PD=1.06U
M$80 VDD VDD VDD VDD pfet_03v3 L=2U W=0.5U AS=0.14P AD=0.14P PS=1.06U PD=1.06U
M$81 VDD VDD VDD VDD pfet_03v3 L=2U W=0.5U AS=0.14P AD=0.14P PS=1.06U PD=1.06U
M$82 VDD VDD VDD VDD pfet_03v3 L=2U W=0.5U AS=0.14P AD=0.14P PS=1.06U PD=1.06U
M$83 VDD VDD VDD VDD pfet_03v3 L=2U W=0.5U AS=0.14P AD=0.14P PS=1.06U PD=1.06U
M$84 VDD VDD VDD VDD pfet_03v3 L=2U W=0.5U AS=0.14P AD=0.14P PS=1.06U PD=1.06U
M$85 VDD VDD VDD VDD pfet_03v3 L=2U W=0.5U AS=0.14P AD=0.14P PS=1.06U PD=1.06U
M$86 VDD VDD VDD VDD pfet_03v3 L=2U W=0.5U AS=0.14P AD=0.14P PS=1.06U PD=1.06U
M$87 VDD VDD VDD VDD pfet_03v3 L=2U W=0.5U AS=0.14P AD=0.14P PS=1.06U PD=1.06U
M$88 VDD VDD VDD VDD pfet_03v3 L=2U W=0.5U AS=0.14P AD=0.14P PS=1.06U PD=1.06U
M$89 VDD VDD VDD VDD pfet_03v3 L=2U W=0.5U AS=0.14P AD=0.14P PS=1.06U PD=1.06U
M$90 VDD VDD VDD VDD pfet_03v3 L=2U W=0.5U AS=0.14P AD=0.14P PS=1.06U PD=1.06U
M$91 VDD VDD VDD VDD pfet_03v3 L=2U W=0.5U AS=0.14P AD=0.14P PS=1.06U PD=1.06U
M$92 VDD VDD VDD VDD pfet_03v3 L=2U W=0.5U AS=0.14P AD=0.14P PS=1.06U PD=1.06U
M$93 VDD VDD VDD VDD pfet_03v3 L=2U W=0.5U AS=0.14P AD=0.14P PS=1.06U PD=1.06U
M$94 VDD VDD VDD VDD pfet_03v3 L=2U W=0.5U AS=0.14P AD=0.14P PS=1.06U PD=1.06U
M$95 VDD VDD VDD VDD pfet_03v3 L=2U W=0.5U AS=0.14P AD=0.14P PS=1.06U PD=1.06U
M$96 VDD VDD VDD VDD pfet_03v3 L=2U W=0.5U AS=0.14P AD=0.14P PS=1.06U PD=1.06U
M$97 VDD VDD VDD VDD pfet_03v3 L=2U W=0.5U AS=0.14P AD=0.14P PS=1.06U PD=1.06U
M$98 VDD VDD VDD VDD pfet_03v3 L=2U W=0.5U AS=0.14P AD=0.14P PS=1.06U PD=1.06U
M$99 VDD VDD VDD VDD pfet_03v3 L=2U W=0.5U AS=0.14P AD=0.14P PS=1.06U PD=1.06U
M$100 VDD VDD VDD VDD pfet_03v3 L=2U W=0.5U AS=0.14P AD=0.14P PS=1.06U PD=1.06U
M$101 VDD VDD VDD VDD pfet_03v3 L=2U W=0.5U AS=0.14P AD=0.14P PS=1.06U PD=1.06U
M$102 VDD VDD VDD VDD pfet_03v3 L=2U W=0.5U AS=0.14P AD=0.14P PS=1.06U PD=1.06U
M$103 VDD VDD VDD VDD pfet_03v3 L=2U W=0.5U AS=0.14P AD=0.14P PS=1.06U PD=1.06U
M$104 VDD VDD VDD VDD pfet_03v3 L=2U W=0.5U AS=0.14P AD=0.14P PS=1.06U PD=1.06U
M$105 VDD VDD VDD VDD pfet_03v3 L=2U W=0.5U AS=0.14P AD=0.14P PS=1.06U PD=1.06U
M$106 VDD VDD VDD VDD pfet_03v3 L=2U W=0.5U AS=0.14P AD=0.14P PS=1.06U PD=1.06U
M$107 VDD VDD VDD VDD pfet_03v3 L=2U W=0.5U AS=0.14P AD=0.14P PS=1.06U PD=1.06U
M$108 VDD VDD VDD VDD pfet_03v3 L=2U W=0.5U AS=0.14P AD=0.14P PS=1.06U PD=1.06U
M$109 VDD VDD VDD VDD pfet_03v3 L=2U W=0.5U AS=0.14P AD=0.14P PS=1.06U PD=1.06U
M$110 VDD VDD VDD VDD pfet_03v3 L=2U W=0.5U AS=0.14P AD=0.14P PS=1.06U PD=1.06U
M$111 VDD VDD VDD VDD pfet_03v3 L=2U W=0.5U AS=0.14P AD=0.14P PS=1.06U PD=1.06U
M$112 VDD VDD VDD VDD pfet_03v3 L=2U W=0.5U AS=0.14P AD=0.14P PS=1.06U PD=1.06U
M$113 VDD VDD VDD VDD pfet_03v3 L=2U W=0.5U AS=0.14P AD=0.14P PS=1.06U PD=1.06U
M$114 VDD VDD VDD VDD pfet_03v3 L=2U W=0.5U AS=0.14P AD=0.14P PS=1.06U PD=1.06U
M$115 VDD VDD VDD VDD pfet_03v3 L=2U W=0.5U AS=0.14P AD=0.14P PS=1.06U PD=1.06U
M$116 VDD VDD VDD VDD pfet_03v3 L=2U W=0.5U AS=0.14P AD=0.14P PS=1.06U PD=1.06U
M$117 VDD VDD VDD VDD pfet_03v3 L=2U W=0.5U AS=0.14P AD=0.14P PS=1.06U PD=1.06U
M$118 VDD VDD VDD VDD pfet_03v3 L=2U W=0.5U AS=0.14P AD=0.14P PS=1.06U PD=1.06U
M$119 VDD VDD VDD VDD pfet_03v3 L=2U W=0.5U AS=0.14P AD=0.14P PS=1.06U PD=1.06U
M$120 VDD VDD VDD VDD pfet_03v3 L=2U W=0.5U AS=0.14P AD=0.14P PS=1.06U PD=1.06U
M$121 VDD VDD VDD VDD pfet_03v3 L=2U W=0.5U AS=0.14P AD=0.14P PS=1.06U PD=1.06U
M$122 VDD VDD VDD VDD pfet_03v3 L=2U W=0.5U AS=0.14P AD=0.14P PS=1.06U PD=1.06U
M$123 VDD VDD VDD VDD pfet_03v3 L=2U W=0.5U AS=0.14P AD=0.14P PS=1.06U PD=1.06U
M$124 VDD VDD VDD VDD pfet_03v3 L=2U W=0.5U AS=0.14P AD=0.14P PS=1.06U PD=1.06U
M$125 VDD VDD VDD VDD pfet_03v3 L=2U W=0.5U AS=0.14P AD=0.14P PS=1.06U PD=1.06U
M$126 VDD VDD VDD VDD pfet_03v3 L=2U W=0.5U AS=0.14P AD=0.14P PS=1.06U PD=1.06U
M$127 VDD VDD VDD VDD pfet_03v3 L=2U W=0.5U AS=0.14P AD=0.14P PS=1.06U PD=1.06U
M$128 VDD VDD VDD VDD pfet_03v3 L=2U W=0.5U AS=0.14P AD=0.14P PS=1.06U PD=1.06U
M$129 VDD VDD VDD VDD pfet_03v3 L=2U W=0.5U AS=0.14P AD=0.14P PS=1.06U PD=1.06U
M$130 VDD VDD VDD VDD pfet_03v3 L=2U W=0.5U AS=0.14P AD=0.14P PS=1.06U PD=1.06U
M$131 VDD VDD VDD VDD pfet_03v3 L=2U W=0.5U AS=0.14P AD=0.14P PS=1.06U PD=1.06U
M$132 VDD VDD VDD VDD pfet_03v3 L=2U W=0.5U AS=0.14P AD=0.14P PS=1.06U PD=1.06U
M$133 VDD VDD VDD VDD pfet_03v3 L=2U W=0.5U AS=0.14P AD=0.14P PS=1.06U PD=1.06U
M$134 VDD VDD VDD VDD pfet_03v3 L=2U W=0.5U AS=0.14P AD=0.14P PS=1.06U PD=1.06U
M$135 VDD VDD VDD VDD pfet_03v3 L=2U W=0.5U AS=0.14P AD=0.14P PS=1.06U PD=1.06U
M$136 VDD VDD VDD VDD pfet_03v3 L=2U W=0.5U AS=0.14P AD=0.14P PS=1.06U PD=1.06U
M$137 VDD VDD VDD VDD pfet_03v3 L=2U W=0.5U AS=0.14P AD=0.14P PS=1.06U PD=1.06U
M$138 VDD VDD VDD VDD pfet_03v3 L=2U W=0.5U AS=0.14P AD=0.14P PS=1.06U PD=1.06U
M$139 VDD VDD VDD VDD pfet_03v3 L=2U W=0.5U AS=0.14P AD=0.14P PS=1.06U PD=1.06U
M$140 VDD VDD VDD VDD pfet_03v3 L=2U W=0.5U AS=0.14P AD=0.14P PS=1.06U PD=1.06U
M$141 VDD VDD VDD VDD pfet_03v3 L=2U W=0.5U AS=0.14P AD=0.14P PS=1.06U PD=1.06U
M$142 VDD VDD VDD VDD pfet_03v3 L=2U W=0.5U AS=0.14P AD=0.14P PS=1.06U PD=1.06U
M$143 VDD VDD VDD VDD pfet_03v3 L=2U W=0.5U AS=0.14P AD=0.14P PS=1.06U PD=1.06U
M$144 VDD VDD VDD VDD pfet_03v3 L=2U W=0.5U AS=0.14P AD=0.14P PS=1.06U PD=1.06U
M$145 VDD VDD VDD VDD pfet_03v3 L=2U W=0.5U AS=0.14P AD=0.14P PS=1.06U PD=1.06U
M$146 VDD VDD VDD VDD pfet_03v3 L=2U W=0.5U AS=0.14P AD=0.14P PS=1.06U PD=1.06U
M$147 VDD VDD VDD VDD pfet_03v3 L=2U W=0.5U AS=0.14P AD=0.14P PS=1.06U PD=1.06U
M$148 VDD VDD VDD VDD pfet_03v3 L=2U W=0.5U AS=0.14P AD=0.14P PS=1.06U PD=1.06U
M$149 VDD VDD VDD VDD pfet_03v3 L=2U W=0.5U AS=0.14P AD=0.14P PS=1.06U PD=1.06U
M$150 VDD VDD VDD VDD pfet_03v3 L=2U W=0.5U AS=0.14P AD=0.14P PS=1.06U PD=1.06U
M$151 VDD VDD VDD VDD pfet_03v3 L=2U W=0.5U AS=0.14P AD=0.14P PS=1.06U PD=1.06U
M$152 VDD VDD VDD VDD pfet_03v3 L=2U W=0.5U AS=0.14P AD=0.14P PS=1.06U PD=1.06U
M$153 VDD VDD VDD VDD pfet_03v3 L=2U W=0.5U AS=0.14P AD=0.14P PS=1.06U PD=1.06U
M$154 VDD VDD VDD VDD pfet_03v3 L=2U W=0.5U AS=0.14P AD=0.14P PS=1.06U PD=1.06U
M$155 VDD VDD VDD VDD pfet_03v3 L=2U W=0.5U AS=0.14P AD=0.14P PS=1.06U PD=1.06U
M$156 VDD VDD VDD VDD pfet_03v3 L=2U W=0.5U AS=0.14P AD=0.14P PS=1.06U PD=1.06U
M$157 VDD VDD VDD VDD pfet_03v3 L=2U W=0.5U AS=0.14P AD=0.14P PS=1.06U PD=1.06U
M$158 VDD VDD VDD VDD pfet_03v3 L=2U W=0.5U AS=0.14P AD=0.14P PS=1.06U PD=1.06U
M$159 VDD VDD VDD VDD pfet_03v3 L=2U W=0.5U AS=0.14P AD=0.14P PS=1.06U PD=1.06U
M$160 VDD VDD VDD VDD pfet_03v3 L=2U W=0.5U AS=0.14P AD=0.14P PS=1.06U PD=1.06U
M$161 VDD VDD VDD VDD pfet_03v3 L=2U W=0.5U AS=0.14P AD=0.14P PS=1.06U PD=1.06U
M$162 VDD VDD VDD VDD pfet_03v3 L=2U W=0.5U AS=0.14P AD=0.14P PS=1.06U PD=1.06U
M$163 VDD VDD VDD VDD pfet_03v3 L=2U W=0.5U AS=0.14P AD=0.14P PS=1.06U PD=1.06U
M$164 VDD VDD VDD VDD pfet_03v3 L=2U W=0.5U AS=0.14P AD=0.14P PS=1.06U PD=1.06U
M$165 VDD VDD VDD VDD pfet_03v3 L=2U W=0.5U AS=0.14P AD=0.14P PS=1.06U PD=1.06U
M$166 VDD VDD VDD VDD pfet_03v3 L=2U W=0.5U AS=0.14P AD=0.14P PS=1.06U PD=1.06U
M$167 VDD VDD VDD VDD pfet_03v3 L=2U W=0.5U AS=0.14P AD=0.14P PS=1.06U PD=1.06U
M$168 VDD VDD VDD VDD pfet_03v3 L=2U W=0.5U AS=0.14P AD=0.14P PS=1.06U PD=1.06U
M$169 VDD VDD VDD VDD pfet_03v3 L=2U W=0.5U AS=0.14P AD=0.14P PS=1.06U PD=1.06U
M$170 VDD VDD VDD VDD pfet_03v3 L=2U W=0.5U AS=0.14P AD=0.14P PS=1.06U PD=1.06U
M$171 VDD VDD VDD VDD pfet_03v3 L=2U W=0.5U AS=0.14P AD=0.14P PS=1.06U PD=1.06U
M$172 VDD VDD VDD VDD pfet_03v3 L=2U W=0.5U AS=0.14P AD=0.14P PS=1.06U PD=1.06U
M$173 VDD VDD VDD VDD pfet_03v3 L=2U W=0.5U AS=0.14P AD=0.14P PS=1.06U PD=1.06U
M$174 VDD VDD VDD VDD pfet_03v3 L=2U W=0.5U AS=0.14P AD=0.14P PS=1.06U PD=1.06U
M$175 VDD VDD VDD VDD pfet_03v3 L=2U W=0.5U AS=0.14P AD=0.14P PS=1.06U PD=1.06U
M$176 VDD VDD VDD VDD pfet_03v3 L=2U W=0.5U AS=0.14P AD=0.14P PS=1.06U PD=1.06U
M$177 VDD VDD VDD VDD pfet_03v3 L=2U W=0.5U AS=0.14P AD=0.14P PS=1.06U PD=1.06U
M$178 VDD VDD VDD VDD pfet_03v3 L=2U W=0.5U AS=0.14P AD=0.14P PS=1.06U PD=1.06U
M$179 VDD VDD VDD VDD pfet_03v3 L=2U W=0.5U AS=0.14P AD=0.14P PS=1.06U PD=1.06U
M$180 VDD VDD VDD VDD pfet_03v3 L=2U W=0.5U AS=0.14P AD=0.14P PS=1.06U PD=1.06U
M$181 VDD VDD VDD VDD pfet_03v3 L=2U W=0.5U AS=0.14P AD=0.14P PS=1.06U PD=1.06U
M$182 VDD VDD VDD VDD pfet_03v3 L=2U W=0.5U AS=0.14P AD=0.14P PS=1.06U PD=1.06U
M$183 VDD VDD VDD VDD pfet_03v3 L=2U W=0.5U AS=0.14P AD=0.14P PS=1.06U PD=1.06U
M$184 VDD VDD VDD VDD pfet_03v3 L=2U W=0.5U AS=0.14P AD=0.14P PS=1.06U PD=1.06U
M$185 VDD VDD VDD VDD pfet_03v3 L=2U W=0.5U AS=0.14P AD=0.14P PS=1.06U PD=1.06U
M$186 VDD VDD VDD VDD pfet_03v3 L=2U W=0.5U AS=0.14P AD=0.14P PS=1.06U PD=1.06U
M$187 VDD VDD VDD VDD pfet_03v3 L=2U W=0.5U AS=0.14P AD=0.14P PS=1.06U PD=1.06U
M$188 VDD VDD VDD VDD pfet_03v3 L=2U W=0.5U AS=0.14P AD=0.14P PS=1.06U PD=1.06U
M$189 VDD VDD VDD VDD pfet_03v3 L=2U W=0.5U AS=0.14P AD=0.14P PS=1.06U PD=1.06U
M$190 VDD VDD VDD VDD pfet_03v3 L=2U W=0.5U AS=0.14P AD=0.14P PS=1.06U PD=1.06U
M$191 VDD VDD VDD VDD pfet_03v3 L=2U W=0.5U AS=0.14P AD=0.14P PS=1.06U PD=1.06U
M$192 VDD VDD VDD VDD pfet_03v3 L=2U W=0.5U AS=0.14P AD=0.14P PS=1.06U PD=1.06U
M$193 VDD VDD VDD VDD pfet_03v3 L=2U W=0.5U AS=0.14P AD=0.14P PS=1.06U PD=1.06U
M$194 VDD VDD VDD VDD pfet_03v3 L=2U W=0.5U AS=0.14P AD=0.14P PS=1.06U PD=1.06U
M$195 VDD VDD VDD VDD pfet_03v3 L=2U W=0.5U AS=0.14P AD=0.14P PS=1.06U PD=1.06U
M$196 VDD VDD VDD VDD pfet_03v3 L=2U W=0.5U AS=0.14P AD=0.14P PS=1.06U PD=1.06U
M$197 VDD VDD VDD VDD pfet_03v3 L=2U W=0.5U AS=0.14P AD=0.14P PS=1.06U PD=1.06U
M$198 VDD VDD VDD VDD pfet_03v3 L=2U W=0.5U AS=0.14P AD=0.14P PS=1.06U PD=1.06U
M$199 VDD VDD VDD VDD pfet_03v3 L=2U W=0.5U AS=0.14P AD=0.14P PS=1.06U PD=1.06U
M$200 VDD VDD VDD VDD pfet_03v3 L=2U W=0.5U AS=0.14P AD=0.14P PS=1.06U PD=1.06U
M$201 VDD VDD VDD VDD pfet_03v3 L=2U W=0.5U AS=0.14P AD=0.14P PS=1.06U PD=1.06U
M$202 VDD VDD VDD VDD pfet_03v3 L=2U W=0.5U AS=0.14P AD=0.14P PS=1.06U PD=1.06U
M$203 VDD VDD VDD VDD pfet_03v3 L=2U W=0.5U AS=0.14P AD=0.14P PS=1.06U PD=1.06U
M$204 VDD VDD VDD VDD pfet_03v3 L=2U W=0.5U AS=0.14P AD=0.14P PS=1.06U PD=1.06U
M$205 VDD VDD VDD VDD pfet_03v3 L=2U W=0.5U AS=0.14P AD=0.14P PS=1.06U PD=1.06U
M$206 VDD VDD VDD VDD pfet_03v3 L=2U W=0.5U AS=0.14P AD=0.14P PS=1.06U PD=1.06U
M$207 VDD VDD VDD VDD pfet_03v3 L=2U W=0.5U AS=0.14P AD=0.14P PS=1.06U PD=1.06U
M$208 VDD VDD VDD VDD pfet_03v3 L=2U W=0.5U AS=0.14P AD=0.14P PS=1.06U PD=1.06U
M$209 VDD VDD VDD VDD pfet_03v3 L=2U W=0.5U AS=0.14P AD=0.14P PS=1.06U PD=1.06U
M$210 VDD VDD VDD VDD pfet_03v3 L=2U W=0.5U AS=0.14P AD=0.14P PS=1.06U PD=1.06U
M$211 VDD VDD VDD VDD pfet_03v3 L=2U W=0.5U AS=0.3P AD=0.14P PS=2.2U PD=1.06U
M$212 VDD VDD VDD VDD pfet_03v3 L=2U W=1U AS=0.6P AD=0.6P PS=3.2U PD=3.2U
M$213 VDD VDD VDD VDD pfet_03v3 L=2U W=0.5U AS=0.14P AD=0.14P PS=1.06U PD=1.06U
M$214 VDD VDD VDD VDD pfet_03v3 L=2U W=0.5U AS=0.14P AD=0.14P PS=1.06U PD=1.06U
M$215 VDD VDD VDD VDD pfet_03v3 L=2U W=0.5U AS=0.14P AD=0.14P PS=1.06U PD=1.06U
M$216 VDD VDD VDD VDD pfet_03v3 L=2U W=0.5U AS=0.14P AD=0.14P PS=1.06U PD=1.06U
M$217 VDD VDD VDD VDD pfet_03v3 L=2U W=0.5U AS=0.14P AD=0.14P PS=1.06U PD=1.06U
M$218 VDD VDD VDD VDD pfet_03v3 L=2U W=0.5U AS=0.14P AD=0.14P PS=1.06U PD=1.06U
M$219 VDD VDD VDD VDD pfet_03v3 L=2U W=0.5U AS=0.14P AD=0.14P PS=1.06U PD=1.06U
M$220 VDD VDD VDD VDD pfet_03v3 L=2U W=0.5U AS=0.14P AD=0.14P PS=1.06U PD=1.06U
M$221 VDD VDD VDD VDD pfet_03v3 L=2U W=0.5U AS=0.14P AD=0.14P PS=1.06U PD=1.06U
M$222 VDD VDD VDD VDD pfet_03v3 L=2U W=0.5U AS=0.14P AD=0.14P PS=1.06U PD=1.06U
M$223 VDD VDD VDD VDD pfet_03v3 L=2U W=0.5U AS=0.14P AD=0.14P PS=1.06U PD=1.06U
M$224 VDD VDD VDD VDD pfet_03v3 L=2U W=0.5U AS=0.14P AD=0.14P PS=1.06U PD=1.06U
M$225 VDD VDD VDD VDD pfet_03v3 L=2U W=0.5U AS=0.14P AD=0.14P PS=1.06U PD=1.06U
M$226 VDD VDD VDD VDD pfet_03v3 L=2U W=0.5U AS=0.14P AD=0.14P PS=1.06U PD=1.06U
M$227 VDD VDD VDD VDD pfet_03v3 L=2U W=0.5U AS=0.14P AD=0.14P PS=1.06U PD=1.06U
M$228 VDD VDD VDD VDD pfet_03v3 L=2U W=0.5U AS=0.14P AD=0.14P PS=1.06U PD=1.06U
M$229 VDD VDD VDD VDD pfet_03v3 L=2U W=0.5U AS=0.14P AD=0.14P PS=1.06U PD=1.06U
M$230 VDD VDD VDD VDD pfet_03v3 L=2U W=0.5U AS=0.14P AD=0.14P PS=1.06U PD=1.06U
M$231 VDD VDD VDD VDD pfet_03v3 L=2U W=0.5U AS=0.14P AD=0.14P PS=1.06U PD=1.06U
M$232 VDD VDD VDD VDD pfet_03v3 L=2U W=0.5U AS=0.14P AD=0.14P PS=1.06U PD=1.06U
M$233 VDD VDD VDD VDD pfet_03v3 L=2U W=0.5U AS=0.14P AD=0.14P PS=1.06U PD=1.06U
M$234 VDD VDD VDD VDD pfet_03v3 L=2U W=0.5U AS=0.14P AD=0.14P PS=1.06U PD=1.06U
M$235 VDD VDD VDD VDD pfet_03v3 L=2U W=0.5U AS=0.14P AD=0.14P PS=1.06U PD=1.06U
M$236 VDD VDD VDD VDD pfet_03v3 L=2U W=0.5U AS=0.14P AD=0.14P PS=1.06U PD=1.06U
M$237 VDD VDD VDD VDD pfet_03v3 L=2U W=0.5U AS=0.14P AD=0.14P PS=1.06U PD=1.06U
M$238 VDD VDD VDD VDD pfet_03v3 L=2U W=0.5U AS=0.14P AD=0.14P PS=1.06U PD=1.06U
M$239 VDD VDD VDD VDD pfet_03v3 L=2U W=0.5U AS=0.14P AD=0.14P PS=1.06U PD=1.06U
M$240 VDD VDD VDD VDD pfet_03v3 L=2U W=0.5U AS=0.14P AD=0.14P PS=1.06U PD=1.06U
M$241 VDD VDD VDD VDD pfet_03v3 L=2U W=0.5U AS=0.14P AD=0.14P PS=1.06U PD=1.06U
M$242 VDD VDD VDD VDD pfet_03v3 L=2U W=0.5U AS=0.14P AD=0.14P PS=1.06U PD=1.06U
M$243 VDD VDD VDD VDD pfet_03v3 L=2U W=0.5U AS=0.14P AD=0.14P PS=1.06U PD=1.06U
M$244 VDD VDD VDD VDD pfet_03v3 L=2U W=0.5U AS=0.14P AD=0.14P PS=1.06U PD=1.06U
M$245 VDD VDD VDD VDD pfet_03v3 L=2U W=0.5U AS=0.14P AD=0.14P PS=1.06U PD=1.06U
M$246 VDD VDD VDD VDD pfet_03v3 L=2U W=0.5U AS=0.14P AD=0.14P PS=1.06U PD=1.06U
M$247 VDD VDD VDD VDD pfet_03v3 L=2U W=0.5U AS=0.14P AD=0.14P PS=1.06U PD=1.06U
M$248 VDD VDD VDD VDD pfet_03v3 L=2U W=0.5U AS=0.14P AD=0.14P PS=1.06U PD=1.06U
M$249 VDD VDD VDD VDD pfet_03v3 L=2U W=0.5U AS=0.14P AD=0.14P PS=1.06U PD=1.06U
M$250 VDD VDD VDD VDD pfet_03v3 L=2U W=0.5U AS=0.14P AD=0.14P PS=1.06U PD=1.06U
M$251 VDD VDD VDD VDD pfet_03v3 L=2U W=0.5U AS=0.14P AD=0.14P PS=1.06U PD=1.06U
M$252 VDD VDD VDD VDD pfet_03v3 L=2U W=0.5U AS=0.14P AD=0.14P PS=1.06U PD=1.06U
M$253 VDD VDD VDD VDD pfet_03v3 L=2U W=0.5U AS=0.14P AD=0.14P PS=1.06U PD=1.06U
M$254 VDD VDD VDD VDD pfet_03v3 L=2U W=0.5U AS=0.14P AD=0.14P PS=1.06U PD=1.06U
M$255 VDD VDD VDD VDD pfet_03v3 L=2U W=0.5U AS=0.14P AD=0.14P PS=1.06U PD=1.06U
M$256 VDD VDD VDD VDD pfet_03v3 L=2U W=0.5U AS=0.14P AD=0.14P PS=1.06U PD=1.06U
M$257 VDD VDD VDD VDD pfet_03v3 L=2U W=0.5U AS=0.14P AD=0.14P PS=1.06U PD=1.06U
M$258 VDD VDD VDD VDD pfet_03v3 L=2U W=0.5U AS=0.14P AD=0.14P PS=1.06U PD=1.06U
M$259 VDD VDD VDD VDD pfet_03v3 L=2U W=0.5U AS=0.14P AD=0.14P PS=1.06U PD=1.06U
M$260 VDD VDD VDD VDD pfet_03v3 L=2U W=0.5U AS=0.14P AD=0.14P PS=1.06U PD=1.06U
M$261 VDD VDD VDD VDD pfet_03v3 L=2U W=0.5U AS=0.14P AD=0.14P PS=1.06U PD=1.06U
M$262 VDD VDD VDD VDD pfet_03v3 L=2U W=0.5U AS=0.14P AD=0.14P PS=1.06U PD=1.06U
M$263 VDD VDD VDD VDD pfet_03v3 L=2U W=0.5U AS=0.14P AD=0.14P PS=1.06U PD=1.06U
M$264 VDD VDD VDD VDD pfet_03v3 L=2U W=0.5U AS=0.14P AD=0.14P PS=1.06U PD=1.06U
M$265 VDD VDD VDD VDD pfet_03v3 L=2U W=0.5U AS=0.14P AD=0.14P PS=1.06U PD=1.06U
M$266 VDD VDD VDD VDD pfet_03v3 L=2U W=0.5U AS=0.14P AD=0.3P PS=1.06U PD=2.2U
M$267 VDD VDD VDD VDD pfet_03v3 L=2U W=0.5U AS=0.14P AD=0.14P PS=1.06U PD=1.06U
M$268 VDD VDD VDD VDD pfet_03v3 L=2U W=0.5U AS=0.14P AD=0.14P PS=1.06U PD=1.06U
M$269 VDD VDD VDD VDD pfet_03v3 L=2U W=0.5U AS=0.14P AD=0.14P PS=1.06U PD=1.06U
M$270 VDD VDD VDD VDD pfet_03v3 L=2U W=0.5U AS=0.14P AD=0.14P PS=1.06U PD=1.06U
M$271 VDD VDD VDD VDD pfet_03v3 L=2U W=0.5U AS=0.14P AD=0.14P PS=1.06U PD=1.06U
M$272 VDD VDD VDD VDD pfet_03v3 L=2U W=0.5U AS=0.14P AD=0.14P PS=1.06U PD=1.06U
M$273 VDD VDD VDD VDD pfet_03v3 L=2U W=0.5U AS=0.14P AD=0.14P PS=1.06U PD=1.06U
M$274 VDD VDD VDD VDD pfet_03v3 L=2U W=0.5U AS=0.14P AD=0.14P PS=1.06U PD=1.06U
M$275 VDD VDD VDD VDD pfet_03v3 L=2U W=0.5U AS=0.14P AD=0.14P PS=1.06U PD=1.06U
M$276 VDD VDD VDD VDD pfet_03v3 L=2U W=0.5U AS=0.14P AD=0.14P PS=1.06U PD=1.06U
M$277 VDD VDD VDD VDD pfet_03v3 L=2U W=0.5U AS=0.14P AD=0.14P PS=1.06U PD=1.06U
M$278 VDD VDD VDD VDD pfet_03v3 L=2U W=0.5U AS=0.14P AD=0.14P PS=1.06U PD=1.06U
M$279 VDD VDD VDD VDD pfet_03v3 L=2U W=0.5U AS=0.14P AD=0.14P PS=1.06U PD=1.06U
M$280 VDD VDD VDD VDD pfet_03v3 L=2U W=0.5U AS=0.14P AD=0.14P PS=1.06U PD=1.06U
M$281 VDD VDD VDD VDD pfet_03v3 L=2U W=0.5U AS=0.14P AD=0.14P PS=1.06U PD=1.06U
M$282 VDD VDD VDD VDD pfet_03v3 L=2U W=0.5U AS=0.14P AD=0.14P PS=1.06U PD=1.06U
M$283 VDD VDD VDD VDD pfet_03v3 L=2U W=0.5U AS=0.14P AD=0.14P PS=1.06U PD=1.06U
M$284 VDD VDD VDD VDD pfet_03v3 L=2U W=0.5U AS=0.14P AD=0.14P PS=1.06U PD=1.06U
M$285 VDD VDD VDD VDD pfet_03v3 L=2U W=0.5U AS=0.14P AD=0.14P PS=1.06U PD=1.06U
M$286 VDD VDD VDD VDD pfet_03v3 L=2U W=0.5U AS=0.14P AD=0.14P PS=1.06U PD=1.06U
M$287 VDD VDD VDD VDD pfet_03v3 L=2U W=0.5U AS=0.14P AD=0.14P PS=1.06U PD=1.06U
M$288 VDD VDD VDD VDD pfet_03v3 L=2U W=0.5U AS=0.14P AD=0.14P PS=1.06U PD=1.06U
M$289 VDD VDD VDD VDD pfet_03v3 L=2U W=0.5U AS=0.14P AD=0.14P PS=1.06U PD=1.06U
M$290 VDD VDD VDD VDD pfet_03v3 L=2U W=0.5U AS=0.14P AD=0.14P PS=1.06U PD=1.06U
M$291 VDD VDD VDD VDD pfet_03v3 L=2U W=0.5U AS=0.14P AD=0.14P PS=1.06U PD=1.06U
M$292 VDD VDD VDD VDD pfet_03v3 L=2U W=0.5U AS=0.14P AD=0.14P PS=1.06U PD=1.06U
M$293 VDD VDD VDD VDD pfet_03v3 L=2U W=0.5U AS=0.14P AD=0.14P PS=1.06U PD=1.06U
M$294 VDD VDD VDD VDD pfet_03v3 L=2U W=0.5U AS=0.14P AD=0.14P PS=1.06U PD=1.06U
M$295 VDD VDD VDD VDD pfet_03v3 L=2U W=0.5U AS=0.14P AD=0.14P PS=1.06U PD=1.06U
M$296 VDD VDD VDD VDD pfet_03v3 L=2U W=0.5U AS=0.14P AD=0.14P PS=1.06U PD=1.06U
M$297 VDD VDD VDD VDD pfet_03v3 L=2U W=0.5U AS=0.14P AD=0.14P PS=1.06U PD=1.06U
M$298 VDD VDD VDD VDD pfet_03v3 L=2U W=0.5U AS=0.14P AD=0.14P PS=1.06U PD=1.06U
M$299 VDD VDD VDD VDD pfet_03v3 L=2U W=0.5U AS=0.14P AD=0.14P PS=1.06U PD=1.06U
M$300 VDD VDD VDD VDD pfet_03v3 L=2U W=0.5U AS=0.14P AD=0.14P PS=1.06U PD=1.06U
M$301 VDD VDD VDD VDD pfet_03v3 L=2U W=0.5U AS=0.14P AD=0.14P PS=1.06U PD=1.06U
M$302 VDD VDD VDD VDD pfet_03v3 L=2U W=0.5U AS=0.14P AD=0.14P PS=1.06U PD=1.06U
M$303 VDD VDD VDD VDD pfet_03v3 L=2U W=0.5U AS=0.14P AD=0.14P PS=1.06U PD=1.06U
M$304 VDD VDD VDD VDD pfet_03v3 L=2U W=0.5U AS=0.14P AD=0.14P PS=1.06U PD=1.06U
M$305 VDD VDD VDD VDD pfet_03v3 L=2U W=0.5U AS=0.14P AD=0.14P PS=1.06U PD=1.06U
M$306 VDD VDD VDD VDD pfet_03v3 L=2U W=0.5U AS=0.14P AD=0.14P PS=1.06U PD=1.06U
M$307 VDD VDD VDD VDD pfet_03v3 L=2U W=0.5U AS=0.14P AD=0.14P PS=1.06U PD=1.06U
M$308 VDD VDD VDD VDD pfet_03v3 L=2U W=0.5U AS=0.14P AD=0.14P PS=1.06U PD=1.06U
M$309 VDD VDD VDD VDD pfet_03v3 L=2U W=0.5U AS=0.14P AD=0.14P PS=1.06U PD=1.06U
M$310 VDD VDD VDD VDD pfet_03v3 L=2U W=0.5U AS=0.14P AD=0.14P PS=1.06U PD=1.06U
M$311 VDD VDD VDD VDD pfet_03v3 L=2U W=0.5U AS=0.14P AD=0.14P PS=1.06U PD=1.06U
M$312 VDD VDD VDD VDD pfet_03v3 L=2U W=0.5U AS=0.14P AD=0.14P PS=1.06U PD=1.06U
M$313 VDD VDD VDD VDD pfet_03v3 L=2U W=0.5U AS=0.14P AD=0.14P PS=1.06U PD=1.06U
M$314 VDD VDD VDD VDD pfet_03v3 L=2U W=0.5U AS=0.14P AD=0.14P PS=1.06U PD=1.06U
M$315 VDD VDD VDD VDD pfet_03v3 L=2U W=0.5U AS=0.14P AD=0.14P PS=1.06U PD=1.06U
M$316 VDD VDD VDD VDD pfet_03v3 L=2U W=0.5U AS=0.14P AD=0.14P PS=1.06U PD=1.06U
M$317 VDD VDD VDD VDD pfet_03v3 L=2U W=0.5U AS=0.14P AD=0.14P PS=1.06U PD=1.06U
M$318 VDD VDD VDD VDD pfet_03v3 L=2U W=0.5U AS=0.14P AD=0.14P PS=1.06U PD=1.06U
M$319 VDD VDD VDD VDD pfet_03v3 L=2U W=0.5U AS=0.14P AD=0.14P PS=1.06U PD=1.06U
M$320 VDD VDD VDD VDD pfet_03v3 L=2U W=0.5U AS=0.14P AD=0.14P PS=1.06U PD=1.06U
M$321 VDD VDD VDD VDD pfet_03v3 L=2U W=0.5U AS=0.14P AD=0.14P PS=1.06U PD=1.06U
M$322 VDD VDD VDD VDD pfet_03v3 L=2U W=0.5U AS=0.14P AD=0.14P PS=1.06U PD=1.06U
M$323 VDD VDD VDD VDD pfet_03v3 L=2U W=0.5U AS=0.14P AD=0.14P PS=1.06U PD=1.06U
M$324 VDD VDD VDD VDD pfet_03v3 L=2U W=0.5U AS=0.14P AD=0.14P PS=1.06U PD=1.06U
M$325 VDD VDD VDD VDD pfet_03v3 L=2U W=0.5U AS=0.14P AD=0.14P PS=1.06U PD=1.06U
M$326 VDD VDD VDD VDD pfet_03v3 L=2U W=0.5U AS=0.14P AD=0.14P PS=1.06U PD=1.06U
M$327 VDD VDD VDD VDD pfet_03v3 L=2U W=0.5U AS=0.14P AD=0.14P PS=1.06U PD=1.06U
M$328 VDD VDD VDD VDD pfet_03v3 L=2U W=0.5U AS=0.14P AD=0.14P PS=1.06U PD=1.06U
M$329 VDD VDD VDD VDD pfet_03v3 L=2U W=0.5U AS=0.14P AD=0.14P PS=1.06U PD=1.06U
M$330 VDD VDD VDD VDD pfet_03v3 L=2U W=0.5U AS=0.14P AD=0.14P PS=1.06U PD=1.06U
M$331 VDD VDD VDD VDD pfet_03v3 L=2U W=0.5U AS=0.14P AD=0.14P PS=1.06U PD=1.06U
M$332 VDD VDD VDD VDD pfet_03v3 L=2U W=0.5U AS=0.14P AD=0.14P PS=1.06U PD=1.06U
M$333 VDD VDD VDD VDD pfet_03v3 L=2U W=0.5U AS=0.14P AD=0.14P PS=1.06U PD=1.06U
M$334 VDD VDD VDD VDD pfet_03v3 L=2U W=0.5U AS=0.14P AD=0.14P PS=1.06U PD=1.06U
M$335 VDD VDD VDD VDD pfet_03v3 L=2U W=0.5U AS=0.14P AD=0.14P PS=1.06U PD=1.06U
M$336 VDD VDD VDD VDD pfet_03v3 L=2U W=0.5U AS=0.14P AD=0.14P PS=1.06U PD=1.06U
M$337 VDD VDD VDD VDD pfet_03v3 L=2U W=0.5U AS=0.14P AD=0.14P PS=1.06U PD=1.06U
M$338 VDD VDD VDD VDD pfet_03v3 L=2U W=0.5U AS=0.14P AD=0.14P PS=1.06U PD=1.06U
M$339 VDD VDD VDD VDD pfet_03v3 L=2U W=0.5U AS=0.14P AD=0.14P PS=1.06U PD=1.06U
M$340 VDD VDD VDD VDD pfet_03v3 L=2U W=0.5U AS=0.14P AD=0.14P PS=1.06U PD=1.06U
M$341 VDD VDD VDD VDD pfet_03v3 L=2U W=0.5U AS=0.14P AD=0.14P PS=1.06U PD=1.06U
M$342 VDD VDD VDD VDD pfet_03v3 L=2U W=0.5U AS=0.14P AD=0.14P PS=1.06U PD=1.06U
M$343 VDD VDD VDD VDD pfet_03v3 L=2U W=0.5U AS=0.14P AD=0.14P PS=1.06U PD=1.06U
M$344 VDD VDD VDD VDD pfet_03v3 L=2U W=0.5U AS=0.14P AD=0.14P PS=1.06U PD=1.06U
M$345 VDD VDD VDD VDD pfet_03v3 L=2U W=0.5U AS=0.14P AD=0.14P PS=1.06U PD=1.06U
M$346 VDD VDD VDD VDD pfet_03v3 L=2U W=0.5U AS=0.14P AD=0.14P PS=1.06U PD=1.06U
M$347 VDD VDD VDD VDD pfet_03v3 L=2U W=0.5U AS=0.14P AD=0.14P PS=1.06U PD=1.06U
M$348 VDD VDD VDD VDD pfet_03v3 L=2U W=0.5U AS=0.14P AD=0.14P PS=1.06U PD=1.06U
M$349 VDD VDD VDD VDD pfet_03v3 L=2U W=0.5U AS=0.14P AD=0.14P PS=1.06U PD=1.06U
M$350 VDD VDD VDD VDD pfet_03v3 L=2U W=0.5U AS=0.14P AD=0.14P PS=1.06U PD=1.06U
M$351 VDD VDD VDD VDD pfet_03v3 L=2U W=0.5U AS=0.14P AD=0.14P PS=1.06U PD=1.06U
M$352 VDD VDD VDD VDD pfet_03v3 L=2U W=0.5U AS=0.14P AD=0.14P PS=1.06U PD=1.06U
M$353 VDD VDD VDD VDD pfet_03v3 L=2U W=0.5U AS=0.14P AD=0.14P PS=1.06U PD=1.06U
M$354 VDD VDD VDD VDD pfet_03v3 L=2U W=0.5U AS=0.14P AD=0.14P PS=1.06U PD=1.06U
M$355 VDD VDD VDD VDD pfet_03v3 L=2U W=0.5U AS=0.14P AD=0.14P PS=1.06U PD=1.06U
M$356 VDD VDD VDD VDD pfet_03v3 L=2U W=0.5U AS=0.14P AD=0.14P PS=1.06U PD=1.06U
M$357 VDD VDD VDD VDD pfet_03v3 L=2U W=0.5U AS=0.14P AD=0.14P PS=1.06U PD=1.06U
M$358 VDD VDD VDD VDD pfet_03v3 L=2U W=0.5U AS=0.14P AD=0.14P PS=1.06U PD=1.06U
M$359 VDD VDD VDD VDD pfet_03v3 L=2U W=0.5U AS=0.14P AD=0.14P PS=1.06U PD=1.06U
M$360 VDD VDD VDD VDD pfet_03v3 L=2U W=0.5U AS=0.14P AD=0.14P PS=1.06U PD=1.06U
M$361 VDD VDD VDD VDD pfet_03v3 L=2U W=0.5U AS=0.14P AD=0.14P PS=1.06U PD=1.06U
M$362 VDD VDD VDD VDD pfet_03v3 L=2U W=0.5U AS=0.14P AD=0.14P PS=1.06U PD=1.06U
M$363 VDD VDD VDD VDD pfet_03v3 L=2U W=0.5U AS=0.14P AD=0.14P PS=1.06U PD=1.06U
M$364 VDD VDD VDD VDD pfet_03v3 L=2U W=0.5U AS=0.14P AD=0.14P PS=1.06U PD=1.06U
M$365 VDD VDD VDD VDD pfet_03v3 L=2U W=0.5U AS=0.14P AD=0.14P PS=1.06U PD=1.06U
M$366 VDD VDD VDD VDD pfet_03v3 L=2U W=0.5U AS=0.14P AD=0.14P PS=1.06U PD=1.06U
M$367 VDD VDD VDD VDD pfet_03v3 L=2U W=0.5U AS=0.14P AD=0.14P PS=1.06U PD=1.06U
M$368 VDD VDD VDD VDD pfet_03v3 L=2U W=0.5U AS=0.14P AD=0.14P PS=1.06U PD=1.06U
M$369 VDD VDD VDD VDD pfet_03v3 L=2U W=0.5U AS=0.14P AD=0.14P PS=1.06U PD=1.06U
M$370 VDD VDD VDD VDD pfet_03v3 L=2U W=0.5U AS=0.14P AD=0.14P PS=1.06U PD=1.06U
M$371 VDD VDD VDD VDD pfet_03v3 L=2U W=0.5U AS=0.14P AD=0.14P PS=1.06U PD=1.06U
M$372 VDD VDD VDD VDD pfet_03v3 L=2U W=0.5U AS=0.14P AD=0.14P PS=1.06U PD=1.06U
M$373 VDD VDD VDD VDD pfet_03v3 L=2U W=0.5U AS=0.14P AD=0.14P PS=1.06U PD=1.06U
M$374 VDD VDD VDD VDD pfet_03v3 L=2U W=0.5U AS=0.14P AD=0.14P PS=1.06U PD=1.06U
M$375 VDD VDD VDD VDD pfet_03v3 L=2U W=0.5U AS=0.14P AD=0.14P PS=1.06U PD=1.06U
M$376 VDD VDD VDD VDD pfet_03v3 L=2U W=0.5U AS=0.14P AD=0.14P PS=1.06U PD=1.06U
M$377 VDD VDD VDD VDD pfet_03v3 L=2U W=0.5U AS=0.14P AD=0.14P PS=1.06U PD=1.06U
M$378 VDD VDD VDD VDD pfet_03v3 L=2U W=0.5U AS=0.14P AD=0.14P PS=1.06U PD=1.06U
M$379 VDD VDD VDD VDD pfet_03v3 L=2U W=0.5U AS=0.14P AD=0.14P PS=1.06U PD=1.06U
M$380 VDD VDD VDD VDD pfet_03v3 L=2U W=0.5U AS=0.14P AD=0.14P PS=1.06U PD=1.06U
M$381 VDD VDD VDD VDD pfet_03v3 L=2U W=0.5U AS=0.14P AD=0.14P PS=1.06U PD=1.06U
M$382 VDD VDD VDD VDD pfet_03v3 L=2U W=0.5U AS=0.14P AD=0.14P PS=1.06U PD=1.06U
M$383 VDD VDD VDD VDD pfet_03v3 L=2U W=0.5U AS=0.14P AD=0.14P PS=1.06U PD=1.06U
M$384 VDD VDD VDD VDD pfet_03v3 L=2U W=0.5U AS=0.14P AD=0.14P PS=1.06U PD=1.06U
M$385 VDD VDD VDD VDD pfet_03v3 L=2U W=0.5U AS=0.14P AD=0.14P PS=1.06U PD=1.06U
M$386 VDD VDD VDD VDD pfet_03v3 L=2U W=0.5U AS=0.14P AD=0.14P PS=1.06U PD=1.06U
M$387 VDD VDD VDD VDD pfet_03v3 L=2U W=0.5U AS=0.14P AD=0.14P PS=1.06U PD=1.06U
M$388 VDD VDD VDD VDD pfet_03v3 L=2U W=0.5U AS=0.14P AD=0.14P PS=1.06U PD=1.06U
M$389 VDD VDD VDD VDD pfet_03v3 L=2U W=0.5U AS=0.14P AD=0.14P PS=1.06U PD=1.06U
M$390 VDD VDD VDD VDD pfet_03v3 L=2U W=0.5U AS=0.14P AD=0.14P PS=1.06U PD=1.06U
M$391 VDD VDD VDD VDD pfet_03v3 L=2U W=0.5U AS=0.14P AD=0.14P PS=1.06U PD=1.06U
M$392 VDD VDD VDD VDD pfet_03v3 L=2U W=0.5U AS=0.14P AD=0.14P PS=1.06U PD=1.06U
M$393 VDD VDD VDD VDD pfet_03v3 L=2U W=0.5U AS=0.14P AD=0.14P PS=1.06U PD=1.06U
M$394 VDD VDD VDD VDD pfet_03v3 L=2U W=0.5U AS=0.14P AD=0.14P PS=1.06U PD=1.06U
M$395 VDD VDD VDD VDD pfet_03v3 L=2U W=0.5U AS=0.14P AD=0.14P PS=1.06U PD=1.06U
M$396 VDD VDD VDD VDD pfet_03v3 L=2U W=0.5U AS=0.14P AD=0.14P PS=1.06U PD=1.06U
M$397 VDD VDD VDD VDD pfet_03v3 L=2U W=0.5U AS=0.14P AD=0.14P PS=1.06U PD=1.06U
M$398 VDD VDD VDD VDD pfet_03v3 L=2U W=0.5U AS=0.14P AD=0.14P PS=1.06U PD=1.06U
M$399 VDD VDD VDD VDD pfet_03v3 L=2U W=0.5U AS=0.14P AD=0.14P PS=1.06U PD=1.06U
M$400 VDD VDD VDD VDD pfet_03v3 L=2U W=0.5U AS=0.14P AD=0.14P PS=1.06U PD=1.06U
M$401 VDD VDD VDD VDD pfet_03v3 L=2U W=0.5U AS=0.14P AD=0.14P PS=1.06U PD=1.06U
M$402 VDD VDD VDD VDD pfet_03v3 L=2U W=0.5U AS=0.14P AD=0.14P PS=1.06U PD=1.06U
M$403 VDD VDD VDD VDD pfet_03v3 L=2U W=0.5U AS=0.14P AD=0.14P PS=1.06U PD=1.06U
M$404 VDD VDD VDD VDD pfet_03v3 L=2U W=0.5U AS=0.14P AD=0.14P PS=1.06U PD=1.06U
M$405 VDD VDD VDD VDD pfet_03v3 L=2U W=0.5U AS=0.14P AD=0.14P PS=1.06U PD=1.06U
M$406 VDD VDD VDD VDD pfet_03v3 L=2U W=0.5U AS=0.14P AD=0.14P PS=1.06U PD=1.06U
M$407 VDD VDD VDD VDD pfet_03v3 L=2U W=0.5U AS=0.14P AD=0.14P PS=1.06U PD=1.06U
M$408 VDD VDD VDD VDD pfet_03v3 L=2U W=0.5U AS=0.14P AD=0.14P PS=1.06U PD=1.06U
M$409 VDD VDD VDD VDD pfet_03v3 L=2U W=0.5U AS=0.14P AD=0.14P PS=1.06U PD=1.06U
M$410 VDD VDD VDD VDD pfet_03v3 L=2U W=0.5U AS=0.14P AD=0.14P PS=1.06U PD=1.06U
M$411 VDD VDD VDD VDD pfet_03v3 L=2U W=0.5U AS=0.14P AD=0.14P PS=1.06U PD=1.06U
M$412 VDD VDD VDD VDD pfet_03v3 L=2U W=0.5U AS=0.14P AD=0.14P PS=1.06U PD=1.06U
M$413 VDD VDD VDD VDD pfet_03v3 L=2U W=0.5U AS=0.14P AD=0.14P PS=1.06U PD=1.06U
M$414 VDD VDD VDD VDD pfet_03v3 L=2U W=0.5U AS=0.14P AD=0.14P PS=1.06U PD=1.06U
M$415 VDD VDD VDD VDD pfet_03v3 L=2U W=0.5U AS=0.14P AD=0.14P PS=1.06U PD=1.06U
M$416 VDD VDD VDD VDD pfet_03v3 L=2U W=0.5U AS=0.14P AD=0.14P PS=1.06U PD=1.06U
M$417 VDD VDD VDD VDD pfet_03v3 L=2U W=0.5U AS=0.14P AD=0.14P PS=1.06U PD=1.06U
M$418 VDD VDD VDD VDD pfet_03v3 L=2U W=0.5U AS=0.14P AD=0.14P PS=1.06U PD=1.06U
M$419 VDD VDD VDD VDD pfet_03v3 L=2U W=0.5U AS=0.14P AD=0.14P PS=1.06U PD=1.06U
M$420 VDD VDD VDD VDD pfet_03v3 L=2U W=0.5U AS=0.14P AD=0.14P PS=1.06U PD=1.06U
M$421 VDD VDD VDD VDD pfet_03v3 L=2U W=0.5U AS=0.14P AD=0.14P PS=1.06U PD=1.06U
M$422 VDD VDD VDD VDD pfet_03v3 L=2U W=0.5U AS=0.14P AD=0.14P PS=1.06U PD=1.06U
M$423 VDD VDD VDD VDD pfet_03v3 L=2U W=0.5U AS=0.3P AD=0.14P PS=2.2U PD=1.06U
M$424 \$274 \$274 VDD VDD pfet_03v3 L=6U W=1U AS=0.6P AD=0.28P PS=3.2U PD=1.56U
M$425 VDD \$274 \$274 VDD pfet_03v3 L=6U W=1U AS=0.28P AD=0.28P PS=1.56U
+ PD=1.56U
M$426 \$274 \$274 VDD VDD pfet_03v3 L=6U W=1U AS=0.28P AD=0.28P PS=1.56U
+ PD=1.56U
M$427 VDD \$274 \$274 VDD pfet_03v3 L=6U W=1U AS=0.28P AD=0.6P PS=1.56U PD=3.2U
M$428 \$140 \$274 VDD VDD pfet_03v3 L=6U W=1U AS=0.6P AD=0.28P PS=3.2U PD=1.56U
M$429 VDD \$274 \$140 VDD pfet_03v3 L=6U W=1U AS=0.28P AD=0.28P PS=1.56U
+ PD=1.56U
M$430 \$140 \$274 VDD VDD pfet_03v3 L=6U W=1U AS=0.28P AD=0.28P PS=1.56U
+ PD=1.56U
M$431 VDD \$274 \$140 VDD pfet_03v3 L=6U W=1U AS=0.28P AD=0.6P PS=1.56U PD=3.2U
M$432 VDD VSS \$669 VDD pfet_03v3 L=45.45U W=0.5U AS=0.3P AD=0.3P PS=2.2U
+ PD=2.2U
M$433 \$669 VSS \$670 VDD pfet_03v3 L=45.45U W=0.5U AS=0.3P AD=0.3P PS=2.2U
+ PD=2.2U
M$434 \$670 VSS \$671 VDD pfet_03v3 L=45.45U W=0.5U AS=0.3P AD=0.3P PS=2.2U
+ PD=2.2U
M$435 \$671 VSS \$672 VDD pfet_03v3 L=45.45U W=0.5U AS=0.3P AD=0.3P PS=2.2U
+ PD=2.2U
M$436 \$672 VSS \$673 VDD pfet_03v3 L=45.45U W=0.5U AS=0.3P AD=0.3P PS=2.2U
+ PD=2.2U
M$437 \$673 VSS \$674 VDD pfet_03v3 L=45.45U W=0.5U AS=0.3P AD=0.3P PS=2.2U
+ PD=2.2U
M$438 \$674 VSS \$675 VDD pfet_03v3 L=45.45U W=0.5U AS=0.3P AD=0.3P PS=2.2U
+ PD=2.2U
M$439 \$675 VSS \$676 VDD pfet_03v3 L=45.45U W=0.5U AS=0.3P AD=0.3P PS=2.2U
+ PD=2.2U
M$440 \$676 VSS \$677 VDD pfet_03v3 L=45.45U W=0.5U AS=0.3P AD=0.3P PS=2.2U
+ PD=2.2U
M$441 \$677 VSS \$275 VDD pfet_03v3 L=45.45U W=0.5U AS=0.3P AD=0.3P PS=2.2U
+ PD=2.2U
M$442 VDD VDD VDD VDD pfet_03v3 L=2U W=1U AS=0.6P AD=0.6P PS=3.2U PD=3.2U
M$443 VSS VSS VSS VSS nfet_03v3 L=2U W=0.5U AS=0.14P AD=0.14P PS=1.06U PD=1.06U
M$444 VSS VSS VSS VSS nfet_03v3 L=2U W=0.5U AS=0.14P AD=0.14P PS=1.06U PD=1.06U
M$445 VSS VSS VSS VSS nfet_03v3 L=2U W=0.5U AS=0.14P AD=0.14P PS=1.06U PD=1.06U
M$446 VSS VSS VSS VSS nfet_03v3 L=2U W=0.5U AS=0.14P AD=0.14P PS=1.06U PD=1.06U
M$447 VSS VSS VSS VSS nfet_03v3 L=2U W=0.5U AS=0.14P AD=0.14P PS=1.06U PD=1.06U
M$448 VSS VSS VSS VSS nfet_03v3 L=2U W=0.5U AS=0.14P AD=0.14P PS=1.06U PD=1.06U
M$449 VSS VSS VSS VSS nfet_03v3 L=2U W=0.5U AS=0.14P AD=0.14P PS=1.06U PD=1.06U
M$450 VSS VSS VSS VSS nfet_03v3 L=2U W=0.5U AS=0.14P AD=0.14P PS=1.06U PD=1.06U
M$451 VSS VSS VSS VSS nfet_03v3 L=2U W=0.5U AS=0.14P AD=0.14P PS=1.06U PD=1.06U
M$452 VSS VSS VSS VSS nfet_03v3 L=2U W=0.5U AS=0.14P AD=0.14P PS=1.06U PD=1.06U
M$453 VSS VSS VSS VSS nfet_03v3 L=2U W=0.5U AS=0.14P AD=0.14P PS=1.06U PD=1.06U
M$454 VSS VSS VSS VSS nfet_03v3 L=2U W=0.5U AS=0.14P AD=0.14P PS=1.06U PD=1.06U
M$455 VSS VSS VSS VSS nfet_03v3 L=2U W=0.5U AS=0.14P AD=0.14P PS=1.06U PD=1.06U
M$456 VSS VSS VSS VSS nfet_03v3 L=2U W=0.5U AS=0.14P AD=0.14P PS=1.06U PD=1.06U
M$457 VSS VSS VSS VSS nfet_03v3 L=2U W=0.5U AS=0.14P AD=0.14P PS=1.06U PD=1.06U
M$458 VSS VSS VSS VSS nfet_03v3 L=2U W=0.5U AS=0.14P AD=0.14P PS=1.06U PD=1.06U
M$459 VSS VSS VSS VSS nfet_03v3 L=2U W=0.5U AS=0.14P AD=0.14P PS=1.06U PD=1.06U
M$460 VSS VSS VSS VSS nfet_03v3 L=2U W=0.5U AS=0.14P AD=0.14P PS=1.06U PD=1.06U
M$461 VSS VSS VSS VSS nfet_03v3 L=2U W=0.5U AS=0.14P AD=0.14P PS=1.06U PD=1.06U
M$462 VSS VSS VSS VSS nfet_03v3 L=2U W=0.5U AS=0.14P AD=0.14P PS=1.06U PD=1.06U
M$463 VSS VSS VSS VSS nfet_03v3 L=2U W=0.5U AS=0.14P AD=0.14P PS=1.06U PD=1.06U
M$464 VSS VSS VSS VSS nfet_03v3 L=2U W=0.5U AS=0.14P AD=0.14P PS=1.06U PD=1.06U
M$465 VSS VSS VSS VSS nfet_03v3 L=2U W=0.5U AS=0.14P AD=0.14P PS=1.06U PD=1.06U
M$466 VSS VSS VSS VSS nfet_03v3 L=2U W=0.5U AS=0.14P AD=0.14P PS=1.06U PD=1.06U
M$467 VSS VSS VSS VSS nfet_03v3 L=2U W=0.5U AS=0.14P AD=0.14P PS=1.06U PD=1.06U
M$468 VSS VSS VSS VSS nfet_03v3 L=2U W=0.5U AS=0.14P AD=0.14P PS=1.06U PD=1.06U
M$469 VSS VSS VSS VSS nfet_03v3 L=2U W=0.5U AS=0.14P AD=0.14P PS=1.06U PD=1.06U
M$470 VSS VSS VSS VSS nfet_03v3 L=2U W=0.5U AS=0.14P AD=0.14P PS=1.06U PD=1.06U
M$471 VSS VSS VSS VSS nfet_03v3 L=2U W=0.5U AS=0.14P AD=0.14P PS=1.06U PD=1.06U
M$472 VSS VSS VSS VSS nfet_03v3 L=2U W=0.5U AS=0.14P AD=0.14P PS=1.06U PD=1.06U
M$473 VSS VSS VSS VSS nfet_03v3 L=2U W=0.5U AS=0.14P AD=0.14P PS=1.06U PD=1.06U
M$474 VSS VSS VSS VSS nfet_03v3 L=2U W=0.5U AS=0.14P AD=0.14P PS=1.06U PD=1.06U
M$475 VSS VSS VSS VSS nfet_03v3 L=2U W=0.5U AS=0.14P AD=0.14P PS=1.06U PD=1.06U
M$476 VSS VSS VSS VSS nfet_03v3 L=2U W=0.5U AS=0.14P AD=0.14P PS=1.06U PD=1.06U
M$477 VSS VSS VSS VSS nfet_03v3 L=2U W=0.5U AS=0.14P AD=0.14P PS=1.06U PD=1.06U
M$478 VSS VSS VSS VSS nfet_03v3 L=2U W=0.5U AS=0.14P AD=0.14P PS=1.06U PD=1.06U
M$479 VSS VSS VSS VSS nfet_03v3 L=2U W=0.5U AS=0.14P AD=0.14P PS=1.06U PD=1.06U
M$480 VSS VSS VSS VSS nfet_03v3 L=2U W=0.5U AS=0.14P AD=0.14P PS=1.06U PD=1.06U
M$481 VSS VSS VSS VSS nfet_03v3 L=2U W=0.5U AS=0.14P AD=0.14P PS=1.06U PD=1.06U
M$482 VSS VSS VSS VSS nfet_03v3 L=2U W=0.5U AS=0.14P AD=0.14P PS=1.06U PD=1.06U
M$483 VSS VSS VSS VSS nfet_03v3 L=2U W=0.5U AS=0.14P AD=0.14P PS=1.06U PD=1.06U
M$484 VSS VSS VSS VSS nfet_03v3 L=2U W=0.5U AS=0.14P AD=0.14P PS=1.06U PD=1.06U
M$485 VSS VSS VSS VSS nfet_03v3 L=2U W=0.5U AS=0.14P AD=0.14P PS=1.06U PD=1.06U
M$486 VSS VSS VSS VSS nfet_03v3 L=2U W=0.5U AS=0.14P AD=0.14P PS=1.06U PD=1.06U
M$487 VSS VSS VSS VSS nfet_03v3 L=2U W=0.5U AS=0.14P AD=0.14P PS=1.06U PD=1.06U
M$488 VSS VSS VSS VSS nfet_03v3 L=2U W=0.5U AS=0.14P AD=0.14P PS=1.06U PD=1.06U
M$489 VSS VSS VSS VSS nfet_03v3 L=2U W=0.5U AS=0.14P AD=0.14P PS=1.06U PD=1.06U
M$490 VSS VSS VSS VSS nfet_03v3 L=2U W=0.5U AS=0.14P AD=0.14P PS=1.06U PD=1.06U
M$491 VSS VSS VSS VSS nfet_03v3 L=2U W=0.5U AS=0.14P AD=0.14P PS=1.06U PD=1.06U
M$492 VSS VSS VSS VSS nfet_03v3 L=2U W=0.5U AS=0.14P AD=0.14P PS=1.06U PD=1.06U
M$493 VSS VSS VSS VSS nfet_03v3 L=2U W=0.5U AS=0.14P AD=0.14P PS=1.06U PD=1.06U
M$494 VSS VSS VSS VSS nfet_03v3 L=2U W=0.5U AS=0.14P AD=0.14P PS=1.06U PD=1.06U
M$495 VSS VSS VSS VSS nfet_03v3 L=2U W=0.5U AS=0.14P AD=0.14P PS=1.06U PD=1.06U
M$496 VSS VSS VSS VSS nfet_03v3 L=2U W=0.5U AS=0.14P AD=0.14P PS=1.06U PD=1.06U
M$497 VSS VSS VSS VSS nfet_03v3 L=2U W=0.5U AS=0.14P AD=0.14P PS=1.06U PD=1.06U
M$498 VSS VSS VSS VSS nfet_03v3 L=2U W=0.5U AS=0.14P AD=0.14P PS=1.06U PD=1.06U
M$499 VSS VSS VSS VSS nfet_03v3 L=2U W=0.5U AS=0.14P AD=0.14P PS=1.06U PD=1.06U
M$500 VSS VSS VSS VSS nfet_03v3 L=2U W=0.5U AS=0.14P AD=0.14P PS=1.06U PD=1.06U
M$501 VSS VSS VSS VSS nfet_03v3 L=2U W=0.5U AS=0.14P AD=0.14P PS=1.06U PD=1.06U
M$502 VSS VSS VSS VSS nfet_03v3 L=2U W=0.5U AS=0.14P AD=0.14P PS=1.06U PD=1.06U
M$503 VSS VSS VSS VSS nfet_03v3 L=2U W=0.5U AS=0.14P AD=0.14P PS=1.06U PD=1.06U
M$504 VSS VSS VSS VSS nfet_03v3 L=2U W=0.5U AS=0.14P AD=0.14P PS=1.06U PD=1.06U
M$505 VSS VSS VSS VSS nfet_03v3 L=2U W=0.5U AS=0.14P AD=0.14P PS=1.06U PD=1.06U
M$506 VSS VSS VSS VSS nfet_03v3 L=2U W=0.5U AS=0.14P AD=0.14P PS=1.06U PD=1.06U
M$507 VSS VSS VSS VSS nfet_03v3 L=2U W=0.5U AS=0.14P AD=0.14P PS=1.06U PD=1.06U
M$508 VSS VSS VSS VSS nfet_03v3 L=2U W=0.5U AS=0.14P AD=0.3P PS=1.06U PD=2.2U
M$509 VSS VSS VSS VSS nfet_03v3 L=2U W=0.5U AS=0.14P AD=0.14P PS=1.06U PD=1.06U
M$510 VSS VSS VSS VSS nfet_03v3 L=2U W=0.5U AS=0.14P AD=0.14P PS=1.06U PD=1.06U
M$511 VSS VSS VSS VSS nfet_03v3 L=2U W=0.5U AS=0.14P AD=0.14P PS=1.06U PD=1.06U
M$512 VSS VSS VSS VSS nfet_03v3 L=2U W=0.5U AS=0.14P AD=0.14P PS=1.06U PD=1.06U
M$513 VSS VSS VSS VSS nfet_03v3 L=2U W=0.5U AS=0.14P AD=0.14P PS=1.06U PD=1.06U
M$514 VSS VSS VSS VSS nfet_03v3 L=2U W=0.5U AS=0.14P AD=0.14P PS=1.06U PD=1.06U
M$515 VSS VSS VSS VSS nfet_03v3 L=2U W=0.5U AS=0.14P AD=0.14P PS=1.06U PD=1.06U
M$516 VSS VSS VSS VSS nfet_03v3 L=2U W=0.5U AS=0.14P AD=0.14P PS=1.06U PD=1.06U
M$517 VSS VSS VSS VSS nfet_03v3 L=2U W=0.5U AS=0.14P AD=0.14P PS=1.06U PD=1.06U
M$518 VSS VSS VSS VSS nfet_03v3 L=2U W=0.5U AS=0.14P AD=0.14P PS=1.06U PD=1.06U
M$519 VSS VSS VSS VSS nfet_03v3 L=2U W=0.5U AS=0.14P AD=0.14P PS=1.06U PD=1.06U
M$520 VSS VSS VSS VSS nfet_03v3 L=2U W=0.5U AS=0.14P AD=0.14P PS=1.06U PD=1.06U
M$521 VSS VSS VSS VSS nfet_03v3 L=2U W=0.5U AS=0.14P AD=0.14P PS=1.06U PD=1.06U
M$522 VSS VSS VSS VSS nfet_03v3 L=2U W=0.5U AS=0.14P AD=0.14P PS=1.06U PD=1.06U
M$523 VSS VSS VSS VSS nfet_03v3 L=2U W=0.5U AS=0.14P AD=0.14P PS=1.06U PD=1.06U
M$524 VSS VSS VSS VSS nfet_03v3 L=2U W=0.5U AS=0.14P AD=0.14P PS=1.06U PD=1.06U
M$525 VSS VSS VSS VSS nfet_03v3 L=2U W=0.5U AS=0.14P AD=0.14P PS=1.06U PD=1.06U
M$526 VSS VSS VSS VSS nfet_03v3 L=2U W=0.5U AS=0.14P AD=0.14P PS=1.06U PD=1.06U
M$527 VSS VSS VSS VSS nfet_03v3 L=2U W=0.5U AS=0.14P AD=0.14P PS=1.06U PD=1.06U
M$528 VSS VSS VSS VSS nfet_03v3 L=2U W=0.5U AS=0.14P AD=0.14P PS=1.06U PD=1.06U
M$529 VSS VSS VSS VSS nfet_03v3 L=2U W=0.5U AS=0.14P AD=0.14P PS=1.06U PD=1.06U
M$530 VSS VSS VSS VSS nfet_03v3 L=2U W=0.5U AS=0.14P AD=0.14P PS=1.06U PD=1.06U
M$531 VSS VSS VSS VSS nfet_03v3 L=2U W=0.5U AS=0.14P AD=0.14P PS=1.06U PD=1.06U
M$532 VSS VSS VSS VSS nfet_03v3 L=2U W=0.5U AS=0.14P AD=0.14P PS=1.06U PD=1.06U
M$533 VSS VSS VSS VSS nfet_03v3 L=2U W=0.5U AS=0.14P AD=0.14P PS=1.06U PD=1.06U
M$534 VSS VSS VSS VSS nfet_03v3 L=2U W=0.5U AS=0.14P AD=0.14P PS=1.06U PD=1.06U
M$535 VSS VSS VSS VSS nfet_03v3 L=2U W=0.5U AS=0.14P AD=0.14P PS=1.06U PD=1.06U
M$536 VSS VSS VSS VSS nfet_03v3 L=2U W=0.5U AS=0.14P AD=0.14P PS=1.06U PD=1.06U
M$537 VSS VSS VSS VSS nfet_03v3 L=2U W=0.5U AS=0.14P AD=0.14P PS=1.06U PD=1.06U
M$538 VSS VSS VSS VSS nfet_03v3 L=2U W=0.5U AS=0.14P AD=0.14P PS=1.06U PD=1.06U
M$539 VSS VSS VSS VSS nfet_03v3 L=2U W=0.5U AS=0.14P AD=0.14P PS=1.06U PD=1.06U
M$540 VSS VSS VSS VSS nfet_03v3 L=2U W=0.5U AS=0.14P AD=0.14P PS=1.06U PD=1.06U
M$541 VSS VSS VSS VSS nfet_03v3 L=2U W=0.5U AS=0.14P AD=0.14P PS=1.06U PD=1.06U
M$542 VSS VSS VSS VSS nfet_03v3 L=2U W=0.5U AS=0.14P AD=0.14P PS=1.06U PD=1.06U
M$543 VSS VSS VSS VSS nfet_03v3 L=2U W=0.5U AS=0.14P AD=0.14P PS=1.06U PD=1.06U
M$544 VSS VSS VSS VSS nfet_03v3 L=2U W=0.5U AS=0.14P AD=0.14P PS=1.06U PD=1.06U
M$545 VSS VSS VSS VSS nfet_03v3 L=2U W=0.5U AS=0.14P AD=0.14P PS=1.06U PD=1.06U
M$546 VSS VSS VSS VSS nfet_03v3 L=2U W=0.5U AS=0.14P AD=0.14P PS=1.06U PD=1.06U
M$547 VSS VSS VSS VSS nfet_03v3 L=2U W=0.5U AS=0.14P AD=0.14P PS=1.06U PD=1.06U
M$548 VSS VSS VSS VSS nfet_03v3 L=2U W=0.5U AS=0.14P AD=0.14P PS=1.06U PD=1.06U
M$549 VSS VSS VSS VSS nfet_03v3 L=2U W=0.5U AS=0.14P AD=0.14P PS=1.06U PD=1.06U
M$550 VSS VSS VSS VSS nfet_03v3 L=2U W=0.5U AS=0.14P AD=0.14P PS=1.06U PD=1.06U
M$551 VSS VSS VSS VSS nfet_03v3 L=2U W=0.5U AS=0.14P AD=0.14P PS=1.06U PD=1.06U
M$552 VSS VSS VSS VSS nfet_03v3 L=2U W=0.5U AS=0.14P AD=0.14P PS=1.06U PD=1.06U
M$553 VSS VSS VSS VSS nfet_03v3 L=2U W=0.5U AS=0.14P AD=0.14P PS=1.06U PD=1.06U
M$554 VSS VSS VSS VSS nfet_03v3 L=2U W=0.5U AS=0.14P AD=0.14P PS=1.06U PD=1.06U
M$555 VSS VSS VSS VSS nfet_03v3 L=2U W=0.5U AS=0.14P AD=0.14P PS=1.06U PD=1.06U
M$556 VSS VSS VSS VSS nfet_03v3 L=2U W=0.5U AS=0.14P AD=0.14P PS=1.06U PD=1.06U
M$557 VSS VSS VSS VSS nfet_03v3 L=2U W=0.5U AS=0.14P AD=0.14P PS=1.06U PD=1.06U
M$558 VSS VSS VSS VSS nfet_03v3 L=2U W=0.5U AS=0.14P AD=0.14P PS=1.06U PD=1.06U
M$559 VSS VSS VSS VSS nfet_03v3 L=2U W=0.5U AS=0.14P AD=0.14P PS=1.06U PD=1.06U
M$560 VSS VSS VSS VSS nfet_03v3 L=2U W=0.5U AS=0.14P AD=0.14P PS=1.06U PD=1.06U
M$561 VSS VSS VSS VSS nfet_03v3 L=2U W=0.5U AS=0.14P AD=0.14P PS=1.06U PD=1.06U
M$562 VSS VSS VSS VSS nfet_03v3 L=2U W=0.5U AS=0.14P AD=0.14P PS=1.06U PD=1.06U
M$563 VSS VSS VSS VSS nfet_03v3 L=2U W=0.5U AS=0.14P AD=0.14P PS=1.06U PD=1.06U
M$564 VSS VSS VSS VSS nfet_03v3 L=2U W=0.5U AS=0.14P AD=0.14P PS=1.06U PD=1.06U
M$565 VSS VSS VSS VSS nfet_03v3 L=2U W=0.5U AS=0.14P AD=0.14P PS=1.06U PD=1.06U
M$566 VSS VSS VSS VSS nfet_03v3 L=2U W=0.5U AS=0.14P AD=0.14P PS=1.06U PD=1.06U
M$567 VSS VSS VSS VSS nfet_03v3 L=2U W=0.5U AS=0.14P AD=0.14P PS=1.06U PD=1.06U
M$568 VSS VSS VSS VSS nfet_03v3 L=2U W=0.5U AS=0.14P AD=0.14P PS=1.06U PD=1.06U
M$569 VSS VSS VSS VSS nfet_03v3 L=2U W=0.5U AS=0.14P AD=0.14P PS=1.06U PD=1.06U
M$570 VSS VSS VSS VSS nfet_03v3 L=2U W=0.5U AS=0.14P AD=0.14P PS=1.06U PD=1.06U
M$571 VSS VSS VSS VSS nfet_03v3 L=2U W=0.5U AS=0.14P AD=0.14P PS=1.06U PD=1.06U
M$572 VSS VSS VSS VSS nfet_03v3 L=2U W=0.5U AS=0.14P AD=0.14P PS=1.06U PD=1.06U
M$573 VSS VSS VSS VSS nfet_03v3 L=2U W=0.5U AS=0.14P AD=0.14P PS=1.06U PD=1.06U
M$574 VSS VSS VSS VSS nfet_03v3 L=2U W=0.5U AS=0.14P AD=0.14P PS=1.06U PD=1.06U
M$575 VSS VSS VSS VSS nfet_03v3 L=2U W=0.5U AS=0.14P AD=0.14P PS=1.06U PD=1.06U
M$576 VSS VSS VSS VSS nfet_03v3 L=2U W=0.5U AS=0.14P AD=0.14P PS=1.06U PD=1.06U
M$577 VSS VSS VSS VSS nfet_03v3 L=2U W=0.5U AS=0.14P AD=0.14P PS=1.06U PD=1.06U
M$578 VSS VSS VSS VSS nfet_03v3 L=2U W=0.5U AS=0.14P AD=0.14P PS=1.06U PD=1.06U
M$579 VSS VSS VSS VSS nfet_03v3 L=2U W=0.5U AS=0.14P AD=0.14P PS=1.06U PD=1.06U
M$580 VSS VSS VSS VSS nfet_03v3 L=2U W=0.5U AS=0.14P AD=0.14P PS=1.06U PD=1.06U
M$581 VSS VSS VSS VSS nfet_03v3 L=2U W=0.5U AS=0.14P AD=0.14P PS=1.06U PD=1.06U
M$582 VSS VSS VSS VSS nfet_03v3 L=2U W=0.5U AS=0.14P AD=0.14P PS=1.06U PD=1.06U
M$583 VSS VSS VSS VSS nfet_03v3 L=2U W=0.5U AS=0.14P AD=0.14P PS=1.06U PD=1.06U
M$584 VSS VSS VSS VSS nfet_03v3 L=2U W=0.5U AS=0.14P AD=0.14P PS=1.06U PD=1.06U
M$585 VSS VSS VSS VSS nfet_03v3 L=2U W=0.5U AS=0.14P AD=0.14P PS=1.06U PD=1.06U
M$586 VSS VSS VSS VSS nfet_03v3 L=2U W=0.5U AS=0.14P AD=0.14P PS=1.06U PD=1.06U
M$587 VSS VSS VSS VSS nfet_03v3 L=2U W=0.5U AS=0.14P AD=0.14P PS=1.06U PD=1.06U
M$588 VSS VSS VSS VSS nfet_03v3 L=2U W=0.5U AS=0.14P AD=0.14P PS=1.06U PD=1.06U
M$589 VSS VSS VSS VSS nfet_03v3 L=2U W=0.5U AS=0.14P AD=0.14P PS=1.06U PD=1.06U
M$590 VSS VSS VSS VSS nfet_03v3 L=2U W=0.5U AS=0.14P AD=0.14P PS=1.06U PD=1.06U
M$591 VSS VSS VSS VSS nfet_03v3 L=2U W=0.5U AS=0.14P AD=0.14P PS=1.06U PD=1.06U
M$592 VSS VSS VSS VSS nfet_03v3 L=2U W=0.5U AS=0.14P AD=0.14P PS=1.06U PD=1.06U
M$593 VSS VSS VSS VSS nfet_03v3 L=2U W=0.5U AS=0.14P AD=0.14P PS=1.06U PD=1.06U
M$594 VSS VSS VSS VSS nfet_03v3 L=2U W=0.5U AS=0.14P AD=0.14P PS=1.06U PD=1.06U
M$595 VSS VSS VSS VSS nfet_03v3 L=2U W=0.5U AS=0.14P AD=0.14P PS=1.06U PD=1.06U
M$596 VSS VSS VSS VSS nfet_03v3 L=2U W=0.5U AS=0.14P AD=0.14P PS=1.06U PD=1.06U
M$597 VSS VSS VSS VSS nfet_03v3 L=2U W=0.5U AS=0.14P AD=0.14P PS=1.06U PD=1.06U
M$598 VSS VSS VSS VSS nfet_03v3 L=2U W=0.5U AS=0.14P AD=0.14P PS=1.06U PD=1.06U
M$599 VSS VSS VSS VSS nfet_03v3 L=2U W=0.5U AS=0.14P AD=0.14P PS=1.06U PD=1.06U
M$600 VSS VSS VSS VSS nfet_03v3 L=2U W=0.5U AS=0.14P AD=0.14P PS=1.06U PD=1.06U
M$601 VSS VSS VSS VSS nfet_03v3 L=2U W=0.5U AS=0.14P AD=0.14P PS=1.06U PD=1.06U
M$602 VSS VSS VSS VSS nfet_03v3 L=2U W=0.5U AS=0.14P AD=0.14P PS=1.06U PD=1.06U
M$603 VSS VSS VSS VSS nfet_03v3 L=2U W=0.5U AS=0.14P AD=0.14P PS=1.06U PD=1.06U
M$604 VSS VSS VSS VSS nfet_03v3 L=2U W=0.5U AS=0.14P AD=0.14P PS=1.06U PD=1.06U
M$605 VSS VSS VSS VSS nfet_03v3 L=2U W=0.5U AS=0.14P AD=0.14P PS=1.06U PD=1.06U
M$606 VSS VSS VSS VSS nfet_03v3 L=2U W=0.5U AS=0.14P AD=0.14P PS=1.06U PD=1.06U
M$607 VSS VSS VSS VSS nfet_03v3 L=2U W=0.5U AS=0.14P AD=0.14P PS=1.06U PD=1.06U
M$608 VSS VSS VSS VSS nfet_03v3 L=2U W=0.5U AS=0.14P AD=0.14P PS=1.06U PD=1.06U
M$609 VSS VSS VSS VSS nfet_03v3 L=2U W=0.5U AS=0.14P AD=0.14P PS=1.06U PD=1.06U
M$610 VSS VSS VSS VSS nfet_03v3 L=2U W=0.5U AS=0.14P AD=0.14P PS=1.06U PD=1.06U
M$611 VSS VSS VSS VSS nfet_03v3 L=2U W=0.5U AS=0.14P AD=0.14P PS=1.06U PD=1.06U
M$612 VSS VSS VSS VSS nfet_03v3 L=2U W=0.5U AS=0.14P AD=0.14P PS=1.06U PD=1.06U
M$613 VSS VSS VSS VSS nfet_03v3 L=2U W=0.5U AS=0.14P AD=0.14P PS=1.06U PD=1.06U
M$614 VSS VSS VSS VSS nfet_03v3 L=2U W=0.5U AS=0.14P AD=0.14P PS=1.06U PD=1.06U
M$615 VSS VSS VSS VSS nfet_03v3 L=2U W=0.5U AS=0.14P AD=0.14P PS=1.06U PD=1.06U
M$616 VSS VSS VSS VSS nfet_03v3 L=2U W=0.5U AS=0.14P AD=0.14P PS=1.06U PD=1.06U
M$617 VSS VSS VSS VSS nfet_03v3 L=2U W=0.5U AS=0.14P AD=0.14P PS=1.06U PD=1.06U
M$618 VSS VSS VSS VSS nfet_03v3 L=2U W=0.5U AS=0.14P AD=0.14P PS=1.06U PD=1.06U
M$619 VSS VSS VSS VSS nfet_03v3 L=2U W=0.5U AS=0.14P AD=0.14P PS=1.06U PD=1.06U
M$620 VSS VSS VSS VSS nfet_03v3 L=2U W=0.5U AS=0.14P AD=0.14P PS=1.06U PD=1.06U
M$621 VSS VSS VSS VSS nfet_03v3 L=2U W=0.5U AS=0.14P AD=0.14P PS=1.06U PD=1.06U
M$622 VSS VSS VSS VSS nfet_03v3 L=2U W=0.5U AS=0.14P AD=0.14P PS=1.06U PD=1.06U
M$623 VSS VSS VSS VSS nfet_03v3 L=2U W=0.5U AS=0.14P AD=0.14P PS=1.06U PD=1.06U
M$624 VSS VSS VSS VSS nfet_03v3 L=2U W=0.5U AS=0.14P AD=0.14P PS=1.06U PD=1.06U
M$625 VSS VSS VSS VSS nfet_03v3 L=2U W=0.5U AS=0.14P AD=0.14P PS=1.06U PD=1.06U
M$626 VSS VSS VSS VSS nfet_03v3 L=2U W=0.5U AS=0.14P AD=0.14P PS=1.06U PD=1.06U
M$627 VSS VSS VSS VSS nfet_03v3 L=2U W=0.5U AS=0.14P AD=0.14P PS=1.06U PD=1.06U
M$628 VSS VSS VSS VSS nfet_03v3 L=2U W=0.5U AS=0.14P AD=0.14P PS=1.06U PD=1.06U
M$629 VSS VSS VSS VSS nfet_03v3 L=2U W=0.5U AS=0.14P AD=0.14P PS=1.06U PD=1.06U
M$630 VSS VSS VSS VSS nfet_03v3 L=2U W=0.5U AS=0.14P AD=0.14P PS=1.06U PD=1.06U
M$631 VSS VSS VSS VSS nfet_03v3 L=2U W=0.5U AS=0.14P AD=0.14P PS=1.06U PD=1.06U
M$632 VSS VSS VSS VSS nfet_03v3 L=2U W=0.5U AS=0.14P AD=0.14P PS=1.06U PD=1.06U
M$633 VSS VSS VSS VSS nfet_03v3 L=2U W=0.5U AS=0.14P AD=0.14P PS=1.06U PD=1.06U
M$634 VSS VSS VSS VSS nfet_03v3 L=2U W=0.5U AS=0.14P AD=0.14P PS=1.06U PD=1.06U
M$635 VSS VSS VSS VSS nfet_03v3 L=2U W=0.5U AS=0.14P AD=0.14P PS=1.06U PD=1.06U
M$636 VSS VSS VSS VSS nfet_03v3 L=2U W=0.5U AS=0.14P AD=0.14P PS=1.06U PD=1.06U
M$637 VSS VSS VSS VSS nfet_03v3 L=2U W=0.5U AS=0.14P AD=0.14P PS=1.06U PD=1.06U
M$638 VSS VSS VSS VSS nfet_03v3 L=2U W=0.5U AS=0.14P AD=0.14P PS=1.06U PD=1.06U
M$639 VSS VSS VSS VSS nfet_03v3 L=2U W=0.5U AS=0.14P AD=0.14P PS=1.06U PD=1.06U
M$640 VSS VSS VSS VSS nfet_03v3 L=2U W=0.5U AS=0.14P AD=0.14P PS=1.06U PD=1.06U
M$641 VSS VSS VSS VSS nfet_03v3 L=2U W=0.5U AS=0.14P AD=0.14P PS=1.06U PD=1.06U
M$642 VSS VSS VSS VSS nfet_03v3 L=2U W=0.5U AS=0.14P AD=0.14P PS=1.06U PD=1.06U
M$643 VSS VSS VSS VSS nfet_03v3 L=2U W=0.5U AS=0.14P AD=0.14P PS=1.06U PD=1.06U
M$644 VSS VSS VSS VSS nfet_03v3 L=2U W=0.5U AS=0.14P AD=0.14P PS=1.06U PD=1.06U
M$645 VSS VSS VSS VSS nfet_03v3 L=2U W=0.5U AS=0.14P AD=0.14P PS=1.06U PD=1.06U
M$646 VSS VSS VSS VSS nfet_03v3 L=2U W=0.5U AS=0.14P AD=0.14P PS=1.06U PD=1.06U
M$647 VSS VSS VSS VSS nfet_03v3 L=2U W=0.5U AS=0.14P AD=0.14P PS=1.06U PD=1.06U
M$648 VSS VSS VSS VSS nfet_03v3 L=2U W=0.5U AS=0.14P AD=0.14P PS=1.06U PD=1.06U
M$649 VSS VSS VSS VSS nfet_03v3 L=2U W=0.5U AS=0.14P AD=0.14P PS=1.06U PD=1.06U
M$650 VSS VSS VSS VSS nfet_03v3 L=2U W=0.5U AS=0.14P AD=0.14P PS=1.06U PD=1.06U
M$651 VSS VSS VSS VSS nfet_03v3 L=2U W=0.5U AS=0.14P AD=0.14P PS=1.06U PD=1.06U
M$652 VSS VSS VSS VSS nfet_03v3 L=2U W=0.5U AS=0.14P AD=0.14P PS=1.06U PD=1.06U
M$653 VSS VSS VSS VSS nfet_03v3 L=2U W=0.5U AS=0.14P AD=0.14P PS=1.06U PD=1.06U
M$654 VSS VSS VSS VSS nfet_03v3 L=2U W=0.5U AS=0.14P AD=0.14P PS=1.06U PD=1.06U
M$655 VSS VSS VSS VSS nfet_03v3 L=2U W=0.5U AS=0.14P AD=0.14P PS=1.06U PD=1.06U
M$656 VSS VSS VSS VSS nfet_03v3 L=2U W=0.5U AS=0.14P AD=0.14P PS=1.06U PD=1.06U
M$657 VSS VSS VSS VSS nfet_03v3 L=2U W=0.5U AS=0.14P AD=0.14P PS=1.06U PD=1.06U
M$658 VSS VSS VSS VSS nfet_03v3 L=2U W=0.5U AS=0.14P AD=0.14P PS=1.06U PD=1.06U
M$659 VSS VSS VSS VSS nfet_03v3 L=2U W=0.5U AS=0.14P AD=0.14P PS=1.06U PD=1.06U
M$660 VSS VSS VSS VSS nfet_03v3 L=2U W=0.5U AS=0.14P AD=0.14P PS=1.06U PD=1.06U
M$661 VSS VSS VSS VSS nfet_03v3 L=2U W=0.5U AS=0.14P AD=0.14P PS=1.06U PD=1.06U
M$662 VSS VSS VSS VSS nfet_03v3 L=2U W=0.5U AS=0.14P AD=0.14P PS=1.06U PD=1.06U
M$663 VSS VSS VSS VSS nfet_03v3 L=2U W=0.5U AS=0.14P AD=0.14P PS=1.06U PD=1.06U
M$664 VSS VSS VSS VSS nfet_03v3 L=2U W=0.5U AS=0.14P AD=0.14P PS=1.06U PD=1.06U
M$665 VSS VSS VSS VSS nfet_03v3 L=2U W=0.5U AS=0.14P AD=0.14P PS=1.06U PD=1.06U
M$666 VSS VSS VSS VSS nfet_03v3 L=2U W=0.5U AS=0.14P AD=0.14P PS=1.06U PD=1.06U
M$667 VSS VSS VSS VSS nfet_03v3 L=2U W=0.5U AS=0.14P AD=0.14P PS=1.06U PD=1.06U
M$668 VSS VSS VSS VSS nfet_03v3 L=2U W=0.5U AS=0.14P AD=0.14P PS=1.06U PD=1.06U
M$669 VSS VSS VSS VSS nfet_03v3 L=2U W=0.5U AS=0.14P AD=0.14P PS=1.06U PD=1.06U
M$670 VSS VSS VSS VSS nfet_03v3 L=2U W=0.5U AS=0.14P AD=0.14P PS=1.06U PD=1.06U
M$671 VSS VSS VSS VSS nfet_03v3 L=2U W=0.5U AS=0.14P AD=0.14P PS=1.06U PD=1.06U
M$672 VSS VSS VSS VSS nfet_03v3 L=2U W=0.5U AS=0.14P AD=0.14P PS=1.06U PD=1.06U
M$673 VSS VSS VSS VSS nfet_03v3 L=2U W=0.5U AS=0.14P AD=0.14P PS=1.06U PD=1.06U
M$674 VSS VSS VSS VSS nfet_03v3 L=2U W=0.5U AS=0.14P AD=0.14P PS=1.06U PD=1.06U
M$675 VSS VSS VSS VSS nfet_03v3 L=2U W=0.5U AS=0.14P AD=0.14P PS=1.06U PD=1.06U
M$676 VSS VSS VSS VSS nfet_03v3 L=2U W=0.5U AS=0.14P AD=0.14P PS=1.06U PD=1.06U
M$677 VSS VSS VSS VSS nfet_03v3 L=2U W=0.5U AS=0.14P AD=0.14P PS=1.06U PD=1.06U
M$678 VSS VSS VSS VSS nfet_03v3 L=2U W=0.5U AS=0.14P AD=0.14P PS=1.06U PD=1.06U
M$679 VSS VSS VSS VSS nfet_03v3 L=2U W=0.5U AS=0.14P AD=0.14P PS=1.06U PD=1.06U
M$680 VSS VSS VSS VSS nfet_03v3 L=2U W=0.5U AS=0.14P AD=0.14P PS=1.06U PD=1.06U
M$681 VSS VSS VSS VSS nfet_03v3 L=2U W=0.5U AS=0.14P AD=0.14P PS=1.06U PD=1.06U
M$682 VSS VSS VSS VSS nfet_03v3 L=2U W=0.5U AS=0.14P AD=0.14P PS=1.06U PD=1.06U
M$683 VSS VSS VSS VSS nfet_03v3 L=2U W=0.5U AS=0.14P AD=0.14P PS=1.06U PD=1.06U
M$684 VSS VSS VSS VSS nfet_03v3 L=2U W=0.5U AS=0.14P AD=0.14P PS=1.06U PD=1.06U
M$685 VSS VSS VSS VSS nfet_03v3 L=2U W=0.5U AS=0.14P AD=0.14P PS=1.06U PD=1.06U
M$686 VSS VSS VSS VSS nfet_03v3 L=2U W=0.5U AS=0.14P AD=0.14P PS=1.06U PD=1.06U
M$687 VSS VSS VSS VSS nfet_03v3 L=2U W=0.5U AS=0.14P AD=0.14P PS=1.06U PD=1.06U
M$688 VSS VSS VSS VSS nfet_03v3 L=2U W=0.5U AS=0.14P AD=0.14P PS=1.06U PD=1.06U
M$689 VSS VSS VSS VSS nfet_03v3 L=2U W=0.5U AS=0.14P AD=0.14P PS=1.06U PD=1.06U
M$690 VSS VSS VSS VSS nfet_03v3 L=2U W=0.5U AS=0.14P AD=0.14P PS=1.06U PD=1.06U
M$691 VSS VSS VSS VSS nfet_03v3 L=2U W=0.5U AS=0.14P AD=0.14P PS=1.06U PD=1.06U
M$692 VSS VSS VSS VSS nfet_03v3 L=2U W=0.5U AS=0.14P AD=0.14P PS=1.06U PD=1.06U
M$693 VSS VSS VSS VSS nfet_03v3 L=2U W=0.5U AS=0.14P AD=0.14P PS=1.06U PD=1.06U
M$694 VSS VSS VSS VSS nfet_03v3 L=2U W=0.5U AS=0.14P AD=0.14P PS=1.06U PD=1.06U
M$695 VSS VSS VSS VSS nfet_03v3 L=2U W=0.5U AS=0.14P AD=0.14P PS=1.06U PD=1.06U
M$696 VSS VSS VSS VSS nfet_03v3 L=2U W=0.5U AS=0.14P AD=0.14P PS=1.06U PD=1.06U
M$697 VSS VSS VSS VSS nfet_03v3 L=2U W=0.5U AS=0.14P AD=0.14P PS=1.06U PD=1.06U
M$698 VSS VSS VSS VSS nfet_03v3 L=2U W=0.5U AS=0.14P AD=0.14P PS=1.06U PD=1.06U
M$699 VSS VSS VSS VSS nfet_03v3 L=2U W=0.5U AS=0.14P AD=0.14P PS=1.06U PD=1.06U
M$700 VSS VSS VSS VSS nfet_03v3 L=2U W=0.5U AS=0.14P AD=0.14P PS=1.06U PD=1.06U
M$701 VSS VSS VSS VSS nfet_03v3 L=2U W=0.5U AS=0.14P AD=0.14P PS=1.06U PD=1.06U
M$702 VSS VSS VSS VSS nfet_03v3 L=2U W=0.5U AS=0.14P AD=0.14P PS=1.06U PD=1.06U
M$703 VSS VSS VSS VSS nfet_03v3 L=2U W=0.5U AS=0.14P AD=0.14P PS=1.06U PD=1.06U
M$704 VSS VSS VSS VSS nfet_03v3 L=2U W=0.5U AS=0.3P AD=0.14P PS=2.2U PD=1.06U
M$705 VSS VSS VSS VSS nfet_03v3 L=2U W=1U AS=0.6P AD=0.6P PS=3.2U PD=3.2U
M$706 VSS VSS VSS VSS nfet_03v3 L=2U W=0.5U AS=0.14P AD=0.14P PS=1.06U PD=1.06U
M$707 VSS VSS VSS VSS nfet_03v3 L=2U W=0.5U AS=0.14P AD=0.14P PS=1.06U PD=1.06U
M$708 VSS VSS VSS VSS nfet_03v3 L=2U W=0.5U AS=0.14P AD=0.14P PS=1.06U PD=1.06U
M$709 VSS VSS VSS VSS nfet_03v3 L=2U W=0.5U AS=0.14P AD=0.14P PS=1.06U PD=1.06U
M$710 VSS VSS VSS VSS nfet_03v3 L=2U W=0.5U AS=0.14P AD=0.14P PS=1.06U PD=1.06U
M$711 VSS VSS VSS VSS nfet_03v3 L=2U W=0.5U AS=0.14P AD=0.14P PS=1.06U PD=1.06U
M$712 VSS VSS VSS VSS nfet_03v3 L=2U W=0.5U AS=0.14P AD=0.14P PS=1.06U PD=1.06U
M$713 VSS VSS VSS VSS nfet_03v3 L=2U W=0.5U AS=0.14P AD=0.14P PS=1.06U PD=1.06U
M$714 VSS VSS VSS VSS nfet_03v3 L=2U W=0.5U AS=0.14P AD=0.14P PS=1.06U PD=1.06U
M$715 VSS VSS VSS VSS nfet_03v3 L=2U W=0.5U AS=0.14P AD=0.14P PS=1.06U PD=1.06U
M$716 VSS VSS VSS VSS nfet_03v3 L=2U W=0.5U AS=0.14P AD=0.14P PS=1.06U PD=1.06U
M$717 VSS VSS VSS VSS nfet_03v3 L=2U W=0.5U AS=0.14P AD=0.14P PS=1.06U PD=1.06U
M$718 VSS VSS VSS VSS nfet_03v3 L=2U W=0.5U AS=0.14P AD=0.14P PS=1.06U PD=1.06U
M$719 VSS VSS VSS VSS nfet_03v3 L=2U W=0.5U AS=0.14P AD=0.14P PS=1.06U PD=1.06U
M$720 VSS VSS VSS VSS nfet_03v3 L=2U W=0.5U AS=0.14P AD=0.14P PS=1.06U PD=1.06U
M$721 VSS VSS VSS VSS nfet_03v3 L=2U W=0.5U AS=0.14P AD=0.14P PS=1.06U PD=1.06U
M$722 VSS VSS VSS VSS nfet_03v3 L=2U W=0.5U AS=0.14P AD=0.14P PS=1.06U PD=1.06U
M$723 VSS VSS VSS VSS nfet_03v3 L=2U W=0.5U AS=0.14P AD=0.14P PS=1.06U PD=1.06U
M$724 VSS VSS VSS VSS nfet_03v3 L=2U W=0.5U AS=0.14P AD=0.14P PS=1.06U PD=1.06U
M$725 VSS VSS VSS VSS nfet_03v3 L=2U W=0.5U AS=0.14P AD=0.14P PS=1.06U PD=1.06U
M$726 VSS VSS VSS VSS nfet_03v3 L=2U W=0.5U AS=0.14P AD=0.14P PS=1.06U PD=1.06U
M$727 VSS VSS VSS VSS nfet_03v3 L=2U W=0.5U AS=0.14P AD=0.14P PS=1.06U PD=1.06U
M$728 VSS VSS VSS VSS nfet_03v3 L=2U W=0.5U AS=0.14P AD=0.14P PS=1.06U PD=1.06U
M$729 VSS VSS VSS VSS nfet_03v3 L=2U W=0.5U AS=0.14P AD=0.14P PS=1.06U PD=1.06U
M$730 VSS VSS VSS VSS nfet_03v3 L=2U W=0.5U AS=0.14P AD=0.14P PS=1.06U PD=1.06U
M$731 VSS VSS VSS VSS nfet_03v3 L=2U W=0.5U AS=0.14P AD=0.14P PS=1.06U PD=1.06U
M$732 VSS VSS VSS VSS nfet_03v3 L=2U W=0.5U AS=0.14P AD=0.14P PS=1.06U PD=1.06U
M$733 VSS VSS VSS VSS nfet_03v3 L=2U W=0.5U AS=0.14P AD=0.14P PS=1.06U PD=1.06U
M$734 VSS VSS VSS VSS nfet_03v3 L=2U W=0.5U AS=0.14P AD=0.14P PS=1.06U PD=1.06U
M$735 VSS VSS VSS VSS nfet_03v3 L=2U W=0.5U AS=0.14P AD=0.14P PS=1.06U PD=1.06U
M$736 VSS VSS VSS VSS nfet_03v3 L=2U W=0.5U AS=0.14P AD=0.14P PS=1.06U PD=1.06U
M$737 VSS VSS VSS VSS nfet_03v3 L=2U W=0.5U AS=0.14P AD=0.14P PS=1.06U PD=1.06U
M$738 VSS VSS VSS VSS nfet_03v3 L=2U W=0.5U AS=0.14P AD=0.14P PS=1.06U PD=1.06U
M$739 VSS VSS VSS VSS nfet_03v3 L=2U W=0.5U AS=0.14P AD=0.14P PS=1.06U PD=1.06U
M$740 VSS VSS VSS VSS nfet_03v3 L=2U W=0.5U AS=0.14P AD=0.14P PS=1.06U PD=1.06U
M$741 VSS VSS VSS VSS nfet_03v3 L=2U W=0.5U AS=0.14P AD=0.14P PS=1.06U PD=1.06U
M$742 VSS VSS VSS VSS nfet_03v3 L=2U W=0.5U AS=0.14P AD=0.14P PS=1.06U PD=1.06U
M$743 VSS VSS VSS VSS nfet_03v3 L=2U W=0.5U AS=0.14P AD=0.14P PS=1.06U PD=1.06U
M$744 VSS VSS VSS VSS nfet_03v3 L=2U W=0.5U AS=0.14P AD=0.14P PS=1.06U PD=1.06U
M$745 VSS VSS VSS VSS nfet_03v3 L=2U W=0.5U AS=0.14P AD=0.14P PS=1.06U PD=1.06U
M$746 VSS VSS VSS VSS nfet_03v3 L=2U W=0.5U AS=0.14P AD=0.14P PS=1.06U PD=1.06U
M$747 VSS VSS VSS VSS nfet_03v3 L=2U W=0.5U AS=0.14P AD=0.14P PS=1.06U PD=1.06U
M$748 VSS VSS VSS VSS nfet_03v3 L=2U W=0.5U AS=0.14P AD=0.14P PS=1.06U PD=1.06U
M$749 VSS VSS VSS VSS nfet_03v3 L=2U W=0.5U AS=0.14P AD=0.14P PS=1.06U PD=1.06U
M$750 VSS VSS VSS VSS nfet_03v3 L=2U W=0.5U AS=0.14P AD=0.14P PS=1.06U PD=1.06U
M$751 VSS VSS VSS VSS nfet_03v3 L=2U W=0.5U AS=0.14P AD=0.14P PS=1.06U PD=1.06U
M$752 VSS VSS VSS VSS nfet_03v3 L=2U W=0.5U AS=0.14P AD=0.14P PS=1.06U PD=1.06U
M$753 VSS VSS VSS VSS nfet_03v3 L=2U W=0.5U AS=0.14P AD=0.14P PS=1.06U PD=1.06U
M$754 VSS VSS VSS VSS nfet_03v3 L=2U W=0.5U AS=0.14P AD=0.14P PS=1.06U PD=1.06U
M$755 VSS VSS VSS VSS nfet_03v3 L=2U W=0.5U AS=0.14P AD=0.14P PS=1.06U PD=1.06U
M$756 VSS VSS VSS VSS nfet_03v3 L=2U W=0.5U AS=0.14P AD=0.14P PS=1.06U PD=1.06U
M$757 VSS VSS VSS VSS nfet_03v3 L=2U W=0.5U AS=0.14P AD=0.14P PS=1.06U PD=1.06U
M$758 VSS VSS VSS VSS nfet_03v3 L=2U W=0.5U AS=0.14P AD=0.14P PS=1.06U PD=1.06U
M$759 VSS VSS VSS VSS nfet_03v3 L=2U W=0.5U AS=0.14P AD=0.14P PS=1.06U PD=1.06U
M$760 VSS VSS VSS VSS nfet_03v3 L=2U W=0.5U AS=0.14P AD=0.14P PS=1.06U PD=1.06U
M$761 VSS VSS VSS VSS nfet_03v3 L=2U W=0.5U AS=0.14P AD=0.14P PS=1.06U PD=1.06U
M$762 VSS VSS VSS VSS nfet_03v3 L=2U W=0.5U AS=0.14P AD=0.14P PS=1.06U PD=1.06U
M$763 VSS VSS VSS VSS nfet_03v3 L=2U W=0.5U AS=0.14P AD=0.14P PS=1.06U PD=1.06U
M$764 VSS VSS VSS VSS nfet_03v3 L=2U W=0.5U AS=0.14P AD=0.14P PS=1.06U PD=1.06U
M$765 VSS VSS VSS VSS nfet_03v3 L=2U W=0.5U AS=0.14P AD=0.14P PS=1.06U PD=1.06U
M$766 VSS VSS VSS VSS nfet_03v3 L=2U W=0.5U AS=0.14P AD=0.14P PS=1.06U PD=1.06U
M$767 VSS VSS VSS VSS nfet_03v3 L=2U W=0.5U AS=0.14P AD=0.14P PS=1.06U PD=1.06U
M$768 VSS VSS VSS VSS nfet_03v3 L=2U W=0.5U AS=0.14P AD=0.14P PS=1.06U PD=1.06U
M$769 VSS VSS VSS VSS nfet_03v3 L=2U W=0.5U AS=0.14P AD=0.14P PS=1.06U PD=1.06U
M$770 VSS VSS VSS VSS nfet_03v3 L=2U W=0.5U AS=0.14P AD=0.14P PS=1.06U PD=1.06U
M$771 VSS VSS VSS VSS nfet_03v3 L=2U W=0.5U AS=0.14P AD=0.3P PS=1.06U PD=2.2U
M$772 VSS VSS VSS VSS nfet_03v3 L=2U W=0.5U AS=0.14P AD=0.14P PS=1.06U PD=1.06U
M$773 VSS VSS VSS VSS nfet_03v3 L=2U W=0.5U AS=0.14P AD=0.14P PS=1.06U PD=1.06U
M$774 VSS VSS VSS VSS nfet_03v3 L=2U W=0.5U AS=0.14P AD=0.14P PS=1.06U PD=1.06U
M$775 VSS VSS VSS VSS nfet_03v3 L=2U W=0.5U AS=0.14P AD=0.14P PS=1.06U PD=1.06U
M$776 VSS VSS VSS VSS nfet_03v3 L=2U W=0.5U AS=0.14P AD=0.14P PS=1.06U PD=1.06U
M$777 VSS VSS VSS VSS nfet_03v3 L=2U W=0.5U AS=0.14P AD=0.14P PS=1.06U PD=1.06U
M$778 VSS VSS VSS VSS nfet_03v3 L=2U W=0.5U AS=0.14P AD=0.14P PS=1.06U PD=1.06U
M$779 VSS VSS VSS VSS nfet_03v3 L=2U W=0.5U AS=0.14P AD=0.14P PS=1.06U PD=1.06U
M$780 VSS VSS VSS VSS nfet_03v3 L=2U W=0.5U AS=0.14P AD=0.14P PS=1.06U PD=1.06U
M$781 VSS VSS VSS VSS nfet_03v3 L=2U W=0.5U AS=0.14P AD=0.14P PS=1.06U PD=1.06U
M$782 VSS VSS VSS VSS nfet_03v3 L=2U W=0.5U AS=0.14P AD=0.14P PS=1.06U PD=1.06U
M$783 VSS VSS VSS VSS nfet_03v3 L=2U W=0.5U AS=0.14P AD=0.14P PS=1.06U PD=1.06U
M$784 VSS VSS VSS VSS nfet_03v3 L=2U W=0.5U AS=0.14P AD=0.14P PS=1.06U PD=1.06U
M$785 VSS VSS VSS VSS nfet_03v3 L=2U W=0.5U AS=0.14P AD=0.14P PS=1.06U PD=1.06U
M$786 VSS VSS VSS VSS nfet_03v3 L=2U W=0.5U AS=0.14P AD=0.14P PS=1.06U PD=1.06U
M$787 VSS VSS VSS VSS nfet_03v3 L=2U W=0.5U AS=0.14P AD=0.14P PS=1.06U PD=1.06U
M$788 VSS VSS VSS VSS nfet_03v3 L=2U W=0.5U AS=0.14P AD=0.14P PS=1.06U PD=1.06U
M$789 VSS VSS VSS VSS nfet_03v3 L=2U W=0.5U AS=0.14P AD=0.14P PS=1.06U PD=1.06U
M$790 VSS VSS VSS VSS nfet_03v3 L=2U W=0.5U AS=0.14P AD=0.14P PS=1.06U PD=1.06U
M$791 VSS VSS VSS VSS nfet_03v3 L=2U W=0.5U AS=0.14P AD=0.14P PS=1.06U PD=1.06U
M$792 VSS VSS VSS VSS nfet_03v3 L=2U W=0.5U AS=0.14P AD=0.14P PS=1.06U PD=1.06U
M$793 VSS VSS VSS VSS nfet_03v3 L=2U W=0.5U AS=0.14P AD=0.14P PS=1.06U PD=1.06U
M$794 VSS VSS VSS VSS nfet_03v3 L=2U W=0.5U AS=0.14P AD=0.14P PS=1.06U PD=1.06U
M$795 VSS VSS VSS VSS nfet_03v3 L=2U W=0.5U AS=0.14P AD=0.14P PS=1.06U PD=1.06U
M$796 VSS VSS VSS VSS nfet_03v3 L=2U W=0.5U AS=0.14P AD=0.14P PS=1.06U PD=1.06U
M$797 VSS VSS VSS VSS nfet_03v3 L=2U W=0.5U AS=0.14P AD=0.14P PS=1.06U PD=1.06U
M$798 VSS VSS VSS VSS nfet_03v3 L=2U W=0.5U AS=0.14P AD=0.14P PS=1.06U PD=1.06U
M$799 VSS VSS VSS VSS nfet_03v3 L=2U W=0.5U AS=0.14P AD=0.14P PS=1.06U PD=1.06U
M$800 VSS VSS VSS VSS nfet_03v3 L=2U W=0.5U AS=0.14P AD=0.14P PS=1.06U PD=1.06U
M$801 VSS VSS VSS VSS nfet_03v3 L=2U W=0.5U AS=0.14P AD=0.14P PS=1.06U PD=1.06U
M$802 VSS VSS VSS VSS nfet_03v3 L=2U W=0.5U AS=0.14P AD=0.14P PS=1.06U PD=1.06U
M$803 VSS VSS VSS VSS nfet_03v3 L=2U W=0.5U AS=0.14P AD=0.14P PS=1.06U PD=1.06U
M$804 VSS VSS VSS VSS nfet_03v3 L=2U W=0.5U AS=0.14P AD=0.14P PS=1.06U PD=1.06U
M$805 VSS VSS VSS VSS nfet_03v3 L=2U W=0.5U AS=0.14P AD=0.14P PS=1.06U PD=1.06U
M$806 VSS VSS VSS VSS nfet_03v3 L=2U W=0.5U AS=0.14P AD=0.14P PS=1.06U PD=1.06U
M$807 VSS VSS VSS VSS nfet_03v3 L=2U W=0.5U AS=0.14P AD=0.14P PS=1.06U PD=1.06U
M$808 VSS VSS VSS VSS nfet_03v3 L=2U W=0.5U AS=0.14P AD=0.14P PS=1.06U PD=1.06U
M$809 VSS VSS VSS VSS nfet_03v3 L=2U W=0.5U AS=0.14P AD=0.14P PS=1.06U PD=1.06U
M$810 VSS VSS VSS VSS nfet_03v3 L=2U W=0.5U AS=0.14P AD=0.14P PS=1.06U PD=1.06U
M$811 VSS VSS VSS VSS nfet_03v3 L=2U W=0.5U AS=0.14P AD=0.14P PS=1.06U PD=1.06U
M$812 VSS VSS VSS VSS nfet_03v3 L=2U W=0.5U AS=0.14P AD=0.14P PS=1.06U PD=1.06U
M$813 VSS VSS VSS VSS nfet_03v3 L=2U W=0.5U AS=0.14P AD=0.14P PS=1.06U PD=1.06U
M$814 VSS VSS VSS VSS nfet_03v3 L=2U W=0.5U AS=0.14P AD=0.14P PS=1.06U PD=1.06U
M$815 VSS VSS VSS VSS nfet_03v3 L=2U W=0.5U AS=0.14P AD=0.14P PS=1.06U PD=1.06U
M$816 VSS VSS VSS VSS nfet_03v3 L=2U W=0.5U AS=0.14P AD=0.14P PS=1.06U PD=1.06U
M$817 VSS VSS VSS VSS nfet_03v3 L=2U W=0.5U AS=0.14P AD=0.14P PS=1.06U PD=1.06U
M$818 VSS VSS VSS VSS nfet_03v3 L=2U W=0.5U AS=0.14P AD=0.14P PS=1.06U PD=1.06U
M$819 VSS VSS VSS VSS nfet_03v3 L=2U W=0.5U AS=0.14P AD=0.14P PS=1.06U PD=1.06U
M$820 VSS VSS VSS VSS nfet_03v3 L=2U W=0.5U AS=0.14P AD=0.14P PS=1.06U PD=1.06U
M$821 VSS VSS VSS VSS nfet_03v3 L=2U W=0.5U AS=0.14P AD=0.14P PS=1.06U PD=1.06U
M$822 VSS VSS VSS VSS nfet_03v3 L=2U W=0.5U AS=0.14P AD=0.14P PS=1.06U PD=1.06U
M$823 VSS VSS VSS VSS nfet_03v3 L=2U W=0.5U AS=0.14P AD=0.14P PS=1.06U PD=1.06U
M$824 VSS VSS VSS VSS nfet_03v3 L=2U W=0.5U AS=0.14P AD=0.14P PS=1.06U PD=1.06U
M$825 VSS VSS VSS VSS nfet_03v3 L=2U W=0.5U AS=0.14P AD=0.14P PS=1.06U PD=1.06U
M$826 VSS VSS VSS VSS nfet_03v3 L=2U W=0.5U AS=0.14P AD=0.14P PS=1.06U PD=1.06U
M$827 VSS VSS VSS VSS nfet_03v3 L=2U W=0.5U AS=0.14P AD=0.14P PS=1.06U PD=1.06U
M$828 VSS VSS VSS VSS nfet_03v3 L=2U W=0.5U AS=0.14P AD=0.14P PS=1.06U PD=1.06U
M$829 VSS VSS VSS VSS nfet_03v3 L=2U W=0.5U AS=0.14P AD=0.14P PS=1.06U PD=1.06U
M$830 VSS VSS VSS VSS nfet_03v3 L=2U W=0.5U AS=0.14P AD=0.14P PS=1.06U PD=1.06U
M$831 VSS VSS VSS VSS nfet_03v3 L=2U W=0.5U AS=0.14P AD=0.14P PS=1.06U PD=1.06U
M$832 VSS VSS VSS VSS nfet_03v3 L=2U W=0.5U AS=0.14P AD=0.14P PS=1.06U PD=1.06U
M$833 VSS VSS VSS VSS nfet_03v3 L=2U W=0.5U AS=0.14P AD=0.14P PS=1.06U PD=1.06U
M$834 VSS VSS VSS VSS nfet_03v3 L=2U W=0.5U AS=0.14P AD=0.14P PS=1.06U PD=1.06U
M$835 VSS VSS VSS VSS nfet_03v3 L=2U W=0.5U AS=0.14P AD=0.14P PS=1.06U PD=1.06U
M$836 VSS VSS VSS VSS nfet_03v3 L=2U W=0.5U AS=0.14P AD=0.14P PS=1.06U PD=1.06U
M$837 VSS VSS VSS VSS nfet_03v3 L=2U W=0.5U AS=0.14P AD=0.14P PS=1.06U PD=1.06U
M$838 VSS VSS VSS VSS nfet_03v3 L=2U W=0.5U AS=0.14P AD=0.14P PS=1.06U PD=1.06U
M$839 VSS VSS VSS VSS nfet_03v3 L=2U W=0.5U AS=0.14P AD=0.14P PS=1.06U PD=1.06U
M$840 VSS VSS VSS VSS nfet_03v3 L=2U W=0.5U AS=0.14P AD=0.14P PS=1.06U PD=1.06U
M$841 VSS VSS VSS VSS nfet_03v3 L=2U W=0.5U AS=0.14P AD=0.14P PS=1.06U PD=1.06U
M$842 VSS VSS VSS VSS nfet_03v3 L=2U W=0.5U AS=0.14P AD=0.14P PS=1.06U PD=1.06U
M$843 VSS VSS VSS VSS nfet_03v3 L=2U W=0.5U AS=0.14P AD=0.14P PS=1.06U PD=1.06U
M$844 VSS VSS VSS VSS nfet_03v3 L=2U W=0.5U AS=0.14P AD=0.14P PS=1.06U PD=1.06U
M$845 VSS VSS VSS VSS nfet_03v3 L=2U W=0.5U AS=0.14P AD=0.14P PS=1.06U PD=1.06U
M$846 VSS VSS VSS VSS nfet_03v3 L=2U W=0.5U AS=0.14P AD=0.14P PS=1.06U PD=1.06U
M$847 VSS VSS VSS VSS nfet_03v3 L=2U W=0.5U AS=0.14P AD=0.14P PS=1.06U PD=1.06U
M$848 VSS VSS VSS VSS nfet_03v3 L=2U W=0.5U AS=0.14P AD=0.14P PS=1.06U PD=1.06U
M$849 VSS VSS VSS VSS nfet_03v3 L=2U W=0.5U AS=0.14P AD=0.14P PS=1.06U PD=1.06U
M$850 VSS VSS VSS VSS nfet_03v3 L=2U W=0.5U AS=0.14P AD=0.14P PS=1.06U PD=1.06U
M$851 VSS VSS VSS VSS nfet_03v3 L=2U W=0.5U AS=0.14P AD=0.14P PS=1.06U PD=1.06U
M$852 VSS VSS VSS VSS nfet_03v3 L=2U W=0.5U AS=0.14P AD=0.14P PS=1.06U PD=1.06U
M$853 VSS VSS VSS VSS nfet_03v3 L=2U W=0.5U AS=0.14P AD=0.14P PS=1.06U PD=1.06U
M$854 VSS VSS VSS VSS nfet_03v3 L=2U W=0.5U AS=0.14P AD=0.14P PS=1.06U PD=1.06U
M$855 VSS VSS VSS VSS nfet_03v3 L=2U W=0.5U AS=0.14P AD=0.14P PS=1.06U PD=1.06U
M$856 VSS VSS VSS VSS nfet_03v3 L=2U W=0.5U AS=0.14P AD=0.14P PS=1.06U PD=1.06U
M$857 VSS VSS VSS VSS nfet_03v3 L=2U W=0.5U AS=0.14P AD=0.14P PS=1.06U PD=1.06U
M$858 VSS VSS VSS VSS nfet_03v3 L=2U W=0.5U AS=0.14P AD=0.14P PS=1.06U PD=1.06U
M$859 VSS VSS VSS VSS nfet_03v3 L=2U W=0.5U AS=0.14P AD=0.14P PS=1.06U PD=1.06U
M$860 VSS VSS VSS VSS nfet_03v3 L=2U W=0.5U AS=0.14P AD=0.14P PS=1.06U PD=1.06U
M$861 VSS VSS VSS VSS nfet_03v3 L=2U W=0.5U AS=0.14P AD=0.14P PS=1.06U PD=1.06U
M$862 VSS VSS VSS VSS nfet_03v3 L=2U W=0.5U AS=0.14P AD=0.14P PS=1.06U PD=1.06U
M$863 VSS VSS VSS VSS nfet_03v3 L=2U W=0.5U AS=0.14P AD=0.14P PS=1.06U PD=1.06U
M$864 VSS VSS VSS VSS nfet_03v3 L=2U W=0.5U AS=0.14P AD=0.14P PS=1.06U PD=1.06U
M$865 VSS VSS VSS VSS nfet_03v3 L=2U W=0.5U AS=0.14P AD=0.14P PS=1.06U PD=1.06U
M$866 VSS VSS VSS VSS nfet_03v3 L=2U W=0.5U AS=0.14P AD=0.14P PS=1.06U PD=1.06U
M$867 VSS VSS VSS VSS nfet_03v3 L=2U W=0.5U AS=0.14P AD=0.14P PS=1.06U PD=1.06U
M$868 VSS VSS VSS VSS nfet_03v3 L=2U W=0.5U AS=0.14P AD=0.14P PS=1.06U PD=1.06U
M$869 VSS VSS VSS VSS nfet_03v3 L=2U W=0.5U AS=0.14P AD=0.14P PS=1.06U PD=1.06U
M$870 VSS VSS VSS VSS nfet_03v3 L=2U W=0.5U AS=0.14P AD=0.14P PS=1.06U PD=1.06U
M$871 VSS VSS VSS VSS nfet_03v3 L=2U W=0.5U AS=0.14P AD=0.14P PS=1.06U PD=1.06U
M$872 VSS VSS VSS VSS nfet_03v3 L=2U W=0.5U AS=0.14P AD=0.14P PS=1.06U PD=1.06U
M$873 VSS VSS VSS VSS nfet_03v3 L=2U W=0.5U AS=0.14P AD=0.14P PS=1.06U PD=1.06U
M$874 VSS VSS VSS VSS nfet_03v3 L=2U W=0.5U AS=0.14P AD=0.14P PS=1.06U PD=1.06U
M$875 VSS VSS VSS VSS nfet_03v3 L=2U W=0.5U AS=0.14P AD=0.14P PS=1.06U PD=1.06U
M$876 VSS VSS VSS VSS nfet_03v3 L=2U W=0.5U AS=0.14P AD=0.14P PS=1.06U PD=1.06U
M$877 VSS VSS VSS VSS nfet_03v3 L=2U W=0.5U AS=0.14P AD=0.14P PS=1.06U PD=1.06U
M$878 VSS VSS VSS VSS nfet_03v3 L=2U W=0.5U AS=0.14P AD=0.14P PS=1.06U PD=1.06U
M$879 VSS VSS VSS VSS nfet_03v3 L=2U W=0.5U AS=0.14P AD=0.14P PS=1.06U PD=1.06U
M$880 VSS VSS VSS VSS nfet_03v3 L=2U W=0.5U AS=0.14P AD=0.14P PS=1.06U PD=1.06U
M$881 VSS VSS VSS VSS nfet_03v3 L=2U W=0.5U AS=0.14P AD=0.14P PS=1.06U PD=1.06U
M$882 VSS VSS VSS VSS nfet_03v3 L=2U W=0.5U AS=0.14P AD=0.14P PS=1.06U PD=1.06U
M$883 VSS VSS VSS VSS nfet_03v3 L=2U W=0.5U AS=0.14P AD=0.14P PS=1.06U PD=1.06U
M$884 VSS VSS VSS VSS nfet_03v3 L=2U W=0.5U AS=0.14P AD=0.14P PS=1.06U PD=1.06U
M$885 VSS VSS VSS VSS nfet_03v3 L=2U W=0.5U AS=0.14P AD=0.14P PS=1.06U PD=1.06U
M$886 VSS VSS VSS VSS nfet_03v3 L=2U W=0.5U AS=0.14P AD=0.14P PS=1.06U PD=1.06U
M$887 VSS VSS VSS VSS nfet_03v3 L=2U W=0.5U AS=0.14P AD=0.14P PS=1.06U PD=1.06U
M$888 VSS VSS VSS VSS nfet_03v3 L=2U W=0.5U AS=0.14P AD=0.14P PS=1.06U PD=1.06U
M$889 VSS VSS VSS VSS nfet_03v3 L=2U W=0.5U AS=0.14P AD=0.14P PS=1.06U PD=1.06U
M$890 VSS VSS VSS VSS nfet_03v3 L=2U W=0.5U AS=0.14P AD=0.14P PS=1.06U PD=1.06U
M$891 VSS VSS VSS VSS nfet_03v3 L=2U W=0.5U AS=0.14P AD=0.14P PS=1.06U PD=1.06U
M$892 VSS VSS VSS VSS nfet_03v3 L=2U W=0.5U AS=0.14P AD=0.14P PS=1.06U PD=1.06U
M$893 VSS VSS VSS VSS nfet_03v3 L=2U W=0.5U AS=0.14P AD=0.14P PS=1.06U PD=1.06U
M$894 VSS VSS VSS VSS nfet_03v3 L=2U W=0.5U AS=0.14P AD=0.14P PS=1.06U PD=1.06U
M$895 VSS VSS VSS VSS nfet_03v3 L=2U W=0.5U AS=0.14P AD=0.14P PS=1.06U PD=1.06U
M$896 VSS VSS VSS VSS nfet_03v3 L=2U W=0.5U AS=0.14P AD=0.14P PS=1.06U PD=1.06U
M$897 VSS VSS VSS VSS nfet_03v3 L=2U W=0.5U AS=0.14P AD=0.14P PS=1.06U PD=1.06U
M$898 VSS VSS VSS VSS nfet_03v3 L=2U W=0.5U AS=0.14P AD=0.14P PS=1.06U PD=1.06U
M$899 VSS VSS VSS VSS nfet_03v3 L=2U W=0.5U AS=0.14P AD=0.14P PS=1.06U PD=1.06U
M$900 VSS VSS VSS VSS nfet_03v3 L=2U W=0.5U AS=0.14P AD=0.14P PS=1.06U PD=1.06U
M$901 VSS VSS VSS VSS nfet_03v3 L=2U W=0.5U AS=0.14P AD=0.14P PS=1.06U PD=1.06U
M$902 VSS VSS VSS VSS nfet_03v3 L=2U W=0.5U AS=0.14P AD=0.14P PS=1.06U PD=1.06U
M$903 VSS VSS VSS VSS nfet_03v3 L=2U W=0.5U AS=0.14P AD=0.14P PS=1.06U PD=1.06U
M$904 VSS VSS VSS VSS nfet_03v3 L=2U W=0.5U AS=0.14P AD=0.14P PS=1.06U PD=1.06U
M$905 VSS VSS VSS VSS nfet_03v3 L=2U W=0.5U AS=0.14P AD=0.14P PS=1.06U PD=1.06U
M$906 VSS VSS VSS VSS nfet_03v3 L=2U W=0.5U AS=0.14P AD=0.14P PS=1.06U PD=1.06U
M$907 VSS VSS VSS VSS nfet_03v3 L=2U W=0.5U AS=0.14P AD=0.14P PS=1.06U PD=1.06U
M$908 VSS VSS VSS VSS nfet_03v3 L=2U W=0.5U AS=0.14P AD=0.14P PS=1.06U PD=1.06U
M$909 VSS VSS VSS VSS nfet_03v3 L=2U W=0.5U AS=0.14P AD=0.14P PS=1.06U PD=1.06U
M$910 VSS VSS VSS VSS nfet_03v3 L=2U W=0.5U AS=0.14P AD=0.14P PS=1.06U PD=1.06U
M$911 VSS VSS VSS VSS nfet_03v3 L=2U W=0.5U AS=0.14P AD=0.14P PS=1.06U PD=1.06U
M$912 VSS VSS VSS VSS nfet_03v3 L=2U W=0.5U AS=0.14P AD=0.14P PS=1.06U PD=1.06U
M$913 VSS VSS VSS VSS nfet_03v3 L=2U W=0.5U AS=0.14P AD=0.14P PS=1.06U PD=1.06U
M$914 VSS VSS VSS VSS nfet_03v3 L=2U W=0.5U AS=0.14P AD=0.14P PS=1.06U PD=1.06U
M$915 VSS VSS VSS VSS nfet_03v3 L=2U W=0.5U AS=0.14P AD=0.14P PS=1.06U PD=1.06U
M$916 VSS VSS VSS VSS nfet_03v3 L=2U W=0.5U AS=0.14P AD=0.14P PS=1.06U PD=1.06U
M$917 VSS VSS VSS VSS nfet_03v3 L=2U W=0.5U AS=0.14P AD=0.14P PS=1.06U PD=1.06U
M$918 VSS VSS VSS VSS nfet_03v3 L=2U W=0.5U AS=0.14P AD=0.14P PS=1.06U PD=1.06U
M$919 VSS VSS VSS VSS nfet_03v3 L=2U W=0.5U AS=0.14P AD=0.14P PS=1.06U PD=1.06U
M$920 VSS VSS VSS VSS nfet_03v3 L=2U W=0.5U AS=0.14P AD=0.14P PS=1.06U PD=1.06U
M$921 VSS VSS VSS VSS nfet_03v3 L=2U W=0.5U AS=0.14P AD=0.14P PS=1.06U PD=1.06U
M$922 VSS VSS VSS VSS nfet_03v3 L=2U W=0.5U AS=0.14P AD=0.14P PS=1.06U PD=1.06U
M$923 VSS VSS VSS VSS nfet_03v3 L=2U W=0.5U AS=0.14P AD=0.14P PS=1.06U PD=1.06U
M$924 VSS VSS VSS VSS nfet_03v3 L=2U W=0.5U AS=0.14P AD=0.14P PS=1.06U PD=1.06U
M$925 VSS VSS VSS VSS nfet_03v3 L=2U W=0.5U AS=0.14P AD=0.14P PS=1.06U PD=1.06U
M$926 VSS VSS VSS VSS nfet_03v3 L=2U W=0.5U AS=0.14P AD=0.14P PS=1.06U PD=1.06U
M$927 VSS VSS VSS VSS nfet_03v3 L=2U W=0.5U AS=0.14P AD=0.14P PS=1.06U PD=1.06U
M$928 VSS VSS VSS VSS nfet_03v3 L=2U W=0.5U AS=0.14P AD=0.14P PS=1.06U PD=1.06U
M$929 VSS VSS VSS VSS nfet_03v3 L=2U W=0.5U AS=0.14P AD=0.14P PS=1.06U PD=1.06U
M$930 VSS VSS VSS VSS nfet_03v3 L=2U W=0.5U AS=0.14P AD=0.14P PS=1.06U PD=1.06U
M$931 VSS VSS VSS VSS nfet_03v3 L=2U W=0.5U AS=0.14P AD=0.14P PS=1.06U PD=1.06U
M$932 VSS VSS VSS VSS nfet_03v3 L=2U W=0.5U AS=0.14P AD=0.14P PS=1.06U PD=1.06U
M$933 VSS VSS VSS VSS nfet_03v3 L=2U W=0.5U AS=0.14P AD=0.14P PS=1.06U PD=1.06U
M$934 VSS VSS VSS VSS nfet_03v3 L=2U W=0.5U AS=0.14P AD=0.14P PS=1.06U PD=1.06U
M$935 VSS VSS VSS VSS nfet_03v3 L=2U W=0.5U AS=0.14P AD=0.14P PS=1.06U PD=1.06U
M$936 VSS VSS VSS VSS nfet_03v3 L=2U W=0.5U AS=0.14P AD=0.14P PS=1.06U PD=1.06U
M$937 VSS VSS VSS VSS nfet_03v3 L=2U W=0.5U AS=0.14P AD=0.14P PS=1.06U PD=1.06U
M$938 VSS VSS VSS VSS nfet_03v3 L=2U W=0.5U AS=0.14P AD=0.14P PS=1.06U PD=1.06U
M$939 VSS VSS VSS VSS nfet_03v3 L=2U W=0.5U AS=0.14P AD=0.14P PS=1.06U PD=1.06U
M$940 VSS VSS VSS VSS nfet_03v3 L=2U W=0.5U AS=0.14P AD=0.14P PS=1.06U PD=1.06U
M$941 VSS VSS VSS VSS nfet_03v3 L=2U W=0.5U AS=0.14P AD=0.14P PS=1.06U PD=1.06U
M$942 VSS VSS VSS VSS nfet_03v3 L=2U W=0.5U AS=0.14P AD=0.14P PS=1.06U PD=1.06U
M$943 VSS VSS VSS VSS nfet_03v3 L=2U W=0.5U AS=0.14P AD=0.14P PS=1.06U PD=1.06U
M$944 VSS VSS VSS VSS nfet_03v3 L=2U W=0.5U AS=0.14P AD=0.14P PS=1.06U PD=1.06U
M$945 VSS VSS VSS VSS nfet_03v3 L=2U W=0.5U AS=0.14P AD=0.14P PS=1.06U PD=1.06U
M$946 VSS VSS VSS VSS nfet_03v3 L=2U W=0.5U AS=0.14P AD=0.14P PS=1.06U PD=1.06U
M$947 VSS VSS VSS VSS nfet_03v3 L=2U W=0.5U AS=0.14P AD=0.14P PS=1.06U PD=1.06U
M$948 VSS VSS VSS VSS nfet_03v3 L=2U W=0.5U AS=0.14P AD=0.14P PS=1.06U PD=1.06U
M$949 VSS VSS VSS VSS nfet_03v3 L=2U W=0.5U AS=0.14P AD=0.14P PS=1.06U PD=1.06U
M$950 VSS VSS VSS VSS nfet_03v3 L=2U W=0.5U AS=0.14P AD=0.14P PS=1.06U PD=1.06U
M$951 VSS VSS VSS VSS nfet_03v3 L=2U W=0.5U AS=0.14P AD=0.14P PS=1.06U PD=1.06U
M$952 VSS VSS VSS VSS nfet_03v3 L=2U W=0.5U AS=0.14P AD=0.14P PS=1.06U PD=1.06U
M$953 VSS VSS VSS VSS nfet_03v3 L=2U W=0.5U AS=0.14P AD=0.14P PS=1.06U PD=1.06U
M$954 VSS VSS VSS VSS nfet_03v3 L=2U W=0.5U AS=0.14P AD=0.14P PS=1.06U PD=1.06U
M$955 VSS VSS VSS VSS nfet_03v3 L=2U W=0.5U AS=0.14P AD=0.14P PS=1.06U PD=1.06U
M$956 VSS VSS VSS VSS nfet_03v3 L=2U W=0.5U AS=0.14P AD=0.14P PS=1.06U PD=1.06U
M$957 VSS VSS VSS VSS nfet_03v3 L=2U W=0.5U AS=0.14P AD=0.14P PS=1.06U PD=1.06U
M$958 VSS VSS VSS VSS nfet_03v3 L=2U W=0.5U AS=0.14P AD=0.14P PS=1.06U PD=1.06U
M$959 VSS VSS VSS VSS nfet_03v3 L=2U W=0.5U AS=0.14P AD=0.14P PS=1.06U PD=1.06U
M$960 VSS VSS VSS VSS nfet_03v3 L=2U W=0.5U AS=0.14P AD=0.14P PS=1.06U PD=1.06U
M$961 VSS VSS VSS VSS nfet_03v3 L=2U W=0.5U AS=0.14P AD=0.14P PS=1.06U PD=1.06U
M$962 VSS VSS VSS VSS nfet_03v3 L=2U W=0.5U AS=0.14P AD=0.14P PS=1.06U PD=1.06U
M$963 VSS VSS VSS VSS nfet_03v3 L=2U W=0.5U AS=0.14P AD=0.14P PS=1.06U PD=1.06U
M$964 VSS VSS VSS VSS nfet_03v3 L=2U W=0.5U AS=0.14P AD=0.14P PS=1.06U PD=1.06U
M$965 VSS VSS VSS VSS nfet_03v3 L=2U W=0.5U AS=0.14P AD=0.14P PS=1.06U PD=1.06U
M$966 VSS VSS VSS VSS nfet_03v3 L=2U W=0.5U AS=0.14P AD=0.14P PS=1.06U PD=1.06U
M$967 VSS VSS VSS VSS nfet_03v3 L=2U W=0.5U AS=0.3P AD=0.14P PS=2.2U PD=1.06U
M$968 \$275 \$140 VSS VSS nfet_03v3 L=6U W=1U AS=0.6P AD=0.6P PS=3.2U PD=3.2U
M$969 \$140 \$140 VSS VSS nfet_03v3 L=6U W=1U AS=0.6P AD=0.6P PS=3.2U PD=3.2U
M$970 \$275 \$140 VSS VSS nfet_03v3 L=6U W=1U AS=0.6P AD=0.6P PS=3.2U PD=3.2U
M$971 Iref \$140 VSS VSS nfet_03v3 L=6U W=1U AS=0.6P AD=0.6P PS=3.2U PD=3.2U
M$972 \$275 \$140 VSS VSS nfet_03v3 L=6U W=1U AS=0.6P AD=0.6P PS=3.2U PD=3.2U
M$973 \$140 \$140 VSS VSS nfet_03v3 L=6U W=1U AS=0.6P AD=0.6P PS=3.2U PD=3.2U
M$974 \$275 \$140 VSS VSS nfet_03v3 L=6U W=1U AS=0.6P AD=0.6P PS=3.2U PD=3.2U
M$975 \$275 \$140 VSS VSS nfet_03v3 L=6U W=1U AS=0.6P AD=0.6P PS=3.2U PD=3.2U
M$976 \$140 \$140 VSS VSS nfet_03v3 L=6U W=1U AS=0.6P AD=0.6P PS=3.2U PD=3.2U
M$977 \$275 \$140 VSS VSS nfet_03v3 L=6U W=1U AS=0.6P AD=0.6P PS=3.2U PD=3.2U
M$978 Iref \$140 VSS VSS nfet_03v3 L=6U W=1U AS=0.6P AD=0.6P PS=3.2U PD=3.2U
M$979 \$275 \$140 VSS VSS nfet_03v3 L=6U W=1U AS=0.6P AD=0.6P PS=3.2U PD=3.2U
M$980 \$140 \$140 VSS VSS nfet_03v3 L=6U W=1U AS=0.6P AD=0.6P PS=3.2U PD=3.2U
M$981 \$275 \$140 VSS VSS nfet_03v3 L=6U W=1U AS=0.6P AD=0.6P PS=3.2U PD=3.2U
M$982 \$275 \$140 VSS VSS nfet_03v3 L=6U W=1U AS=0.6P AD=0.6P PS=3.2U PD=3.2U
M$983 \$140 \$140 VSS VSS nfet_03v3 L=6U W=1U AS=0.6P AD=0.6P PS=3.2U PD=3.2U
M$984 \$275 \$140 VSS VSS nfet_03v3 L=6U W=1U AS=0.6P AD=0.6P PS=3.2U PD=3.2U
M$985 Iref \$140 VSS VSS nfet_03v3 L=6U W=1U AS=0.6P AD=0.6P PS=3.2U PD=3.2U
M$986 \$275 \$140 VSS VSS nfet_03v3 L=6U W=1U AS=0.6P AD=0.6P PS=3.2U PD=3.2U
M$987 \$140 \$140 VSS VSS nfet_03v3 L=6U W=1U AS=0.6P AD=0.6P PS=3.2U PD=3.2U
M$988 \$275 \$140 VSS VSS nfet_03v3 L=6U W=1U AS=0.6P AD=0.6P PS=3.2U PD=3.2U
M$989 \$275 \$140 VSS VSS nfet_03v3 L=6U W=1U AS=0.6P AD=0.6P PS=3.2U PD=3.2U
M$990 \$140 \$140 VSS VSS nfet_03v3 L=6U W=1U AS=0.6P AD=0.6P PS=3.2U PD=3.2U
M$991 \$275 \$140 VSS VSS nfet_03v3 L=6U W=1U AS=0.6P AD=0.6P PS=3.2U PD=3.2U
M$992 Iref \$140 VSS VSS nfet_03v3 L=6U W=1U AS=0.6P AD=0.6P PS=3.2U PD=3.2U
M$993 \$275 \$140 VSS VSS nfet_03v3 L=6U W=1U AS=0.6P AD=0.6P PS=3.2U PD=3.2U
M$994 \$140 \$140 VSS VSS nfet_03v3 L=6U W=1U AS=0.6P AD=0.6P PS=3.2U PD=3.2U
M$995 \$275 \$140 VSS VSS nfet_03v3 L=6U W=1U AS=0.6P AD=0.6P PS=3.2U PD=3.2U
M$996 \$274 \$140 \$273 VSS nfet_03v3 L=6U W=1U AS=0.6P AD=0.28P PS=3.2U
+ PD=1.56U
M$997 \$273 \$140 \$274 VSS nfet_03v3 L=6U W=1U AS=0.28P AD=0.28P PS=1.56U
+ PD=1.56U
M$998 \$274 \$140 \$273 VSS nfet_03v3 L=6U W=1U AS=0.28P AD=0.28P PS=1.56U
+ PD=1.56U
M$999 \$273 \$140 \$274 VSS nfet_03v3 L=6U W=1U AS=0.28P AD=0.28P PS=1.56U
+ PD=1.56U
M$1000 \$274 \$140 \$273 VSS nfet_03v3 L=6U W=1U AS=0.28P AD=0.28P PS=1.56U
+ PD=1.56U
M$1001 \$273 \$140 \$274 VSS nfet_03v3 L=6U W=1U AS=0.28P AD=0.28P PS=1.56U
+ PD=1.56U
M$1002 \$274 \$140 \$273 VSS nfet_03v3 L=6U W=1U AS=0.28P AD=0.28P PS=1.56U
+ PD=1.56U
M$1003 \$273 \$140 \$274 VSS nfet_03v3 L=6U W=1U AS=0.28P AD=0.28P PS=1.56U
+ PD=1.56U
M$1004 \$274 \$140 \$273 VSS nfet_03v3 L=6U W=1U AS=0.28P AD=0.28P PS=1.56U
+ PD=1.56U
M$1005 \$273 \$140 \$274 VSS nfet_03v3 L=6U W=1U AS=0.28P AD=0.28P PS=1.56U
+ PD=1.56U
M$1006 \$274 \$140 \$273 VSS nfet_03v3 L=6U W=1U AS=0.28P AD=0.28P PS=1.56U
+ PD=1.56U
M$1007 \$273 \$140 \$274 VSS nfet_03v3 L=6U W=1U AS=0.28P AD=0.28P PS=1.56U
+ PD=1.56U
M$1008 \$274 \$140 \$273 VSS nfet_03v3 L=6U W=1U AS=0.28P AD=0.28P PS=1.56U
+ PD=1.56U
M$1009 \$273 \$140 \$274 VSS nfet_03v3 L=6U W=1U AS=0.28P AD=0.28P PS=1.56U
+ PD=1.56U
M$1010 \$274 \$140 \$273 VSS nfet_03v3 L=6U W=1U AS=0.28P AD=0.28P PS=1.56U
+ PD=1.56U
M$1011 \$273 \$140 \$274 VSS nfet_03v3 L=6U W=1U AS=0.28P AD=0.28P PS=1.56U
+ PD=1.56U
M$1012 \$274 \$140 \$273 VSS nfet_03v3 L=6U W=1U AS=0.28P AD=0.28P PS=1.56U
+ PD=1.56U
M$1013 \$273 \$140 \$274 VSS nfet_03v3 L=6U W=1U AS=0.28P AD=0.28P PS=1.56U
+ PD=1.56U
M$1014 \$274 \$140 \$273 VSS nfet_03v3 L=6U W=1U AS=0.28P AD=0.28P PS=1.56U
+ PD=1.56U
M$1015 \$273 \$140 \$274 VSS nfet_03v3 L=6U W=1U AS=0.28P AD=0.28P PS=1.56U
+ PD=1.56U
M$1016 \$274 \$140 \$273 VSS nfet_03v3 L=6U W=1U AS=0.28P AD=0.28P PS=1.56U
+ PD=1.56U
M$1017 \$273 \$140 \$274 VSS nfet_03v3 L=6U W=1U AS=0.28P AD=0.28P PS=1.56U
+ PD=1.56U
M$1018 \$274 \$140 \$273 VSS nfet_03v3 L=6U W=1U AS=0.28P AD=0.28P PS=1.56U
+ PD=1.56U
M$1019 \$273 \$140 \$274 VSS nfet_03v3 L=6U W=1U AS=0.28P AD=0.28P PS=1.56U
+ PD=1.56U
M$1020 \$274 \$140 \$273 VSS nfet_03v3 L=6U W=1U AS=0.28P AD=0.28P PS=1.56U
+ PD=1.56U
M$1021 \$273 \$140 \$274 VSS nfet_03v3 L=6U W=1U AS=0.28P AD=0.28P PS=1.56U
+ PD=1.56U
M$1022 \$274 \$140 \$273 VSS nfet_03v3 L=6U W=1U AS=0.28P AD=0.28P PS=1.56U
+ PD=1.56U
M$1023 \$273 \$140 \$274 VSS nfet_03v3 L=6U W=1U AS=0.28P AD=0.28P PS=1.56U
+ PD=1.56U
M$1024 \$274 \$140 \$273 VSS nfet_03v3 L=6U W=1U AS=0.28P AD=0.28P PS=1.56U
+ PD=1.56U
M$1025 \$273 \$140 \$274 VSS nfet_03v3 L=6U W=1U AS=0.28P AD=0.28P PS=1.56U
+ PD=1.56U
M$1026 \$274 \$140 \$273 VSS nfet_03v3 L=6U W=1U AS=0.28P AD=0.28P PS=1.56U
+ PD=1.56U
M$1027 \$273 \$140 \$274 VSS nfet_03v3 L=6U W=1U AS=0.28P AD=0.28P PS=1.56U
+ PD=1.56U
M$1028 \$274 \$140 \$273 VSS nfet_03v3 L=6U W=1U AS=0.28P AD=0.28P PS=1.56U
+ PD=1.56U
M$1029 \$273 \$140 \$274 VSS nfet_03v3 L=6U W=1U AS=0.28P AD=0.28P PS=1.56U
+ PD=1.56U
M$1030 \$274 \$140 \$273 VSS nfet_03v3 L=6U W=1U AS=0.28P AD=0.28P PS=1.56U
+ PD=1.56U
M$1031 \$273 \$140 \$274 VSS nfet_03v3 L=6U W=1U AS=0.28P AD=0.28P PS=1.56U
+ PD=1.56U
M$1032 \$274 \$140 \$273 VSS nfet_03v3 L=6U W=1U AS=0.28P AD=0.28P PS=1.56U
+ PD=1.56U
M$1033 \$273 \$140 \$274 VSS nfet_03v3 L=6U W=1U AS=0.28P AD=0.28P PS=1.56U
+ PD=1.56U
M$1034 \$274 \$140 \$273 VSS nfet_03v3 L=6U W=1U AS=0.28P AD=0.28P PS=1.56U
+ PD=1.56U
M$1035 \$273 \$140 \$274 VSS nfet_03v3 L=6U W=1U AS=0.28P AD=0.28P PS=1.56U
+ PD=1.56U
M$1036 \$274 \$140 \$273 VSS nfet_03v3 L=6U W=1U AS=0.28P AD=0.28P PS=1.56U
+ PD=1.56U
M$1037 \$273 \$140 \$274 VSS nfet_03v3 L=6U W=1U AS=0.28P AD=0.28P PS=1.56U
+ PD=1.56U
M$1038 \$274 \$140 \$273 VSS nfet_03v3 L=6U W=1U AS=0.28P AD=0.28P PS=1.56U
+ PD=1.56U
M$1039 \$273 \$140 \$274 VSS nfet_03v3 L=6U W=1U AS=0.28P AD=0.28P PS=1.56U
+ PD=1.56U
M$1040 \$274 \$140 \$273 VSS nfet_03v3 L=6U W=1U AS=0.28P AD=0.28P PS=1.56U
+ PD=1.56U
M$1041 \$273 \$140 \$274 VSS nfet_03v3 L=6U W=1U AS=0.28P AD=0.28P PS=1.56U
+ PD=1.56U
M$1042 \$274 \$140 \$273 VSS nfet_03v3 L=6U W=1U AS=0.28P AD=0.28P PS=1.56U
+ PD=1.56U
M$1043 \$273 \$140 \$274 VSS nfet_03v3 L=6U W=1U AS=0.28P AD=0.28P PS=1.56U
+ PD=1.56U
M$1044 \$274 \$140 \$273 VSS nfet_03v3 L=6U W=1U AS=0.28P AD=0.28P PS=1.56U
+ PD=1.56U
M$1045 \$273 \$140 \$274 VSS nfet_03v3 L=6U W=1U AS=0.28P AD=0.28P PS=1.56U
+ PD=1.56U
M$1046 \$274 \$140 \$273 VSS nfet_03v3 L=6U W=1U AS=0.28P AD=0.28P PS=1.56U
+ PD=1.56U
M$1047 \$273 \$140 \$274 VSS nfet_03v3 L=6U W=1U AS=0.28P AD=0.28P PS=1.56U
+ PD=1.56U
M$1048 \$274 \$140 \$273 VSS nfet_03v3 L=6U W=1U AS=0.28P AD=0.28P PS=1.56U
+ PD=1.56U
M$1049 \$273 \$140 \$274 VSS nfet_03v3 L=6U W=1U AS=0.28P AD=0.28P PS=1.56U
+ PD=1.56U
M$1050 \$274 \$140 \$273 VSS nfet_03v3 L=6U W=1U AS=0.28P AD=0.28P PS=1.56U
+ PD=1.56U
M$1051 \$273 \$140 \$274 VSS nfet_03v3 L=6U W=1U AS=0.28P AD=0.28P PS=1.56U
+ PD=1.56U
M$1052 \$274 \$140 \$273 VSS nfet_03v3 L=6U W=1U AS=0.28P AD=0.28P PS=1.56U
+ PD=1.56U
M$1053 \$273 \$140 \$274 VSS nfet_03v3 L=6U W=1U AS=0.28P AD=0.28P PS=1.56U
+ PD=1.56U
M$1054 \$274 \$140 \$273 VSS nfet_03v3 L=6U W=1U AS=0.28P AD=0.28P PS=1.56U
+ PD=1.56U
M$1055 \$273 \$140 \$274 VSS nfet_03v3 L=6U W=1U AS=0.28P AD=0.28P PS=1.56U
+ PD=1.56U
M$1056 \$274 \$140 \$273 VSS nfet_03v3 L=6U W=1U AS=0.28P AD=0.28P PS=1.56U
+ PD=1.56U
M$1057 \$273 \$140 \$274 VSS nfet_03v3 L=6U W=1U AS=0.28P AD=0.28P PS=1.56U
+ PD=1.56U
M$1058 \$274 \$140 \$273 VSS nfet_03v3 L=6U W=1U AS=0.28P AD=0.28P PS=1.56U
+ PD=1.56U
M$1059 \$273 \$140 \$274 VSS nfet_03v3 L=6U W=1U AS=0.28P AD=0.6P PS=1.56U
+ PD=3.2U
M$1060 \$274 \$275 VSS VSS nfet_03v3 L=4U W=0.5U AS=0.3P AD=0.3P PS=2.2U PD=2.2U
M$1061 VSS VSS VSS VSS nfet_03v3 L=2U W=1U AS=0.6P AD=0.6P PS=3.2U PD=3.2U
R$1062 \$273 \$685 VSS 24390 nwell L=48.78U W=2U
R$1063 \$5 \$685 VSS 24390 nwell L=48.78U W=2U
R$1064 \$5 \$681 VSS 24390 nwell L=48.78U W=2U
R$1065 \$4 \$681 VSS 24390 nwell L=48.78U W=2U
R$1066 \$3 \$680 VSS 24390 nwell L=48.78U W=2U
R$1067 \$2 \$684 VSS 24390 nwell L=48.78U W=2U
R$1068 \$3 \$684 VSS 24390 nwell L=48.78U W=2U
R$1069 \$1 \$683 VSS 24390 nwell L=48.78U W=2U
R$1070 \$1 \$682 VSS 24395 nwell L=48.79U W=2U
R$1071 VSS \$682 VSS 24395 nwell L=48.79U W=2U
R$1072 \$4 \$680 VSS 24390 nwell L=48.78U W=2U
R$1073 \$2 \$683 VSS 24390 nwell L=48.78U W=2U
.ENDS bias_master

.SUBCKT trim_steer trim[0] trim[1] trim[2] cal trim[3] Ibias VDD Iref VSS
M$1 VDD VDD VDD VDD pfet_03v3 L=2U W=0.5U AS=0.14P AD=0.14P PS=1.06U PD=1.06U
M$2 VDD VDD VDD VDD pfet_03v3 L=2U W=0.5U AS=0.14P AD=0.14P PS=1.06U PD=1.06U
M$3 VDD VDD VDD VDD pfet_03v3 L=2U W=0.5U AS=0.14P AD=0.14P PS=1.06U PD=1.06U
M$4 VDD VDD VDD VDD pfet_03v3 L=2U W=0.5U AS=0.14P AD=0.14P PS=1.06U PD=1.06U
M$5 VDD VDD VDD VDD pfet_03v3 L=2U W=0.5U AS=0.14P AD=0.14P PS=1.06U PD=1.06U
M$6 VDD VDD VDD VDD pfet_03v3 L=2U W=0.5U AS=0.14P AD=0.14P PS=1.06U PD=1.06U
M$7 VDD VDD VDD VDD pfet_03v3 L=2U W=0.5U AS=0.14P AD=0.14P PS=1.06U PD=1.06U
M$8 VDD VDD VDD VDD pfet_03v3 L=2U W=0.5U AS=0.14P AD=0.14P PS=1.06U PD=1.06U
M$9 VDD VDD VDD VDD pfet_03v3 L=2U W=0.5U AS=0.14P AD=0.14P PS=1.06U PD=1.06U
M$10 VDD VDD VDD VDD pfet_03v3 L=2U W=0.5U AS=0.14P AD=0.14P PS=1.06U PD=1.06U
M$11 VDD VDD VDD VDD pfet_03v3 L=2U W=0.5U AS=0.14P AD=0.14P PS=1.06U PD=1.06U
M$12 VDD VDD VDD VDD pfet_03v3 L=2U W=0.5U AS=0.14P AD=0.14P PS=1.06U PD=1.06U
M$13 VDD VDD VDD VDD pfet_03v3 L=2U W=0.5U AS=0.14P AD=0.14P PS=1.06U PD=1.06U
M$14 VDD VDD VDD VDD pfet_03v3 L=2U W=0.5U AS=0.14P AD=0.14P PS=1.06U PD=1.06U
M$15 VDD VDD VDD VDD pfet_03v3 L=2U W=0.5U AS=0.14P AD=0.14P PS=1.06U PD=1.06U
M$16 VDD VDD VDD VDD pfet_03v3 L=2U W=0.5U AS=0.14P AD=0.14P PS=1.06U PD=1.06U
M$17 VDD VDD VDD VDD pfet_03v3 L=2U W=0.5U AS=0.14P AD=0.14P PS=1.06U PD=1.06U
M$18 VDD VDD VDD VDD pfet_03v3 L=2U W=0.5U AS=0.14P AD=0.14P PS=1.06U PD=1.06U
M$19 VDD VDD VDD VDD pfet_03v3 L=2U W=0.5U AS=0.14P AD=0.14P PS=1.06U PD=1.06U
M$20 VDD VDD VDD VDD pfet_03v3 L=2U W=0.5U AS=0.14P AD=0.14P PS=1.06U PD=1.06U
M$21 VDD VDD VDD VDD pfet_03v3 L=2U W=0.5U AS=0.14P AD=0.14P PS=1.06U PD=1.06U
M$22 VDD VDD VDD VDD pfet_03v3 L=2U W=0.5U AS=0.14P AD=0.14P PS=1.06U PD=1.06U
M$23 VDD VDD VDD VDD pfet_03v3 L=2U W=0.5U AS=0.14P AD=0.14P PS=1.06U PD=1.06U
M$24 VDD VDD VDD VDD pfet_03v3 L=2U W=0.5U AS=0.14P AD=0.14P PS=1.06U PD=1.06U
M$25 VDD VDD VDD VDD pfet_03v3 L=2U W=0.5U AS=0.14P AD=0.14P PS=1.06U PD=1.06U
M$26 VDD VDD VDD VDD pfet_03v3 L=2U W=0.5U AS=0.14P AD=0.14P PS=1.06U PD=1.06U
M$27 VDD VDD VDD VDD pfet_03v3 L=2U W=0.5U AS=0.14P AD=0.14P PS=1.06U PD=1.06U
M$28 VDD VDD VDD VDD pfet_03v3 L=2U W=0.5U AS=0.14P AD=0.14P PS=1.06U PD=1.06U
M$29 VDD VDD VDD VDD pfet_03v3 L=2U W=0.5U AS=0.14P AD=0.14P PS=1.06U PD=1.06U
M$30 VDD VDD VDD VDD pfet_03v3 L=2U W=0.5U AS=0.14P AD=0.14P PS=1.06U PD=1.06U
M$31 VDD VDD VDD VDD pfet_03v3 L=2U W=0.5U AS=0.14P AD=0.14P PS=1.06U PD=1.06U
M$32 VDD VDD VDD VDD pfet_03v3 L=2U W=0.5U AS=0.14P AD=0.14P PS=1.06U PD=1.06U
M$33 VDD VDD VDD VDD pfet_03v3 L=2U W=0.5U AS=0.14P AD=0.14P PS=1.06U PD=1.06U
M$34 VDD VDD VDD VDD pfet_03v3 L=2U W=0.5U AS=0.14P AD=0.14P PS=1.06U PD=1.06U
M$35 VDD VDD VDD VDD pfet_03v3 L=2U W=0.5U AS=0.14P AD=0.14P PS=1.06U PD=1.06U
M$36 VDD VDD VDD VDD pfet_03v3 L=2U W=0.5U AS=0.14P AD=0.14P PS=1.06U PD=1.06U
M$37 VDD VDD VDD VDD pfet_03v3 L=2U W=0.5U AS=0.14P AD=0.14P PS=1.06U PD=1.06U
M$38 VDD VDD VDD VDD pfet_03v3 L=2U W=0.5U AS=0.14P AD=0.14P PS=1.06U PD=1.06U
M$39 VDD VDD VDD VDD pfet_03v3 L=2U W=0.5U AS=0.14P AD=0.14P PS=1.06U PD=1.06U
M$40 VDD VDD VDD VDD pfet_03v3 L=2U W=0.5U AS=0.14P AD=0.14P PS=1.06U PD=1.06U
M$41 VDD VDD VDD VDD pfet_03v3 L=2U W=0.5U AS=0.14P AD=0.14P PS=1.06U PD=1.06U
M$42 VDD VDD VDD VDD pfet_03v3 L=2U W=0.5U AS=0.14P AD=0.14P PS=1.06U PD=1.06U
M$43 VDD VDD VDD VDD pfet_03v3 L=2U W=0.5U AS=0.14P AD=0.14P PS=1.06U PD=1.06U
M$44 VDD VDD VDD VDD pfet_03v3 L=2U W=0.5U AS=0.14P AD=0.14P PS=1.06U PD=1.06U
M$45 VDD VDD VDD VDD pfet_03v3 L=2U W=0.5U AS=0.14P AD=0.14P PS=1.06U PD=1.06U
M$46 VDD VDD VDD VDD pfet_03v3 L=2U W=0.5U AS=0.14P AD=0.14P PS=1.06U PD=1.06U
M$47 VDD VDD VDD VDD pfet_03v3 L=2U W=0.5U AS=0.14P AD=0.14P PS=1.06U PD=1.06U
M$48 VDD VDD VDD VDD pfet_03v3 L=2U W=0.5U AS=0.14P AD=0.14P PS=1.06U PD=1.06U
M$49 VDD VDD VDD VDD pfet_03v3 L=2U W=0.5U AS=0.14P AD=0.14P PS=1.06U PD=1.06U
M$50 VDD VDD VDD VDD pfet_03v3 L=2U W=0.5U AS=0.14P AD=0.14P PS=1.06U PD=1.06U
M$51 VDD VDD VDD VDD pfet_03v3 L=2U W=0.5U AS=0.14P AD=0.14P PS=1.06U PD=1.06U
M$52 VDD VDD VDD VDD pfet_03v3 L=2U W=0.5U AS=0.14P AD=0.14P PS=1.06U PD=1.06U
M$53 VDD VDD VDD VDD pfet_03v3 L=2U W=0.5U AS=0.14P AD=0.14P PS=1.06U PD=1.06U
M$54 VDD VDD VDD VDD pfet_03v3 L=2U W=0.5U AS=0.14P AD=0.14P PS=1.06U PD=1.06U
M$55 VDD VDD VDD VDD pfet_03v3 L=2U W=0.5U AS=0.14P AD=0.14P PS=1.06U PD=1.06U
M$56 VDD VDD VDD VDD pfet_03v3 L=2U W=0.5U AS=0.14P AD=0.14P PS=1.06U PD=1.06U
M$57 VDD VDD VDD VDD pfet_03v3 L=2U W=0.5U AS=0.14P AD=0.14P PS=1.06U PD=1.06U
M$58 VDD VDD VDD VDD pfet_03v3 L=2U W=0.5U AS=0.14P AD=0.14P PS=1.06U PD=1.06U
M$59 VDD VDD VDD VDD pfet_03v3 L=2U W=0.5U AS=0.14P AD=0.14P PS=1.06U PD=1.06U
M$60 VDD VDD VDD VDD pfet_03v3 L=2U W=0.5U AS=0.14P AD=0.14P PS=1.06U PD=1.06U
M$61 VDD VDD VDD VDD pfet_03v3 L=2U W=0.5U AS=0.14P AD=0.14P PS=1.06U PD=1.06U
M$62 VDD VDD VDD VDD pfet_03v3 L=2U W=0.5U AS=0.14P AD=0.14P PS=1.06U PD=1.06U
M$63 VDD VDD VDD VDD pfet_03v3 L=2U W=0.5U AS=0.14P AD=0.14P PS=1.06U PD=1.06U
M$64 VDD VDD VDD VDD pfet_03v3 L=2U W=0.5U AS=0.14P AD=0.14P PS=1.06U PD=1.06U
M$65 VDD VDD VDD VDD pfet_03v3 L=2U W=0.5U AS=0.14P AD=0.14P PS=1.06U PD=1.06U
M$66 VDD VDD VDD VDD pfet_03v3 L=2U W=0.5U AS=0.14P AD=0.14P PS=1.06U PD=1.06U
M$67 VDD VDD VDD VDD pfet_03v3 L=2U W=0.5U AS=0.14P AD=0.14P PS=1.06U PD=1.06U
M$68 VDD VDD VDD VDD pfet_03v3 L=2U W=0.5U AS=0.14P AD=0.14P PS=1.06U PD=1.06U
M$69 VDD VDD VDD VDD pfet_03v3 L=2U W=0.5U AS=0.14P AD=0.14P PS=1.06U PD=1.06U
M$70 VDD VDD VDD VDD pfet_03v3 L=2U W=0.5U AS=0.14P AD=0.14P PS=1.06U PD=1.06U
M$71 VDD VDD VDD VDD pfet_03v3 L=2U W=0.5U AS=0.14P AD=0.14P PS=1.06U PD=1.06U
M$72 VDD VDD VDD VDD pfet_03v3 L=2U W=0.5U AS=0.14P AD=0.14P PS=1.06U PD=1.06U
M$73 VDD VDD VDD VDD pfet_03v3 L=2U W=0.5U AS=0.14P AD=0.14P PS=1.06U PD=1.06U
M$74 VDD VDD VDD VDD pfet_03v3 L=2U W=0.5U AS=0.14P AD=0.14P PS=1.06U PD=1.06U
M$75 VDD VDD VDD VDD pfet_03v3 L=2U W=0.5U AS=0.14P AD=0.14P PS=1.06U PD=1.06U
M$76 VDD VDD VDD VDD pfet_03v3 L=2U W=0.5U AS=0.14P AD=0.3P PS=1.06U PD=2.2U
M$77 VDD VDD VDD VDD pfet_03v3 L=2U W=0.5U AS=0.14P AD=0.14P PS=1.06U PD=1.06U
M$78 VDD VDD VDD VDD pfet_03v3 L=2U W=0.5U AS=0.14P AD=0.14P PS=1.06U PD=1.06U
M$79 VDD VDD VDD VDD pfet_03v3 L=2U W=0.5U AS=0.14P AD=0.14P PS=1.06U PD=1.06U
M$80 VDD VDD VDD VDD pfet_03v3 L=2U W=0.5U AS=0.14P AD=0.14P PS=1.06U PD=1.06U
M$81 VDD VDD VDD VDD pfet_03v3 L=2U W=0.5U AS=0.14P AD=0.14P PS=1.06U PD=1.06U
M$82 VDD VDD VDD VDD pfet_03v3 L=2U W=0.5U AS=0.14P AD=0.14P PS=1.06U PD=1.06U
M$83 VDD VDD VDD VDD pfet_03v3 L=2U W=0.5U AS=0.14P AD=0.14P PS=1.06U PD=1.06U
M$84 VDD VDD VDD VDD pfet_03v3 L=2U W=0.5U AS=0.14P AD=0.14P PS=1.06U PD=1.06U
M$85 VDD VDD VDD VDD pfet_03v3 L=2U W=0.5U AS=0.14P AD=0.14P PS=1.06U PD=1.06U
M$86 VDD VDD VDD VDD pfet_03v3 L=2U W=0.5U AS=0.14P AD=0.14P PS=1.06U PD=1.06U
M$87 VDD VDD VDD VDD pfet_03v3 L=2U W=0.5U AS=0.14P AD=0.14P PS=1.06U PD=1.06U
M$88 VDD VDD VDD VDD pfet_03v3 L=2U W=0.5U AS=0.14P AD=0.14P PS=1.06U PD=1.06U
M$89 VDD VDD VDD VDD pfet_03v3 L=2U W=0.5U AS=0.14P AD=0.14P PS=1.06U PD=1.06U
M$90 VDD VDD VDD VDD pfet_03v3 L=2U W=0.5U AS=0.14P AD=0.14P PS=1.06U PD=1.06U
M$91 VDD VDD VDD VDD pfet_03v3 L=2U W=0.5U AS=0.14P AD=0.14P PS=1.06U PD=1.06U
M$92 VDD VDD VDD VDD pfet_03v3 L=2U W=0.5U AS=0.14P AD=0.14P PS=1.06U PD=1.06U
M$93 VDD VDD VDD VDD pfet_03v3 L=2U W=0.5U AS=0.14P AD=0.14P PS=1.06U PD=1.06U
M$94 VDD VDD VDD VDD pfet_03v3 L=2U W=0.5U AS=0.14P AD=0.14P PS=1.06U PD=1.06U
M$95 VDD VDD VDD VDD pfet_03v3 L=2U W=0.5U AS=0.14P AD=0.14P PS=1.06U PD=1.06U
M$96 VDD VDD VDD VDD pfet_03v3 L=2U W=0.5U AS=0.14P AD=0.14P PS=1.06U PD=1.06U
M$97 VDD VDD VDD VDD pfet_03v3 L=2U W=0.5U AS=0.14P AD=0.14P PS=1.06U PD=1.06U
M$98 VDD VDD VDD VDD pfet_03v3 L=2U W=0.5U AS=0.14P AD=0.14P PS=1.06U PD=1.06U
M$99 VDD VDD VDD VDD pfet_03v3 L=2U W=0.5U AS=0.14P AD=0.14P PS=1.06U PD=1.06U
M$100 VDD VDD VDD VDD pfet_03v3 L=2U W=0.5U AS=0.14P AD=0.14P PS=1.06U PD=1.06U
M$101 VDD VDD VDD VDD pfet_03v3 L=2U W=0.5U AS=0.14P AD=0.14P PS=1.06U PD=1.06U
M$102 VDD VDD VDD VDD pfet_03v3 L=2U W=0.5U AS=0.14P AD=0.14P PS=1.06U PD=1.06U
M$103 VDD VDD VDD VDD pfet_03v3 L=2U W=0.5U AS=0.14P AD=0.14P PS=1.06U PD=1.06U
M$104 VDD VDD VDD VDD pfet_03v3 L=2U W=0.5U AS=0.14P AD=0.14P PS=1.06U PD=1.06U
M$105 VDD VDD VDD VDD pfet_03v3 L=2U W=0.5U AS=0.14P AD=0.14P PS=1.06U PD=1.06U
M$106 VDD VDD VDD VDD pfet_03v3 L=2U W=0.5U AS=0.14P AD=0.14P PS=1.06U PD=1.06U
M$107 VDD VDD VDD VDD pfet_03v3 L=2U W=0.5U AS=0.14P AD=0.14P PS=1.06U PD=1.06U
M$108 VDD VDD VDD VDD pfet_03v3 L=2U W=0.5U AS=0.14P AD=0.14P PS=1.06U PD=1.06U
M$109 VDD VDD VDD VDD pfet_03v3 L=2U W=0.5U AS=0.14P AD=0.14P PS=1.06U PD=1.06U
M$110 VDD VDD VDD VDD pfet_03v3 L=2U W=0.5U AS=0.14P AD=0.14P PS=1.06U PD=1.06U
M$111 VDD VDD VDD VDD pfet_03v3 L=2U W=0.5U AS=0.14P AD=0.14P PS=1.06U PD=1.06U
M$112 VDD VDD VDD VDD pfet_03v3 L=2U W=0.5U AS=0.14P AD=0.14P PS=1.06U PD=1.06U
M$113 VDD VDD VDD VDD pfet_03v3 L=2U W=0.5U AS=0.14P AD=0.14P PS=1.06U PD=1.06U
M$114 VDD VDD VDD VDD pfet_03v3 L=2U W=0.5U AS=0.14P AD=0.14P PS=1.06U PD=1.06U
M$115 VDD VDD VDD VDD pfet_03v3 L=2U W=0.5U AS=0.14P AD=0.14P PS=1.06U PD=1.06U
M$116 VDD VDD VDD VDD pfet_03v3 L=2U W=0.5U AS=0.14P AD=0.14P PS=1.06U PD=1.06U
M$117 VDD VDD VDD VDD pfet_03v3 L=2U W=0.5U AS=0.14P AD=0.14P PS=1.06U PD=1.06U
M$118 VDD VDD VDD VDD pfet_03v3 L=2U W=0.5U AS=0.14P AD=0.14P PS=1.06U PD=1.06U
M$119 VDD VDD VDD VDD pfet_03v3 L=2U W=0.5U AS=0.14P AD=0.14P PS=1.06U PD=1.06U
M$120 VDD VDD VDD VDD pfet_03v3 L=2U W=0.5U AS=0.14P AD=0.14P PS=1.06U PD=1.06U
M$121 VDD VDD VDD VDD pfet_03v3 L=2U W=0.5U AS=0.14P AD=0.14P PS=1.06U PD=1.06U
M$122 VDD VDD VDD VDD pfet_03v3 L=2U W=0.5U AS=0.14P AD=0.14P PS=1.06U PD=1.06U
M$123 VDD VDD VDD VDD pfet_03v3 L=2U W=0.5U AS=0.14P AD=0.14P PS=1.06U PD=1.06U
M$124 VDD VDD VDD VDD pfet_03v3 L=2U W=0.5U AS=0.14P AD=0.14P PS=1.06U PD=1.06U
M$125 VDD VDD VDD VDD pfet_03v3 L=2U W=0.5U AS=0.14P AD=0.14P PS=1.06U PD=1.06U
M$126 VDD VDD VDD VDD pfet_03v3 L=2U W=0.5U AS=0.14P AD=0.14P PS=1.06U PD=1.06U
M$127 VDD VDD VDD VDD pfet_03v3 L=2U W=0.5U AS=0.14P AD=0.14P PS=1.06U PD=1.06U
M$128 VDD VDD VDD VDD pfet_03v3 L=2U W=0.5U AS=0.14P AD=0.14P PS=1.06U PD=1.06U
M$129 VDD VDD VDD VDD pfet_03v3 L=2U W=0.5U AS=0.14P AD=0.14P PS=1.06U PD=1.06U
M$130 VDD VDD VDD VDD pfet_03v3 L=2U W=0.5U AS=0.14P AD=0.14P PS=1.06U PD=1.06U
M$131 VDD VDD VDD VDD pfet_03v3 L=2U W=0.5U AS=0.14P AD=0.14P PS=1.06U PD=1.06U
M$132 VDD VDD VDD VDD pfet_03v3 L=2U W=0.5U AS=0.14P AD=0.14P PS=1.06U PD=1.06U
M$133 VDD VDD VDD VDD pfet_03v3 L=2U W=0.5U AS=0.14P AD=0.14P PS=1.06U PD=1.06U
M$134 VDD VDD VDD VDD pfet_03v3 L=2U W=0.5U AS=0.14P AD=0.14P PS=1.06U PD=1.06U
M$135 VDD VDD VDD VDD pfet_03v3 L=2U W=0.5U AS=0.14P AD=0.14P PS=1.06U PD=1.06U
M$136 VDD VDD VDD VDD pfet_03v3 L=2U W=0.5U AS=0.14P AD=0.14P PS=1.06U PD=1.06U
M$137 VDD VDD VDD VDD pfet_03v3 L=2U W=0.5U AS=0.14P AD=0.14P PS=1.06U PD=1.06U
M$138 VDD VDD VDD VDD pfet_03v3 L=2U W=0.5U AS=0.14P AD=0.14P PS=1.06U PD=1.06U
M$139 VDD VDD VDD VDD pfet_03v3 L=2U W=0.5U AS=0.14P AD=0.14P PS=1.06U PD=1.06U
M$140 VDD VDD VDD VDD pfet_03v3 L=2U W=0.5U AS=0.14P AD=0.14P PS=1.06U PD=1.06U
M$141 VDD VDD VDD VDD pfet_03v3 L=2U W=0.5U AS=0.14P AD=0.14P PS=1.06U PD=1.06U
M$142 VDD VDD VDD VDD pfet_03v3 L=2U W=0.5U AS=0.14P AD=0.14P PS=1.06U PD=1.06U
M$143 VDD VDD VDD VDD pfet_03v3 L=2U W=0.5U AS=0.14P AD=0.14P PS=1.06U PD=1.06U
M$144 VDD VDD VDD VDD pfet_03v3 L=2U W=0.5U AS=0.14P AD=0.14P PS=1.06U PD=1.06U
M$145 VDD VDD VDD VDD pfet_03v3 L=2U W=0.5U AS=0.14P AD=0.14P PS=1.06U PD=1.06U
M$146 VDD VDD VDD VDD pfet_03v3 L=2U W=0.5U AS=0.14P AD=0.14P PS=1.06U PD=1.06U
M$147 VDD VDD VDD VDD pfet_03v3 L=2U W=0.5U AS=0.14P AD=0.14P PS=1.06U PD=1.06U
M$148 VDD VDD VDD VDD pfet_03v3 L=2U W=0.5U AS=0.14P AD=0.14P PS=1.06U PD=1.06U
M$149 VDD VDD VDD VDD pfet_03v3 L=2U W=0.5U AS=0.14P AD=0.14P PS=1.06U PD=1.06U
M$150 VDD VDD VDD VDD pfet_03v3 L=2U W=0.5U AS=0.14P AD=0.14P PS=1.06U PD=1.06U
M$151 VDD VDD VDD VDD pfet_03v3 L=2U W=0.5U AS=0.3P AD=0.14P PS=2.2U PD=1.06U
M$152 VDD VDD VDD VDD pfet_03v3 L=2U W=10U AS=6P AD=6P PS=21.2U PD=21.2U
M$153 VDD VDD VDD VDD pfet_03v3 L=2U W=0.5U AS=0.14P AD=0.14P PS=1.06U PD=1.06U
M$154 VDD VDD VDD VDD pfet_03v3 L=2U W=0.5U AS=0.14P AD=0.14P PS=1.06U PD=1.06U
M$155 VDD VDD VDD VDD pfet_03v3 L=2U W=0.5U AS=0.14P AD=0.14P PS=1.06U PD=1.06U
M$156 VDD VDD VDD VDD pfet_03v3 L=2U W=0.5U AS=0.14P AD=0.14P PS=1.06U PD=1.06U
M$157 VDD VDD VDD VDD pfet_03v3 L=2U W=0.5U AS=0.14P AD=0.14P PS=1.06U PD=1.06U
M$158 VDD VDD VDD VDD pfet_03v3 L=2U W=0.5U AS=0.14P AD=0.14P PS=1.06U PD=1.06U
M$159 VDD VDD VDD VDD pfet_03v3 L=2U W=0.5U AS=0.14P AD=0.14P PS=1.06U PD=1.06U
M$160 VDD VDD VDD VDD pfet_03v3 L=2U W=0.5U AS=0.14P AD=0.14P PS=1.06U PD=1.06U
M$161 VDD VDD VDD VDD pfet_03v3 L=2U W=0.5U AS=0.14P AD=0.14P PS=1.06U PD=1.06U
M$162 VDD VDD VDD VDD pfet_03v3 L=2U W=0.5U AS=0.14P AD=0.14P PS=1.06U PD=1.06U
M$163 VDD VDD VDD VDD pfet_03v3 L=2U W=0.5U AS=0.14P AD=0.14P PS=1.06U PD=1.06U
M$164 VDD VDD VDD VDD pfet_03v3 L=2U W=0.5U AS=0.14P AD=0.14P PS=1.06U PD=1.06U
M$165 VDD VDD VDD VDD pfet_03v3 L=2U W=0.5U AS=0.14P AD=0.14P PS=1.06U PD=1.06U
M$166 VDD VDD VDD VDD pfet_03v3 L=2U W=0.5U AS=0.14P AD=0.14P PS=1.06U PD=1.06U
M$167 VDD VDD VDD VDD pfet_03v3 L=2U W=0.5U AS=0.14P AD=0.14P PS=1.06U PD=1.06U
M$168 VDD VDD VDD VDD pfet_03v3 L=2U W=0.5U AS=0.14P AD=0.14P PS=1.06U PD=1.06U
M$169 VDD VDD VDD VDD pfet_03v3 L=2U W=0.5U AS=0.14P AD=0.14P PS=1.06U PD=1.06U
M$170 VDD VDD VDD VDD pfet_03v3 L=2U W=0.5U AS=0.14P AD=0.14P PS=1.06U PD=1.06U
M$171 VDD VDD VDD VDD pfet_03v3 L=2U W=0.5U AS=0.14P AD=0.14P PS=1.06U PD=1.06U
M$172 VDD VDD VDD VDD pfet_03v3 L=2U W=0.5U AS=0.14P AD=0.14P PS=1.06U PD=1.06U
M$173 VDD VDD VDD VDD pfet_03v3 L=2U W=0.5U AS=0.14P AD=0.14P PS=1.06U PD=1.06U
M$174 VDD VDD VDD VDD pfet_03v3 L=2U W=0.5U AS=0.14P AD=0.14P PS=1.06U PD=1.06U
M$175 VDD VDD VDD VDD pfet_03v3 L=2U W=0.5U AS=0.14P AD=0.14P PS=1.06U PD=1.06U
M$176 VDD VDD VDD VDD pfet_03v3 L=2U W=0.5U AS=0.14P AD=0.14P PS=1.06U PD=1.06U
M$177 VDD VDD VDD VDD pfet_03v3 L=2U W=0.5U AS=0.14P AD=0.14P PS=1.06U PD=1.06U
M$178 VDD VDD VDD VDD pfet_03v3 L=2U W=0.5U AS=0.14P AD=0.14P PS=1.06U PD=1.06U
M$179 VDD VDD VDD VDD pfet_03v3 L=2U W=0.5U AS=0.14P AD=0.14P PS=1.06U PD=1.06U
M$180 VDD VDD VDD VDD pfet_03v3 L=2U W=0.5U AS=0.14P AD=0.14P PS=1.06U PD=1.06U
M$181 VDD VDD VDD VDD pfet_03v3 L=2U W=0.5U AS=0.14P AD=0.14P PS=1.06U PD=1.06U
M$182 VDD VDD VDD VDD pfet_03v3 L=2U W=0.5U AS=0.14P AD=0.14P PS=1.06U PD=1.06U
M$183 VDD VDD VDD VDD pfet_03v3 L=2U W=0.5U AS=0.14P AD=0.14P PS=1.06U PD=1.06U
M$184 VDD VDD VDD VDD pfet_03v3 L=2U W=0.5U AS=0.14P AD=0.14P PS=1.06U PD=1.06U
M$185 VDD VDD VDD VDD pfet_03v3 L=2U W=0.5U AS=0.14P AD=0.14P PS=1.06U PD=1.06U
M$186 VDD VDD VDD VDD pfet_03v3 L=2U W=0.5U AS=0.14P AD=0.14P PS=1.06U PD=1.06U
M$187 VDD VDD VDD VDD pfet_03v3 L=2U W=0.5U AS=0.14P AD=0.14P PS=1.06U PD=1.06U
M$188 VDD VDD VDD VDD pfet_03v3 L=2U W=0.5U AS=0.14P AD=0.14P PS=1.06U PD=1.06U
M$189 VDD VDD VDD VDD pfet_03v3 L=2U W=0.5U AS=0.14P AD=0.14P PS=1.06U PD=1.06U
M$190 VDD VDD VDD VDD pfet_03v3 L=2U W=0.5U AS=0.14P AD=0.14P PS=1.06U PD=1.06U
M$191 VDD VDD VDD VDD pfet_03v3 L=2U W=0.5U AS=0.14P AD=0.14P PS=1.06U PD=1.06U
M$192 VDD VDD VDD VDD pfet_03v3 L=2U W=0.5U AS=0.14P AD=0.14P PS=1.06U PD=1.06U
M$193 VDD VDD VDD VDD pfet_03v3 L=2U W=0.5U AS=0.14P AD=0.14P PS=1.06U PD=1.06U
M$194 VDD VDD VDD VDD pfet_03v3 L=2U W=0.5U AS=0.14P AD=0.14P PS=1.06U PD=1.06U
M$195 VDD VDD VDD VDD pfet_03v3 L=2U W=0.5U AS=0.14P AD=0.14P PS=1.06U PD=1.06U
M$196 VDD VDD VDD VDD pfet_03v3 L=2U W=0.5U AS=0.14P AD=0.14P PS=1.06U PD=1.06U
M$197 VDD VDD VDD VDD pfet_03v3 L=2U W=0.5U AS=0.14P AD=0.14P PS=1.06U PD=1.06U
M$198 VDD VDD VDD VDD pfet_03v3 L=2U W=0.5U AS=0.14P AD=0.14P PS=1.06U PD=1.06U
M$199 VDD VDD VDD VDD pfet_03v3 L=2U W=0.5U AS=0.14P AD=0.14P PS=1.06U PD=1.06U
M$200 VDD VDD VDD VDD pfet_03v3 L=2U W=0.5U AS=0.14P AD=0.14P PS=1.06U PD=1.06U
M$201 VDD VDD VDD VDD pfet_03v3 L=2U W=0.5U AS=0.14P AD=0.14P PS=1.06U PD=1.06U
M$202 VDD VDD VDD VDD pfet_03v3 L=2U W=0.5U AS=0.14P AD=0.14P PS=1.06U PD=1.06U
M$203 VDD VDD VDD VDD pfet_03v3 L=2U W=0.5U AS=0.14P AD=0.14P PS=1.06U PD=1.06U
M$204 VDD VDD VDD VDD pfet_03v3 L=2U W=0.5U AS=0.14P AD=0.14P PS=1.06U PD=1.06U
M$205 VDD VDD VDD VDD pfet_03v3 L=2U W=0.5U AS=0.14P AD=0.14P PS=1.06U PD=1.06U
M$206 VDD VDD VDD VDD pfet_03v3 L=2U W=0.5U AS=0.14P AD=0.14P PS=1.06U PD=1.06U
M$207 VDD VDD VDD VDD pfet_03v3 L=2U W=0.5U AS=0.14P AD=0.14P PS=1.06U PD=1.06U
M$208 VDD VDD VDD VDD pfet_03v3 L=2U W=0.5U AS=0.14P AD=0.14P PS=1.06U PD=1.06U
M$209 VDD VDD VDD VDD pfet_03v3 L=2U W=0.5U AS=0.14P AD=0.14P PS=1.06U PD=1.06U
M$210 VDD VDD VDD VDD pfet_03v3 L=2U W=0.5U AS=0.14P AD=0.14P PS=1.06U PD=1.06U
M$211 VDD VDD VDD VDD pfet_03v3 L=2U W=0.5U AS=0.14P AD=0.14P PS=1.06U PD=1.06U
M$212 VDD VDD VDD VDD pfet_03v3 L=2U W=0.5U AS=0.14P AD=0.14P PS=1.06U PD=1.06U
M$213 VDD VDD VDD VDD pfet_03v3 L=2U W=0.5U AS=0.14P AD=0.14P PS=1.06U PD=1.06U
M$214 VDD VDD VDD VDD pfet_03v3 L=2U W=0.5U AS=0.14P AD=0.14P PS=1.06U PD=1.06U
M$215 VDD VDD VDD VDD pfet_03v3 L=2U W=0.5U AS=0.14P AD=0.14P PS=1.06U PD=1.06U
M$216 VDD VDD VDD VDD pfet_03v3 L=2U W=0.5U AS=0.14P AD=0.14P PS=1.06U PD=1.06U
M$217 VDD VDD VDD VDD pfet_03v3 L=2U W=0.5U AS=0.14P AD=0.14P PS=1.06U PD=1.06U
M$218 VDD VDD VDD VDD pfet_03v3 L=2U W=0.5U AS=0.14P AD=0.14P PS=1.06U PD=1.06U
M$219 VDD VDD VDD VDD pfet_03v3 L=2U W=0.5U AS=0.14P AD=0.14P PS=1.06U PD=1.06U
M$220 VDD VDD VDD VDD pfet_03v3 L=2U W=0.5U AS=0.14P AD=0.14P PS=1.06U PD=1.06U
M$221 VDD VDD VDD VDD pfet_03v3 L=2U W=0.5U AS=0.14P AD=0.14P PS=1.06U PD=1.06U
M$222 VDD VDD VDD VDD pfet_03v3 L=2U W=0.5U AS=0.14P AD=0.14P PS=1.06U PD=1.06U
M$223 VDD VDD VDD VDD pfet_03v3 L=2U W=0.5U AS=0.14P AD=0.14P PS=1.06U PD=1.06U
M$224 VDD VDD VDD VDD pfet_03v3 L=2U W=0.5U AS=0.14P AD=0.14P PS=1.06U PD=1.06U
M$225 VDD VDD VDD VDD pfet_03v3 L=2U W=0.5U AS=0.14P AD=0.14P PS=1.06U PD=1.06U
M$226 VDD VDD VDD VDD pfet_03v3 L=2U W=0.5U AS=0.14P AD=0.14P PS=1.06U PD=1.06U
M$227 VDD VDD VDD VDD pfet_03v3 L=2U W=0.5U AS=0.14P AD=0.14P PS=1.06U PD=1.06U
M$228 VDD VDD VDD VDD pfet_03v3 L=2U W=0.5U AS=0.14P AD=0.3P PS=1.06U PD=2.2U
M$229 VDD VDD VDD VDD pfet_03v3 L=2U W=0.5U AS=0.14P AD=0.14P PS=1.06U PD=1.06U
M$230 VDD VDD VDD VDD pfet_03v3 L=2U W=0.5U AS=0.14P AD=0.14P PS=1.06U PD=1.06U
M$231 VDD VDD VDD VDD pfet_03v3 L=2U W=0.5U AS=0.14P AD=0.14P PS=1.06U PD=1.06U
M$232 VDD VDD VDD VDD pfet_03v3 L=2U W=0.5U AS=0.14P AD=0.14P PS=1.06U PD=1.06U
M$233 VDD VDD VDD VDD pfet_03v3 L=2U W=0.5U AS=0.14P AD=0.14P PS=1.06U PD=1.06U
M$234 VDD VDD VDD VDD pfet_03v3 L=2U W=0.5U AS=0.14P AD=0.14P PS=1.06U PD=1.06U
M$235 VDD VDD VDD VDD pfet_03v3 L=2U W=0.5U AS=0.14P AD=0.14P PS=1.06U PD=1.06U
M$236 VDD VDD VDD VDD pfet_03v3 L=2U W=0.5U AS=0.14P AD=0.14P PS=1.06U PD=1.06U
M$237 VDD VDD VDD VDD pfet_03v3 L=2U W=0.5U AS=0.14P AD=0.14P PS=1.06U PD=1.06U
M$238 VDD VDD VDD VDD pfet_03v3 L=2U W=0.5U AS=0.14P AD=0.14P PS=1.06U PD=1.06U
M$239 VDD VDD VDD VDD pfet_03v3 L=2U W=0.5U AS=0.14P AD=0.14P PS=1.06U PD=1.06U
M$240 VDD VDD VDD VDD pfet_03v3 L=2U W=0.5U AS=0.14P AD=0.14P PS=1.06U PD=1.06U
M$241 VDD VDD VDD VDD pfet_03v3 L=2U W=0.5U AS=0.14P AD=0.14P PS=1.06U PD=1.06U
M$242 VDD VDD VDD VDD pfet_03v3 L=2U W=0.5U AS=0.14P AD=0.14P PS=1.06U PD=1.06U
M$243 VDD VDD VDD VDD pfet_03v3 L=2U W=0.5U AS=0.14P AD=0.14P PS=1.06U PD=1.06U
M$244 VDD VDD VDD VDD pfet_03v3 L=2U W=0.5U AS=0.14P AD=0.14P PS=1.06U PD=1.06U
M$245 VDD VDD VDD VDD pfet_03v3 L=2U W=0.5U AS=0.14P AD=0.14P PS=1.06U PD=1.06U
M$246 VDD VDD VDD VDD pfet_03v3 L=2U W=0.5U AS=0.14P AD=0.14P PS=1.06U PD=1.06U
M$247 VDD VDD VDD VDD pfet_03v3 L=2U W=0.5U AS=0.14P AD=0.14P PS=1.06U PD=1.06U
M$248 VDD VDD VDD VDD pfet_03v3 L=2U W=0.5U AS=0.14P AD=0.14P PS=1.06U PD=1.06U
M$249 VDD VDD VDD VDD pfet_03v3 L=2U W=0.5U AS=0.14P AD=0.14P PS=1.06U PD=1.06U
M$250 VDD VDD VDD VDD pfet_03v3 L=2U W=0.5U AS=0.14P AD=0.14P PS=1.06U PD=1.06U
M$251 VDD VDD VDD VDD pfet_03v3 L=2U W=0.5U AS=0.14P AD=0.14P PS=1.06U PD=1.06U
M$252 VDD VDD VDD VDD pfet_03v3 L=2U W=0.5U AS=0.14P AD=0.14P PS=1.06U PD=1.06U
M$253 VDD VDD VDD VDD pfet_03v3 L=2U W=0.5U AS=0.14P AD=0.14P PS=1.06U PD=1.06U
M$254 VDD VDD VDD VDD pfet_03v3 L=2U W=0.5U AS=0.14P AD=0.14P PS=1.06U PD=1.06U
M$255 VDD VDD VDD VDD pfet_03v3 L=2U W=0.5U AS=0.14P AD=0.14P PS=1.06U PD=1.06U
M$256 VDD VDD VDD VDD pfet_03v3 L=2U W=0.5U AS=0.14P AD=0.14P PS=1.06U PD=1.06U
M$257 VDD VDD VDD VDD pfet_03v3 L=2U W=0.5U AS=0.14P AD=0.14P PS=1.06U PD=1.06U
M$258 VDD VDD VDD VDD pfet_03v3 L=2U W=0.5U AS=0.14P AD=0.14P PS=1.06U PD=1.06U
M$259 VDD VDD VDD VDD pfet_03v3 L=2U W=0.5U AS=0.14P AD=0.14P PS=1.06U PD=1.06U
M$260 VDD VDD VDD VDD pfet_03v3 L=2U W=0.5U AS=0.14P AD=0.14P PS=1.06U PD=1.06U
M$261 VDD VDD VDD VDD pfet_03v3 L=2U W=0.5U AS=0.14P AD=0.14P PS=1.06U PD=1.06U
M$262 VDD VDD VDD VDD pfet_03v3 L=2U W=0.5U AS=0.14P AD=0.14P PS=1.06U PD=1.06U
M$263 VDD VDD VDD VDD pfet_03v3 L=2U W=0.5U AS=0.14P AD=0.14P PS=1.06U PD=1.06U
M$264 VDD VDD VDD VDD pfet_03v3 L=2U W=0.5U AS=0.14P AD=0.14P PS=1.06U PD=1.06U
M$265 VDD VDD VDD VDD pfet_03v3 L=2U W=0.5U AS=0.14P AD=0.14P PS=1.06U PD=1.06U
M$266 VDD VDD VDD VDD pfet_03v3 L=2U W=0.5U AS=0.14P AD=0.14P PS=1.06U PD=1.06U
M$267 VDD VDD VDD VDD pfet_03v3 L=2U W=0.5U AS=0.14P AD=0.14P PS=1.06U PD=1.06U
M$268 VDD VDD VDD VDD pfet_03v3 L=2U W=0.5U AS=0.14P AD=0.14P PS=1.06U PD=1.06U
M$269 VDD VDD VDD VDD pfet_03v3 L=2U W=0.5U AS=0.14P AD=0.14P PS=1.06U PD=1.06U
M$270 VDD VDD VDD VDD pfet_03v3 L=2U W=0.5U AS=0.14P AD=0.14P PS=1.06U PD=1.06U
M$271 VDD VDD VDD VDD pfet_03v3 L=2U W=0.5U AS=0.14P AD=0.14P PS=1.06U PD=1.06U
M$272 VDD VDD VDD VDD pfet_03v3 L=2U W=0.5U AS=0.14P AD=0.14P PS=1.06U PD=1.06U
M$273 VDD VDD VDD VDD pfet_03v3 L=2U W=0.5U AS=0.14P AD=0.14P PS=1.06U PD=1.06U
M$274 VDD VDD VDD VDD pfet_03v3 L=2U W=0.5U AS=0.14P AD=0.14P PS=1.06U PD=1.06U
M$275 VDD VDD VDD VDD pfet_03v3 L=2U W=0.5U AS=0.14P AD=0.14P PS=1.06U PD=1.06U
M$276 VDD VDD VDD VDD pfet_03v3 L=2U W=0.5U AS=0.14P AD=0.14P PS=1.06U PD=1.06U
M$277 VDD VDD VDD VDD pfet_03v3 L=2U W=0.5U AS=0.14P AD=0.14P PS=1.06U PD=1.06U
M$278 VDD VDD VDD VDD pfet_03v3 L=2U W=0.5U AS=0.14P AD=0.14P PS=1.06U PD=1.06U
M$279 VDD VDD VDD VDD pfet_03v3 L=2U W=0.5U AS=0.14P AD=0.14P PS=1.06U PD=1.06U
M$280 VDD VDD VDD VDD pfet_03v3 L=2U W=0.5U AS=0.14P AD=0.14P PS=1.06U PD=1.06U
M$281 VDD VDD VDD VDD pfet_03v3 L=2U W=0.5U AS=0.14P AD=0.14P PS=1.06U PD=1.06U
M$282 VDD VDD VDD VDD pfet_03v3 L=2U W=0.5U AS=0.14P AD=0.14P PS=1.06U PD=1.06U
M$283 VDD VDD VDD VDD pfet_03v3 L=2U W=0.5U AS=0.14P AD=0.14P PS=1.06U PD=1.06U
M$284 VDD VDD VDD VDD pfet_03v3 L=2U W=0.5U AS=0.14P AD=0.14P PS=1.06U PD=1.06U
M$285 VDD VDD VDD VDD pfet_03v3 L=2U W=0.5U AS=0.14P AD=0.14P PS=1.06U PD=1.06U
M$286 VDD VDD VDD VDD pfet_03v3 L=2U W=0.5U AS=0.14P AD=0.14P PS=1.06U PD=1.06U
M$287 VDD VDD VDD VDD pfet_03v3 L=2U W=0.5U AS=0.14P AD=0.14P PS=1.06U PD=1.06U
M$288 VDD VDD VDD VDD pfet_03v3 L=2U W=0.5U AS=0.14P AD=0.14P PS=1.06U PD=1.06U
M$289 VDD VDD VDD VDD pfet_03v3 L=2U W=0.5U AS=0.14P AD=0.14P PS=1.06U PD=1.06U
M$290 VDD VDD VDD VDD pfet_03v3 L=2U W=0.5U AS=0.14P AD=0.14P PS=1.06U PD=1.06U
M$291 VDD VDD VDD VDD pfet_03v3 L=2U W=0.5U AS=0.14P AD=0.14P PS=1.06U PD=1.06U
M$292 VDD VDD VDD VDD pfet_03v3 L=2U W=0.5U AS=0.14P AD=0.14P PS=1.06U PD=1.06U
M$293 VDD VDD VDD VDD pfet_03v3 L=2U W=0.5U AS=0.14P AD=0.14P PS=1.06U PD=1.06U
M$294 VDD VDD VDD VDD pfet_03v3 L=2U W=0.5U AS=0.14P AD=0.14P PS=1.06U PD=1.06U
M$295 VDD VDD VDD VDD pfet_03v3 L=2U W=0.5U AS=0.14P AD=0.14P PS=1.06U PD=1.06U
M$296 VDD VDD VDD VDD pfet_03v3 L=2U W=0.5U AS=0.14P AD=0.14P PS=1.06U PD=1.06U
M$297 VDD VDD VDD VDD pfet_03v3 L=2U W=0.5U AS=0.14P AD=0.14P PS=1.06U PD=1.06U
M$298 VDD VDD VDD VDD pfet_03v3 L=2U W=0.5U AS=0.14P AD=0.14P PS=1.06U PD=1.06U
M$299 VDD VDD VDD VDD pfet_03v3 L=2U W=0.5U AS=0.14P AD=0.14P PS=1.06U PD=1.06U
M$300 VDD VDD VDD VDD pfet_03v3 L=2U W=0.5U AS=0.14P AD=0.14P PS=1.06U PD=1.06U
M$301 VDD VDD VDD VDD pfet_03v3 L=2U W=0.5U AS=0.14P AD=0.14P PS=1.06U PD=1.06U
M$302 VDD VDD VDD VDD pfet_03v3 L=2U W=0.5U AS=0.14P AD=0.14P PS=1.06U PD=1.06U
M$303 VDD VDD VDD VDD pfet_03v3 L=2U W=0.5U AS=0.3P AD=0.14P PS=2.2U PD=1.06U
M$304 \$160 \$161 VDD VDD pfet_03v3 L=6U W=1U AS=0.6P AD=0.28P PS=3.2U PD=1.56U
M$305 VDD \$161 \$160 VDD pfet_03v3 L=6U W=1U AS=0.28P AD=0.28P PS=1.56U
+ PD=1.56U
M$306 \$160 \$161 VDD VDD pfet_03v3 L=6U W=1U AS=0.28P AD=0.28P PS=1.56U
+ PD=1.56U
M$307 VDD \$161 \$160 VDD pfet_03v3 L=6U W=1U AS=0.28P AD=0.28P PS=1.56U
+ PD=1.56U
M$308 \$160 \$161 VDD VDD pfet_03v3 L=6U W=1U AS=0.28P AD=0.28P PS=1.56U
+ PD=1.56U
M$309 VDD \$161 \$160 VDD pfet_03v3 L=6U W=1U AS=0.28P AD=0.28P PS=1.56U
+ PD=1.56U
M$310 \$160 \$161 VDD VDD pfet_03v3 L=6U W=1U AS=0.28P AD=0.28P PS=1.56U
+ PD=1.56U
M$311 VDD \$161 \$160 VDD pfet_03v3 L=6U W=1U AS=0.28P AD=0.28P PS=1.56U
+ PD=1.56U
M$312 \$160 \$161 VDD VDD pfet_03v3 L=6U W=1U AS=0.28P AD=0.28P PS=1.56U
+ PD=1.56U
M$313 VDD \$161 \$160 VDD pfet_03v3 L=6U W=1U AS=0.28P AD=0.28P PS=1.56U
+ PD=1.56U
M$314 \$160 \$161 VDD VDD pfet_03v3 L=6U W=1U AS=0.28P AD=0.28P PS=1.56U
+ PD=1.56U
M$315 VDD \$161 \$160 VDD pfet_03v3 L=6U W=1U AS=0.28P AD=0.28P PS=1.56U
+ PD=1.56U
M$316 \$160 \$161 VDD VDD pfet_03v3 L=6U W=1U AS=0.28P AD=0.28P PS=1.56U
+ PD=1.56U
M$317 VDD \$161 \$160 VDD pfet_03v3 L=6U W=1U AS=0.28P AD=0.6P PS=1.56U PD=3.2U
M$318 VDD \$161 \$64 VDD pfet_03v3 L=6U W=1U AS=0.6P AD=0.6P PS=3.2U PD=3.2U
M$319 \$65 \$161 VDD VDD pfet_03v3 L=6U W=1U AS=0.6P AD=0.28P PS=3.2U PD=1.56U
M$320 VDD \$161 \$65 VDD pfet_03v3 L=6U W=1U AS=0.28P AD=0.6P PS=1.56U PD=3.2U
M$321 \$66 \$161 VDD VDD pfet_03v3 L=6U W=1U AS=0.6P AD=0.28P PS=3.2U PD=1.56U
M$322 VDD \$161 \$66 VDD pfet_03v3 L=6U W=1U AS=0.28P AD=0.28P PS=1.56U PD=1.56U
M$323 \$66 \$161 VDD VDD pfet_03v3 L=6U W=1U AS=0.28P AD=0.28P PS=1.56U PD=1.56U
M$324 VDD \$161 \$66 VDD pfet_03v3 L=6U W=1U AS=0.28P AD=0.6P PS=1.56U PD=3.2U
M$325 \$67 \$161 VDD VDD pfet_03v3 L=6U W=1U AS=0.6P AD=0.28P PS=3.2U PD=1.56U
M$326 VDD \$161 \$67 VDD pfet_03v3 L=6U W=1U AS=0.28P AD=0.28P PS=1.56U PD=1.56U
M$327 \$67 \$161 VDD VDD pfet_03v3 L=6U W=1U AS=0.28P AD=0.28P PS=1.56U PD=1.56U
M$328 VDD \$161 \$67 VDD pfet_03v3 L=6U W=1U AS=0.28P AD=0.28P PS=1.56U PD=1.56U
M$329 \$67 \$161 VDD VDD pfet_03v3 L=6U W=1U AS=0.28P AD=0.28P PS=1.56U PD=1.56U
M$330 VDD \$161 \$67 VDD pfet_03v3 L=6U W=1U AS=0.28P AD=0.28P PS=1.56U PD=1.56U
M$331 \$67 \$161 VDD VDD pfet_03v3 L=6U W=1U AS=0.28P AD=0.28P PS=1.56U PD=1.56U
M$332 VDD \$161 \$67 VDD pfet_03v3 L=6U W=1U AS=0.28P AD=0.6P PS=1.56U PD=3.2U
M$333 VDD trim[0] \$9 VDD pfet_03v3 L=0.28U W=1U AS=0.75P AD=0.75P PS=3.5U
+ PD=3.5U
M$334 VDD trim[1] \$8 VDD pfet_03v3 L=0.28U W=1U AS=0.75P AD=0.75P PS=3.5U
+ PD=3.5U
M$335 VDD trim[2] \$7 VDD pfet_03v3 L=0.28U W=1U AS=0.75P AD=0.75P PS=3.5U
+ PD=3.5U
M$336 VDD trim[3] \$6 VDD pfet_03v3 L=0.28U W=1U AS=0.75P AD=0.75P PS=3.5U
+ PD=3.5U
M$337 VDD cal \$62 VDD pfet_03v3 L=0.28U W=1U AS=0.75P AD=0.75P PS=3.5U PD=3.5U
M$338 VDD Iref Iref VDD pfet_03v3 L=6U W=1U AS=0.6P AD=0.28P PS=3.2U PD=1.56U
M$339 Iref Iref VDD VDD pfet_03v3 L=6U W=1U AS=0.28P AD=0.28P PS=1.56U PD=1.56U
M$340 VDD Iref Iref VDD pfet_03v3 L=6U W=1U AS=0.28P AD=0.28P PS=1.56U PD=1.56U
M$341 Iref Iref VDD VDD pfet_03v3 L=6U W=1U AS=0.28P AD=0.28P PS=1.56U PD=1.56U
M$342 VDD Iref Iref VDD pfet_03v3 L=6U W=1U AS=0.28P AD=0.28P PS=1.56U PD=1.56U
M$343 Iref Iref VDD VDD pfet_03v3 L=6U W=1U AS=0.28P AD=0.28P PS=1.56U PD=1.56U
M$344 VDD Iref Iref VDD pfet_03v3 L=6U W=1U AS=0.28P AD=0.28P PS=1.56U PD=1.56U
M$345 Iref Iref VDD VDD pfet_03v3 L=6U W=1U AS=0.28P AD=0.28P PS=1.56U PD=1.56U
M$346 VDD Iref Iref VDD pfet_03v3 L=6U W=1U AS=0.28P AD=0.28P PS=1.56U PD=1.56U
M$347 Iref Iref VDD VDD pfet_03v3 L=6U W=1U AS=0.28P AD=0.28P PS=1.56U PD=1.56U
M$348 VDD Iref Iref VDD pfet_03v3 L=6U W=1U AS=0.28P AD=0.28P PS=1.56U PD=1.56U
M$349 Iref Iref VDD VDD pfet_03v3 L=6U W=1U AS=0.28P AD=0.28P PS=1.56U PD=1.56U
M$350 VDD Iref Iref VDD pfet_03v3 L=6U W=1U AS=0.28P AD=0.28P PS=1.56U PD=1.56U
M$351 Iref Iref VDD VDD pfet_03v3 L=6U W=1U AS=0.28P AD=0.28P PS=1.56U PD=1.56U
M$352 VDD Iref Iref VDD pfet_03v3 L=6U W=1U AS=0.28P AD=0.28P PS=1.56U PD=1.56U
M$353 Iref Iref VDD VDD pfet_03v3 L=6U W=1U AS=0.28P AD=0.28P PS=1.56U PD=1.56U
M$354 VDD Iref Iref VDD pfet_03v3 L=6U W=1U AS=0.28P AD=0.28P PS=1.56U PD=1.56U
M$355 Iref Iref VDD VDD pfet_03v3 L=6U W=1U AS=0.28P AD=0.28P PS=1.56U PD=1.56U
M$356 VDD Iref Iref VDD pfet_03v3 L=6U W=1U AS=0.28P AD=0.28P PS=1.56U PD=1.56U
M$357 Iref Iref VDD VDD pfet_03v3 L=6U W=1U AS=0.28P AD=0.28P PS=1.56U PD=1.56U
M$358 VDD Iref Iref VDD pfet_03v3 L=6U W=1U AS=0.28P AD=0.28P PS=1.56U PD=1.56U
M$359 Iref Iref VDD VDD pfet_03v3 L=6U W=1U AS=0.28P AD=0.28P PS=1.56U PD=1.56U
M$360 VDD Iref Iref VDD pfet_03v3 L=6U W=1U AS=0.28P AD=0.6P PS=1.56U PD=3.2U
M$361 VDD \$161 VDD VDD pfet_03v3 L=10U W=10U AS=6P AD=6P PS=21.2U PD=21.2U
M$362 VDD VDD VDD VDD pfet_03v3 L=2U W=10U AS=6P AD=6P PS=21.2U PD=21.2U
M$363 VSS VSS VSS VSS nfet_03v3 L=2U W=0.5U AS=0.3P AD=0.14P PS=2.2U PD=1.06U
M$364 VSS VSS VSS VSS nfet_03v3 L=2U W=0.5U AS=0.14P AD=0.14P PS=1.06U PD=1.06U
M$365 VSS VSS VSS VSS nfet_03v3 L=2U W=0.5U AS=0.14P AD=0.14P PS=1.06U PD=1.06U
M$366 VSS VSS VSS VSS nfet_03v3 L=2U W=0.5U AS=0.14P AD=0.14P PS=1.06U PD=1.06U
M$367 VSS VSS VSS VSS nfet_03v3 L=2U W=0.5U AS=0.14P AD=0.14P PS=1.06U PD=1.06U
M$368 VSS VSS VSS VSS nfet_03v3 L=2U W=0.5U AS=0.14P AD=0.14P PS=1.06U PD=1.06U
M$369 VSS VSS VSS VSS nfet_03v3 L=2U W=0.5U AS=0.14P AD=0.14P PS=1.06U PD=1.06U
M$370 VSS VSS VSS VSS nfet_03v3 L=2U W=0.5U AS=0.14P AD=0.14P PS=1.06U PD=1.06U
M$371 VSS VSS VSS VSS nfet_03v3 L=2U W=0.5U AS=0.14P AD=0.14P PS=1.06U PD=1.06U
M$372 VSS VSS VSS VSS nfet_03v3 L=2U W=0.5U AS=0.14P AD=0.14P PS=1.06U PD=1.06U
M$373 VSS VSS VSS VSS nfet_03v3 L=2U W=0.5U AS=0.14P AD=0.14P PS=1.06U PD=1.06U
M$374 VSS VSS VSS VSS nfet_03v3 L=2U W=0.5U AS=0.14P AD=0.14P PS=1.06U PD=1.06U
M$375 VSS VSS VSS VSS nfet_03v3 L=2U W=0.5U AS=0.14P AD=0.14P PS=1.06U PD=1.06U
M$376 VSS VSS VSS VSS nfet_03v3 L=2U W=0.5U AS=0.14P AD=0.14P PS=1.06U PD=1.06U
M$377 VSS VSS VSS VSS nfet_03v3 L=2U W=0.5U AS=0.14P AD=0.14P PS=1.06U PD=1.06U
M$378 VSS VSS VSS VSS nfet_03v3 L=2U W=0.5U AS=0.14P AD=0.14P PS=1.06U PD=1.06U
M$379 VSS VSS VSS VSS nfet_03v3 L=2U W=0.5U AS=0.14P AD=0.14P PS=1.06U PD=1.06U
M$380 VSS VSS VSS VSS nfet_03v3 L=2U W=0.5U AS=0.14P AD=0.14P PS=1.06U PD=1.06U
M$381 VSS VSS VSS VSS nfet_03v3 L=2U W=0.5U AS=0.14P AD=0.14P PS=1.06U PD=1.06U
M$382 VSS VSS VSS VSS nfet_03v3 L=2U W=0.5U AS=0.14P AD=0.14P PS=1.06U PD=1.06U
M$383 VSS VSS VSS VSS nfet_03v3 L=2U W=0.5U AS=0.14P AD=0.14P PS=1.06U PD=1.06U
M$384 VSS VSS VSS VSS nfet_03v3 L=2U W=0.5U AS=0.14P AD=0.14P PS=1.06U PD=1.06U
M$385 VSS VSS VSS VSS nfet_03v3 L=2U W=0.5U AS=0.14P AD=0.14P PS=1.06U PD=1.06U
M$386 VSS VSS VSS VSS nfet_03v3 L=2U W=0.5U AS=0.14P AD=0.14P PS=1.06U PD=1.06U
M$387 VSS VSS VSS VSS nfet_03v3 L=2U W=0.5U AS=0.14P AD=0.14P PS=1.06U PD=1.06U
M$388 VSS VSS VSS VSS nfet_03v3 L=2U W=0.5U AS=0.14P AD=0.14P PS=1.06U PD=1.06U
M$389 VSS VSS VSS VSS nfet_03v3 L=2U W=0.5U AS=0.14P AD=0.14P PS=1.06U PD=1.06U
M$390 VSS VSS VSS VSS nfet_03v3 L=2U W=0.5U AS=0.14P AD=0.14P PS=1.06U PD=1.06U
M$391 VSS VSS VSS VSS nfet_03v3 L=2U W=0.5U AS=0.14P AD=0.14P PS=1.06U PD=1.06U
M$392 VSS VSS VSS VSS nfet_03v3 L=2U W=0.5U AS=0.14P AD=0.14P PS=1.06U PD=1.06U
M$393 VSS VSS VSS VSS nfet_03v3 L=2U W=0.5U AS=0.14P AD=0.14P PS=1.06U PD=1.06U
M$394 VSS VSS VSS VSS nfet_03v3 L=2U W=0.5U AS=0.14P AD=0.14P PS=1.06U PD=1.06U
M$395 VSS VSS VSS VSS nfet_03v3 L=2U W=0.5U AS=0.14P AD=0.14P PS=1.06U PD=1.06U
M$396 VSS VSS VSS VSS nfet_03v3 L=2U W=0.5U AS=0.14P AD=0.14P PS=1.06U PD=1.06U
M$397 VSS VSS VSS VSS nfet_03v3 L=2U W=0.5U AS=0.14P AD=0.14P PS=1.06U PD=1.06U
M$398 VSS VSS VSS VSS nfet_03v3 L=2U W=0.5U AS=0.14P AD=0.14P PS=1.06U PD=1.06U
M$399 VSS VSS VSS VSS nfet_03v3 L=2U W=0.5U AS=0.14P AD=0.14P PS=1.06U PD=1.06U
M$400 VSS VSS VSS VSS nfet_03v3 L=2U W=0.5U AS=0.14P AD=0.14P PS=1.06U PD=1.06U
M$401 VSS VSS VSS VSS nfet_03v3 L=2U W=0.5U AS=0.14P AD=0.14P PS=1.06U PD=1.06U
M$402 VSS VSS VSS VSS nfet_03v3 L=2U W=0.5U AS=0.14P AD=0.14P PS=1.06U PD=1.06U
M$403 VSS VSS VSS VSS nfet_03v3 L=2U W=0.5U AS=0.14P AD=0.14P PS=1.06U PD=1.06U
M$404 VSS VSS VSS VSS nfet_03v3 L=2U W=0.5U AS=0.14P AD=0.14P PS=1.06U PD=1.06U
M$405 VSS VSS VSS VSS nfet_03v3 L=2U W=0.5U AS=0.14P AD=0.14P PS=1.06U PD=1.06U
M$406 VSS VSS VSS VSS nfet_03v3 L=2U W=0.5U AS=0.14P AD=0.14P PS=1.06U PD=1.06U
M$407 VSS VSS VSS VSS nfet_03v3 L=2U W=0.5U AS=0.14P AD=0.14P PS=1.06U PD=1.06U
M$408 VSS VSS VSS VSS nfet_03v3 L=2U W=0.5U AS=0.14P AD=0.3P PS=1.06U PD=2.2U
M$409 VSS VSS VSS VSS nfet_03v3 L=2U W=10U AS=6P AD=6P PS=21.2U PD=21.2U
M$410 VSS VSS VSS VSS nfet_03v3 L=2U W=0.5U AS=0.3P AD=0.14P PS=2.2U PD=1.06U
M$411 VSS VSS VSS VSS nfet_03v3 L=2U W=0.5U AS=0.14P AD=0.14P PS=1.06U PD=1.06U
M$412 VSS VSS VSS VSS nfet_03v3 L=2U W=0.5U AS=0.14P AD=0.14P PS=1.06U PD=1.06U
M$413 VSS VSS VSS VSS nfet_03v3 L=2U W=0.5U AS=0.14P AD=0.14P PS=1.06U PD=1.06U
M$414 VSS VSS VSS VSS nfet_03v3 L=2U W=0.5U AS=0.14P AD=0.14P PS=1.06U PD=1.06U
M$415 VSS VSS VSS VSS nfet_03v3 L=2U W=0.5U AS=0.14P AD=0.14P PS=1.06U PD=1.06U
M$416 VSS VSS VSS VSS nfet_03v3 L=2U W=0.5U AS=0.14P AD=0.14P PS=1.06U PD=1.06U
M$417 VSS VSS VSS VSS nfet_03v3 L=2U W=0.5U AS=0.14P AD=0.14P PS=1.06U PD=1.06U
M$418 VSS VSS VSS VSS nfet_03v3 L=2U W=0.5U AS=0.14P AD=0.14P PS=1.06U PD=1.06U
M$419 VSS VSS VSS VSS nfet_03v3 L=2U W=0.5U AS=0.14P AD=0.14P PS=1.06U PD=1.06U
M$420 VSS VSS VSS VSS nfet_03v3 L=2U W=0.5U AS=0.14P AD=0.14P PS=1.06U PD=1.06U
M$421 VSS VSS VSS VSS nfet_03v3 L=2U W=0.5U AS=0.14P AD=0.14P PS=1.06U PD=1.06U
M$422 VSS VSS VSS VSS nfet_03v3 L=2U W=0.5U AS=0.14P AD=0.14P PS=1.06U PD=1.06U
M$423 VSS VSS VSS VSS nfet_03v3 L=2U W=0.5U AS=0.14P AD=0.14P PS=1.06U PD=1.06U
M$424 VSS VSS VSS VSS nfet_03v3 L=2U W=0.5U AS=0.14P AD=0.14P PS=1.06U PD=1.06U
M$425 VSS VSS VSS VSS nfet_03v3 L=2U W=0.5U AS=0.14P AD=0.14P PS=1.06U PD=1.06U
M$426 VSS VSS VSS VSS nfet_03v3 L=2U W=0.5U AS=0.14P AD=0.14P PS=1.06U PD=1.06U
M$427 VSS VSS VSS VSS nfet_03v3 L=2U W=0.5U AS=0.14P AD=0.14P PS=1.06U PD=1.06U
M$428 VSS VSS VSS VSS nfet_03v3 L=2U W=0.5U AS=0.14P AD=0.14P PS=1.06U PD=1.06U
M$429 VSS VSS VSS VSS nfet_03v3 L=2U W=0.5U AS=0.14P AD=0.14P PS=1.06U PD=1.06U
M$430 VSS VSS VSS VSS nfet_03v3 L=2U W=0.5U AS=0.14P AD=0.14P PS=1.06U PD=1.06U
M$431 VSS VSS VSS VSS nfet_03v3 L=2U W=0.5U AS=0.14P AD=0.14P PS=1.06U PD=1.06U
M$432 VSS VSS VSS VSS nfet_03v3 L=2U W=0.5U AS=0.14P AD=0.14P PS=1.06U PD=1.06U
M$433 VSS VSS VSS VSS nfet_03v3 L=2U W=0.5U AS=0.14P AD=0.14P PS=1.06U PD=1.06U
M$434 VSS VSS VSS VSS nfet_03v3 L=2U W=0.5U AS=0.14P AD=0.14P PS=1.06U PD=1.06U
M$435 VSS VSS VSS VSS nfet_03v3 L=2U W=0.5U AS=0.14P AD=0.14P PS=1.06U PD=1.06U
M$436 VSS VSS VSS VSS nfet_03v3 L=2U W=0.5U AS=0.14P AD=0.14P PS=1.06U PD=1.06U
M$437 VSS VSS VSS VSS nfet_03v3 L=2U W=0.5U AS=0.14P AD=0.14P PS=1.06U PD=1.06U
M$438 VSS VSS VSS VSS nfet_03v3 L=2U W=0.5U AS=0.14P AD=0.14P PS=1.06U PD=1.06U
M$439 VSS VSS VSS VSS nfet_03v3 L=2U W=0.5U AS=0.14P AD=0.14P PS=1.06U PD=1.06U
M$440 VSS VSS VSS VSS nfet_03v3 L=2U W=0.5U AS=0.14P AD=0.14P PS=1.06U PD=1.06U
M$441 VSS VSS VSS VSS nfet_03v3 L=2U W=0.5U AS=0.14P AD=0.14P PS=1.06U PD=1.06U
M$442 VSS VSS VSS VSS nfet_03v3 L=2U W=0.5U AS=0.14P AD=0.14P PS=1.06U PD=1.06U
M$443 VSS VSS VSS VSS nfet_03v3 L=2U W=0.5U AS=0.14P AD=0.14P PS=1.06U PD=1.06U
M$444 VSS VSS VSS VSS nfet_03v3 L=2U W=0.5U AS=0.14P AD=0.14P PS=1.06U PD=1.06U
M$445 VSS VSS VSS VSS nfet_03v3 L=2U W=0.5U AS=0.14P AD=0.14P PS=1.06U PD=1.06U
M$446 VSS VSS VSS VSS nfet_03v3 L=2U W=0.5U AS=0.14P AD=0.14P PS=1.06U PD=1.06U
M$447 VSS VSS VSS VSS nfet_03v3 L=2U W=0.5U AS=0.14P AD=0.14P PS=1.06U PD=1.06U
M$448 VSS VSS VSS VSS nfet_03v3 L=2U W=0.5U AS=0.14P AD=0.14P PS=1.06U PD=1.06U
M$449 VSS VSS VSS VSS nfet_03v3 L=2U W=0.5U AS=0.14P AD=0.14P PS=1.06U PD=1.06U
M$450 VSS VSS VSS VSS nfet_03v3 L=2U W=0.5U AS=0.14P AD=0.14P PS=1.06U PD=1.06U
M$451 VSS VSS VSS VSS nfet_03v3 L=2U W=0.5U AS=0.14P AD=0.14P PS=1.06U PD=1.06U
M$452 VSS VSS VSS VSS nfet_03v3 L=2U W=0.5U AS=0.14P AD=0.14P PS=1.06U PD=1.06U
M$453 VSS VSS VSS VSS nfet_03v3 L=2U W=0.5U AS=0.14P AD=0.14P PS=1.06U PD=1.06U
M$454 VSS VSS VSS VSS nfet_03v3 L=2U W=0.5U AS=0.14P AD=0.14P PS=1.06U PD=1.06U
M$455 VSS VSS VSS VSS nfet_03v3 L=2U W=0.5U AS=0.14P AD=0.3P PS=1.06U PD=2.2U
M$456 \$160 VDD Ibias VSS nfet_03v3 L=0.5U W=1U AS=0.6P AD=0.6P PS=3.2U PD=3.2U
M$457 \$64 trim[0] Ibias VSS nfet_03v3 L=0.5U W=1U AS=0.6P AD=0.6P PS=3.2U
+ PD=3.2U
M$458 \$61 \$36 VSS VSS nfet_03v3 L=8U W=10U AS=6P AD=6P PS=21.2U PD=21.2U
M$459 \$64 \$9 \$61 VSS nfet_03v3 L=0.5U W=1U AS=0.6P AD=0.6P PS=3.2U PD=3.2U
M$460 \$65 \$8 \$61 VSS nfet_03v3 L=0.5U W=1U AS=0.6P AD=0.6P PS=3.2U PD=3.2U
M$461 \$65 trim[1] Ibias VSS nfet_03v3 L=0.5U W=1U AS=0.6P AD=0.6P PS=3.2U
+ PD=3.2U
M$462 \$66 trim[2] Ibias VSS nfet_03v3 L=0.5U W=1U AS=0.6P AD=0.6P PS=3.2U
+ PD=3.2U
M$463 \$61 cal \$36 VSS nfet_03v3 L=0.5U W=1U AS=0.6P AD=0.6P PS=3.2U PD=3.2U
M$464 \$66 \$7 \$61 VSS nfet_03v3 L=0.5U W=1U AS=0.6P AD=0.6P PS=3.2U PD=3.2U
M$465 \$67 \$6 \$61 VSS nfet_03v3 L=0.5U W=1U AS=0.6P AD=0.6P PS=3.2U PD=3.2U
M$466 \$9 trim[0] VSS VSS nfet_03v3 L=0.28U W=0.5U AS=0.375P AD=0.375P PS=2.5U
+ PD=2.5U
M$467 \$8 trim[1] VSS VSS nfet_03v3 L=0.28U W=0.5U AS=0.375P AD=0.375P PS=2.5U
+ PD=2.5U
M$468 \$7 trim[2] VSS VSS nfet_03v3 L=0.28U W=0.5U AS=0.375P AD=0.375P PS=2.5U
+ PD=2.5U
M$469 \$6 trim[3] VSS VSS nfet_03v3 L=0.28U W=0.5U AS=0.375P AD=0.375P PS=2.5U
+ PD=2.5U
M$470 \$62 cal VSS VSS nfet_03v3 L=0.28U W=0.5U AS=0.375P AD=0.375P PS=2.5U
+ PD=2.5U
M$471 \$67 trim[3] Ibias VSS nfet_03v3 L=0.5U W=1U AS=0.6P AD=0.6P PS=3.2U
+ PD=3.2U
M$472 \$36 \$62 VSS VSS nfet_03v3 L=45.45U W=0.5U AS=0.3P AD=0.3P PS=2.2U
+ PD=2.2U
M$473 VSS \$36 VSS VSS nfet_03v3 L=5U W=5U AS=3P AD=3P PS=11.2U PD=11.2U
M$474 VSS VSS VSS VSS nfet_03v3 L=2U W=10U AS=6P AD=6P PS=21.2U PD=21.2U
R$475 Iref \$163 VSS 25000 nwell L=50U W=2U
R$476 \$37 \$161 VSS 25000 nwell L=50U W=2U
R$477 \$37 \$163 VSS 25000 nwell L=50U W=2U
.ENDS trim_steer

.SUBCKT bias Vamp_bias VIp Iref Imon VKup Vb Vlk VKdn VK VDD VNA VT_inh Vthr
+ VT_dpi VSS
M$1 VDD VDD VDD VDD pfet_03v3 L=2U W=0.5U AS=0.14P AD=0.14P PS=1.06U PD=1.06U
M$2 VDD VDD VDD VDD pfet_03v3 L=2U W=0.5U AS=0.14P AD=0.14P PS=1.06U PD=1.06U
M$3 VDD VDD VDD VDD pfet_03v3 L=2U W=0.5U AS=0.14P AD=0.14P PS=1.06U PD=1.06U
M$4 VDD VDD VDD VDD pfet_03v3 L=2U W=0.5U AS=0.14P AD=0.14P PS=1.06U PD=1.06U
M$5 VDD VDD VDD VDD pfet_03v3 L=2U W=0.5U AS=0.14P AD=0.14P PS=1.06U PD=1.06U
M$6 VDD VDD VDD VDD pfet_03v3 L=2U W=0.5U AS=0.14P AD=0.14P PS=1.06U PD=1.06U
M$7 VDD VDD VDD VDD pfet_03v3 L=2U W=0.5U AS=0.14P AD=0.14P PS=1.06U PD=1.06U
M$8 VDD VDD VDD VDD pfet_03v3 L=2U W=0.5U AS=0.14P AD=0.14P PS=1.06U PD=1.06U
M$9 VDD VDD VDD VDD pfet_03v3 L=2U W=0.5U AS=0.14P AD=0.14P PS=1.06U PD=1.06U
M$10 VDD VDD VDD VDD pfet_03v3 L=2U W=0.5U AS=0.14P AD=0.14P PS=1.06U PD=1.06U
M$11 VDD VDD VDD VDD pfet_03v3 L=2U W=0.5U AS=0.14P AD=0.14P PS=1.06U PD=1.06U
M$12 VDD VDD VDD VDD pfet_03v3 L=2U W=0.5U AS=0.14P AD=0.14P PS=1.06U PD=1.06U
M$13 VDD VDD VDD VDD pfet_03v3 L=2U W=0.5U AS=0.14P AD=0.14P PS=1.06U PD=1.06U
M$14 VDD VDD VDD VDD pfet_03v3 L=2U W=0.5U AS=0.14P AD=0.14P PS=1.06U PD=1.06U
M$15 VDD VDD VDD VDD pfet_03v3 L=2U W=0.5U AS=0.14P AD=0.14P PS=1.06U PD=1.06U
M$16 VDD VDD VDD VDD pfet_03v3 L=2U W=0.5U AS=0.14P AD=0.14P PS=1.06U PD=1.06U
M$17 VDD VDD VDD VDD pfet_03v3 L=2U W=0.5U AS=0.14P AD=0.14P PS=1.06U PD=1.06U
M$18 VDD VDD VDD VDD pfet_03v3 L=2U W=0.5U AS=0.14P AD=0.14P PS=1.06U PD=1.06U
M$19 VDD VDD VDD VDD pfet_03v3 L=2U W=0.5U AS=0.14P AD=0.14P PS=1.06U PD=1.06U
M$20 VDD VDD VDD VDD pfet_03v3 L=2U W=0.5U AS=0.14P AD=0.14P PS=1.06U PD=1.06U
M$21 VDD VDD VDD VDD pfet_03v3 L=2U W=0.5U AS=0.14P AD=0.14P PS=1.06U PD=1.06U
M$22 VDD VDD VDD VDD pfet_03v3 L=2U W=0.5U AS=0.14P AD=0.14P PS=1.06U PD=1.06U
M$23 VDD VDD VDD VDD pfet_03v3 L=2U W=0.5U AS=0.14P AD=0.14P PS=1.06U PD=1.06U
M$24 VDD VDD VDD VDD pfet_03v3 L=2U W=0.5U AS=0.14P AD=0.14P PS=1.06U PD=1.06U
M$25 VDD VDD VDD VDD pfet_03v3 L=2U W=0.5U AS=0.14P AD=0.14P PS=1.06U PD=1.06U
M$26 VDD VDD VDD VDD pfet_03v3 L=2U W=0.5U AS=0.14P AD=0.14P PS=1.06U PD=1.06U
M$27 VDD VDD VDD VDD pfet_03v3 L=2U W=0.5U AS=0.14P AD=0.14P PS=1.06U PD=1.06U
M$28 VDD VDD VDD VDD pfet_03v3 L=2U W=0.5U AS=0.14P AD=0.14P PS=1.06U PD=1.06U
M$29 VDD VDD VDD VDD pfet_03v3 L=2U W=0.5U AS=0.14P AD=0.14P PS=1.06U PD=1.06U
M$30 VDD VDD VDD VDD pfet_03v3 L=2U W=0.5U AS=0.14P AD=0.14P PS=1.06U PD=1.06U
M$31 VDD VDD VDD VDD pfet_03v3 L=2U W=0.5U AS=0.14P AD=0.14P PS=1.06U PD=1.06U
M$32 VDD VDD VDD VDD pfet_03v3 L=2U W=0.5U AS=0.14P AD=0.14P PS=1.06U PD=1.06U
M$33 VDD VDD VDD VDD pfet_03v3 L=2U W=0.5U AS=0.14P AD=0.14P PS=1.06U PD=1.06U
M$34 VDD VDD VDD VDD pfet_03v3 L=2U W=0.5U AS=0.14P AD=0.14P PS=1.06U PD=1.06U
M$35 VDD VDD VDD VDD pfet_03v3 L=2U W=0.5U AS=0.14P AD=0.14P PS=1.06U PD=1.06U
M$36 VDD VDD VDD VDD pfet_03v3 L=2U W=0.5U AS=0.14P AD=0.14P PS=1.06U PD=1.06U
M$37 VDD VDD VDD VDD pfet_03v3 L=2U W=0.5U AS=0.14P AD=0.14P PS=1.06U PD=1.06U
M$38 VDD VDD VDD VDD pfet_03v3 L=2U W=0.5U AS=0.14P AD=0.14P PS=1.06U PD=1.06U
M$39 VDD VDD VDD VDD pfet_03v3 L=2U W=0.5U AS=0.14P AD=0.14P PS=1.06U PD=1.06U
M$40 VDD VDD VDD VDD pfet_03v3 L=2U W=0.5U AS=0.14P AD=0.14P PS=1.06U PD=1.06U
M$41 VDD VDD VDD VDD pfet_03v3 L=2U W=0.5U AS=0.14P AD=0.14P PS=1.06U PD=1.06U
M$42 VDD VDD VDD VDD pfet_03v3 L=2U W=0.5U AS=0.14P AD=0.14P PS=1.06U PD=1.06U
M$43 VDD VDD VDD VDD pfet_03v3 L=2U W=0.5U AS=0.14P AD=0.14P PS=1.06U PD=1.06U
M$44 VDD VDD VDD VDD pfet_03v3 L=2U W=0.5U AS=0.14P AD=0.14P PS=1.06U PD=1.06U
M$45 VDD VDD VDD VDD pfet_03v3 L=2U W=0.5U AS=0.14P AD=0.14P PS=1.06U PD=1.06U
M$46 VDD VDD VDD VDD pfet_03v3 L=2U W=0.5U AS=0.14P AD=0.14P PS=1.06U PD=1.06U
M$47 VDD VDD VDD VDD pfet_03v3 L=2U W=0.5U AS=0.14P AD=0.14P PS=1.06U PD=1.06U
M$48 VDD VDD VDD VDD pfet_03v3 L=2U W=0.5U AS=0.14P AD=0.14P PS=1.06U PD=1.06U
M$49 VDD VDD VDD VDD pfet_03v3 L=2U W=0.5U AS=0.14P AD=0.14P PS=1.06U PD=1.06U
M$50 VDD VDD VDD VDD pfet_03v3 L=2U W=0.5U AS=0.14P AD=0.14P PS=1.06U PD=1.06U
M$51 VDD VDD VDD VDD pfet_03v3 L=2U W=0.5U AS=0.14P AD=0.14P PS=1.06U PD=1.06U
M$52 VDD VDD VDD VDD pfet_03v3 L=2U W=0.5U AS=0.14P AD=0.14P PS=1.06U PD=1.06U
M$53 VDD VDD VDD VDD pfet_03v3 L=2U W=0.5U AS=0.14P AD=0.3P PS=1.06U PD=2.2U
M$54 VDD VDD VDD VDD pfet_03v3 L=2U W=0.5U AS=0.14P AD=0.14P PS=1.06U PD=1.06U
M$55 VDD VDD VDD VDD pfet_03v3 L=2U W=0.5U AS=0.14P AD=0.14P PS=1.06U PD=1.06U
M$56 VDD VDD VDD VDD pfet_03v3 L=2U W=0.5U AS=0.14P AD=0.14P PS=1.06U PD=1.06U
M$57 VDD VDD VDD VDD pfet_03v3 L=2U W=0.5U AS=0.14P AD=0.14P PS=1.06U PD=1.06U
M$58 VDD VDD VDD VDD pfet_03v3 L=2U W=0.5U AS=0.14P AD=0.14P PS=1.06U PD=1.06U
M$59 VDD VDD VDD VDD pfet_03v3 L=2U W=0.5U AS=0.14P AD=0.14P PS=1.06U PD=1.06U
M$60 VDD VDD VDD VDD pfet_03v3 L=2U W=0.5U AS=0.14P AD=0.14P PS=1.06U PD=1.06U
M$61 VDD VDD VDD VDD pfet_03v3 L=2U W=0.5U AS=0.14P AD=0.14P PS=1.06U PD=1.06U
M$62 VDD VDD VDD VDD pfet_03v3 L=2U W=0.5U AS=0.14P AD=0.14P PS=1.06U PD=1.06U
M$63 VDD VDD VDD VDD pfet_03v3 L=2U W=0.5U AS=0.14P AD=0.14P PS=1.06U PD=1.06U
M$64 VDD VDD VDD VDD pfet_03v3 L=2U W=0.5U AS=0.14P AD=0.14P PS=1.06U PD=1.06U
M$65 VDD VDD VDD VDD pfet_03v3 L=2U W=0.5U AS=0.14P AD=0.14P PS=1.06U PD=1.06U
M$66 VDD VDD VDD VDD pfet_03v3 L=2U W=0.5U AS=0.14P AD=0.14P PS=1.06U PD=1.06U
M$67 VDD VDD VDD VDD pfet_03v3 L=2U W=0.5U AS=0.14P AD=0.14P PS=1.06U PD=1.06U
M$68 VDD VDD VDD VDD pfet_03v3 L=2U W=0.5U AS=0.14P AD=0.14P PS=1.06U PD=1.06U
M$69 VDD VDD VDD VDD pfet_03v3 L=2U W=0.5U AS=0.14P AD=0.14P PS=1.06U PD=1.06U
M$70 VDD VDD VDD VDD pfet_03v3 L=2U W=0.5U AS=0.14P AD=0.14P PS=1.06U PD=1.06U
M$71 VDD VDD VDD VDD pfet_03v3 L=2U W=0.5U AS=0.14P AD=0.14P PS=1.06U PD=1.06U
M$72 VDD VDD VDD VDD pfet_03v3 L=2U W=0.5U AS=0.14P AD=0.14P PS=1.06U PD=1.06U
M$73 VDD VDD VDD VDD pfet_03v3 L=2U W=0.5U AS=0.14P AD=0.14P PS=1.06U PD=1.06U
M$74 VDD VDD VDD VDD pfet_03v3 L=2U W=0.5U AS=0.14P AD=0.14P PS=1.06U PD=1.06U
M$75 VDD VDD VDD VDD pfet_03v3 L=2U W=0.5U AS=0.14P AD=0.14P PS=1.06U PD=1.06U
M$76 VDD VDD VDD VDD pfet_03v3 L=2U W=0.5U AS=0.14P AD=0.14P PS=1.06U PD=1.06U
M$77 VDD VDD VDD VDD pfet_03v3 L=2U W=0.5U AS=0.14P AD=0.14P PS=1.06U PD=1.06U
M$78 VDD VDD VDD VDD pfet_03v3 L=2U W=0.5U AS=0.14P AD=0.14P PS=1.06U PD=1.06U
M$79 VDD VDD VDD VDD pfet_03v3 L=2U W=0.5U AS=0.14P AD=0.14P PS=1.06U PD=1.06U
M$80 VDD VDD VDD VDD pfet_03v3 L=2U W=0.5U AS=0.14P AD=0.14P PS=1.06U PD=1.06U
M$81 VDD VDD VDD VDD pfet_03v3 L=2U W=0.5U AS=0.14P AD=0.14P PS=1.06U PD=1.06U
M$82 VDD VDD VDD VDD pfet_03v3 L=2U W=0.5U AS=0.14P AD=0.14P PS=1.06U PD=1.06U
M$83 VDD VDD VDD VDD pfet_03v3 L=2U W=0.5U AS=0.14P AD=0.14P PS=1.06U PD=1.06U
M$84 VDD VDD VDD VDD pfet_03v3 L=2U W=0.5U AS=0.14P AD=0.14P PS=1.06U PD=1.06U
M$85 VDD VDD VDD VDD pfet_03v3 L=2U W=0.5U AS=0.14P AD=0.14P PS=1.06U PD=1.06U
M$86 VDD VDD VDD VDD pfet_03v3 L=2U W=0.5U AS=0.14P AD=0.14P PS=1.06U PD=1.06U
M$87 VDD VDD VDD VDD pfet_03v3 L=2U W=0.5U AS=0.14P AD=0.14P PS=1.06U PD=1.06U
M$88 VDD VDD VDD VDD pfet_03v3 L=2U W=0.5U AS=0.14P AD=0.14P PS=1.06U PD=1.06U
M$89 VDD VDD VDD VDD pfet_03v3 L=2U W=0.5U AS=0.14P AD=0.14P PS=1.06U PD=1.06U
M$90 VDD VDD VDD VDD pfet_03v3 L=2U W=0.5U AS=0.14P AD=0.14P PS=1.06U PD=1.06U
M$91 VDD VDD VDD VDD pfet_03v3 L=2U W=0.5U AS=0.14P AD=0.14P PS=1.06U PD=1.06U
M$92 VDD VDD VDD VDD pfet_03v3 L=2U W=0.5U AS=0.14P AD=0.14P PS=1.06U PD=1.06U
M$93 VDD VDD VDD VDD pfet_03v3 L=2U W=0.5U AS=0.14P AD=0.14P PS=1.06U PD=1.06U
M$94 VDD VDD VDD VDD pfet_03v3 L=2U W=0.5U AS=0.14P AD=0.14P PS=1.06U PD=1.06U
M$95 VDD VDD VDD VDD pfet_03v3 L=2U W=0.5U AS=0.14P AD=0.14P PS=1.06U PD=1.06U
M$96 VDD VDD VDD VDD pfet_03v3 L=2U W=0.5U AS=0.14P AD=0.14P PS=1.06U PD=1.06U
M$97 VDD VDD VDD VDD pfet_03v3 L=2U W=0.5U AS=0.14P AD=0.14P PS=1.06U PD=1.06U
M$98 VDD VDD VDD VDD pfet_03v3 L=2U W=0.5U AS=0.14P AD=0.14P PS=1.06U PD=1.06U
M$99 VDD VDD VDD VDD pfet_03v3 L=2U W=0.5U AS=0.14P AD=0.14P PS=1.06U PD=1.06U
M$100 VDD VDD VDD VDD pfet_03v3 L=2U W=0.5U AS=0.14P AD=0.14P PS=1.06U PD=1.06U
M$101 VDD VDD VDD VDD pfet_03v3 L=2U W=0.5U AS=0.14P AD=0.14P PS=1.06U PD=1.06U
M$102 VDD VDD VDD VDD pfet_03v3 L=2U W=0.5U AS=0.14P AD=0.14P PS=1.06U PD=1.06U
M$103 VDD VDD VDD VDD pfet_03v3 L=2U W=0.5U AS=0.14P AD=0.14P PS=1.06U PD=1.06U
M$104 VDD VDD VDD VDD pfet_03v3 L=2U W=0.5U AS=0.14P AD=0.14P PS=1.06U PD=1.06U
M$105 VDD VDD VDD VDD pfet_03v3 L=2U W=0.5U AS=0.14P AD=0.14P PS=1.06U PD=1.06U
M$106 VDD VDD VDD VDD pfet_03v3 L=2U W=0.5U AS=0.14P AD=0.14P PS=1.06U PD=1.06U
M$107 VDD VDD VDD VDD pfet_03v3 L=2U W=0.5U AS=0.14P AD=0.14P PS=1.06U PD=1.06U
M$108 VDD VDD VDD VDD pfet_03v3 L=2U W=0.5U AS=0.14P AD=0.14P PS=1.06U PD=1.06U
M$109 VDD VDD VDD VDD pfet_03v3 L=2U W=0.5U AS=0.14P AD=0.14P PS=1.06U PD=1.06U
M$110 VDD VDD VDD VDD pfet_03v3 L=2U W=0.5U AS=0.14P AD=0.14P PS=1.06U PD=1.06U
M$111 VDD VDD VDD VDD pfet_03v3 L=2U W=0.5U AS=0.14P AD=0.14P PS=1.06U PD=1.06U
M$112 VDD VDD VDD VDD pfet_03v3 L=2U W=0.5U AS=0.14P AD=0.14P PS=1.06U PD=1.06U
M$113 VDD VDD VDD VDD pfet_03v3 L=2U W=0.5U AS=0.14P AD=0.14P PS=1.06U PD=1.06U
M$114 VDD VDD VDD VDD pfet_03v3 L=2U W=0.5U AS=0.14P AD=0.14P PS=1.06U PD=1.06U
M$115 VDD VDD VDD VDD pfet_03v3 L=2U W=0.5U AS=0.14P AD=0.14P PS=1.06U PD=1.06U
M$116 VDD VDD VDD VDD pfet_03v3 L=2U W=0.5U AS=0.14P AD=0.14P PS=1.06U PD=1.06U
M$117 VDD VDD VDD VDD pfet_03v3 L=2U W=0.5U AS=0.14P AD=0.14P PS=1.06U PD=1.06U
M$118 VDD VDD VDD VDD pfet_03v3 L=2U W=0.5U AS=0.14P AD=0.14P PS=1.06U PD=1.06U
M$119 VDD VDD VDD VDD pfet_03v3 L=2U W=0.5U AS=0.14P AD=0.14P PS=1.06U PD=1.06U
M$120 VDD VDD VDD VDD pfet_03v3 L=2U W=0.5U AS=0.14P AD=0.14P PS=1.06U PD=1.06U
M$121 VDD VDD VDD VDD pfet_03v3 L=2U W=0.5U AS=0.14P AD=0.14P PS=1.06U PD=1.06U
M$122 VDD VDD VDD VDD pfet_03v3 L=2U W=0.5U AS=0.14P AD=0.14P PS=1.06U PD=1.06U
M$123 VDD VDD VDD VDD pfet_03v3 L=2U W=0.5U AS=0.14P AD=0.14P PS=1.06U PD=1.06U
M$124 VDD VDD VDD VDD pfet_03v3 L=2U W=0.5U AS=0.14P AD=0.14P PS=1.06U PD=1.06U
M$125 VDD VDD VDD VDD pfet_03v3 L=2U W=0.5U AS=0.14P AD=0.14P PS=1.06U PD=1.06U
M$126 VDD VDD VDD VDD pfet_03v3 L=2U W=0.5U AS=0.14P AD=0.14P PS=1.06U PD=1.06U
M$127 VDD VDD VDD VDD pfet_03v3 L=2U W=0.5U AS=0.14P AD=0.14P PS=1.06U PD=1.06U
M$128 VDD VDD VDD VDD pfet_03v3 L=2U W=0.5U AS=0.14P AD=0.14P PS=1.06U PD=1.06U
M$129 VDD VDD VDD VDD pfet_03v3 L=2U W=0.5U AS=0.14P AD=0.14P PS=1.06U PD=1.06U
M$130 VDD VDD VDD VDD pfet_03v3 L=2U W=0.5U AS=0.14P AD=0.14P PS=1.06U PD=1.06U
M$131 VDD VDD VDD VDD pfet_03v3 L=2U W=0.5U AS=0.14P AD=0.14P PS=1.06U PD=1.06U
M$132 VDD VDD VDD VDD pfet_03v3 L=2U W=0.5U AS=0.14P AD=0.14P PS=1.06U PD=1.06U
M$133 VDD VDD VDD VDD pfet_03v3 L=2U W=0.5U AS=0.14P AD=0.14P PS=1.06U PD=1.06U
M$134 VDD VDD VDD VDD pfet_03v3 L=2U W=0.5U AS=0.14P AD=0.14P PS=1.06U PD=1.06U
M$135 VDD VDD VDD VDD pfet_03v3 L=2U W=0.5U AS=0.14P AD=0.14P PS=1.06U PD=1.06U
M$136 VDD VDD VDD VDD pfet_03v3 L=2U W=0.5U AS=0.14P AD=0.14P PS=1.06U PD=1.06U
M$137 VDD VDD VDD VDD pfet_03v3 L=2U W=0.5U AS=0.14P AD=0.14P PS=1.06U PD=1.06U
M$138 VDD VDD VDD VDD pfet_03v3 L=2U W=0.5U AS=0.14P AD=0.14P PS=1.06U PD=1.06U
M$139 VDD VDD VDD VDD pfet_03v3 L=2U W=0.5U AS=0.14P AD=0.14P PS=1.06U PD=1.06U
M$140 VDD VDD VDD VDD pfet_03v3 L=2U W=0.5U AS=0.14P AD=0.14P PS=1.06U PD=1.06U
M$141 VDD VDD VDD VDD pfet_03v3 L=2U W=0.5U AS=0.14P AD=0.14P PS=1.06U PD=1.06U
M$142 VDD VDD VDD VDD pfet_03v3 L=2U W=0.5U AS=0.14P AD=0.14P PS=1.06U PD=1.06U
M$143 VDD VDD VDD VDD pfet_03v3 L=2U W=0.5U AS=0.14P AD=0.14P PS=1.06U PD=1.06U
M$144 VDD VDD VDD VDD pfet_03v3 L=2U W=0.5U AS=0.14P AD=0.14P PS=1.06U PD=1.06U
M$145 VDD VDD VDD VDD pfet_03v3 L=2U W=0.5U AS=0.14P AD=0.14P PS=1.06U PD=1.06U
M$146 VDD VDD VDD VDD pfet_03v3 L=2U W=0.5U AS=0.14P AD=0.14P PS=1.06U PD=1.06U
M$147 VDD VDD VDD VDD pfet_03v3 L=2U W=0.5U AS=0.14P AD=0.14P PS=1.06U PD=1.06U
M$148 VDD VDD VDD VDD pfet_03v3 L=2U W=0.5U AS=0.14P AD=0.14P PS=1.06U PD=1.06U
M$149 VDD VDD VDD VDD pfet_03v3 L=2U W=0.5U AS=0.14P AD=0.14P PS=1.06U PD=1.06U
M$150 VDD VDD VDD VDD pfet_03v3 L=2U W=0.5U AS=0.14P AD=0.14P PS=1.06U PD=1.06U
M$151 VDD VDD VDD VDD pfet_03v3 L=2U W=0.5U AS=0.14P AD=0.14P PS=1.06U PD=1.06U
M$152 VDD VDD VDD VDD pfet_03v3 L=2U W=0.5U AS=0.14P AD=0.14P PS=1.06U PD=1.06U
M$153 VDD VDD VDD VDD pfet_03v3 L=2U W=0.5U AS=0.14P AD=0.14P PS=1.06U PD=1.06U
M$154 VDD VDD VDD VDD pfet_03v3 L=2U W=0.5U AS=0.14P AD=0.14P PS=1.06U PD=1.06U
M$155 VDD VDD VDD VDD pfet_03v3 L=2U W=0.5U AS=0.14P AD=0.14P PS=1.06U PD=1.06U
M$156 VDD VDD VDD VDD pfet_03v3 L=2U W=0.5U AS=0.14P AD=0.14P PS=1.06U PD=1.06U
M$157 VDD VDD VDD VDD pfet_03v3 L=2U W=0.5U AS=0.14P AD=0.14P PS=1.06U PD=1.06U
M$158 VDD VDD VDD VDD pfet_03v3 L=2U W=0.5U AS=0.14P AD=0.14P PS=1.06U PD=1.06U
M$159 VDD VDD VDD VDD pfet_03v3 L=2U W=0.5U AS=0.14P AD=0.14P PS=1.06U PD=1.06U
M$160 VDD VDD VDD VDD pfet_03v3 L=2U W=0.5U AS=0.3P AD=0.14P PS=2.2U PD=1.06U
M$161 VDD VDD VDD VDD pfet_03v3 L=2U W=0.5U AS=0.14P AD=0.14P PS=1.06U PD=1.06U
M$162 VDD VDD VDD VDD pfet_03v3 L=2U W=0.5U AS=0.14P AD=0.14P PS=1.06U PD=1.06U
M$163 VDD VDD VDD VDD pfet_03v3 L=2U W=0.5U AS=0.14P AD=0.14P PS=1.06U PD=1.06U
M$164 VDD VDD VDD VDD pfet_03v3 L=2U W=0.5U AS=0.14P AD=0.14P PS=1.06U PD=1.06U
M$165 VDD VDD VDD VDD pfet_03v3 L=2U W=0.5U AS=0.14P AD=0.14P PS=1.06U PD=1.06U
M$166 VDD VDD VDD VDD pfet_03v3 L=2U W=0.5U AS=0.14P AD=0.14P PS=1.06U PD=1.06U
M$167 VDD VDD VDD VDD pfet_03v3 L=2U W=0.5U AS=0.14P AD=0.14P PS=1.06U PD=1.06U
M$168 VDD VDD VDD VDD pfet_03v3 L=2U W=0.5U AS=0.14P AD=0.14P PS=1.06U PD=1.06U
M$169 VDD VDD VDD VDD pfet_03v3 L=2U W=0.5U AS=0.14P AD=0.14P PS=1.06U PD=1.06U
M$170 VDD VDD VDD VDD pfet_03v3 L=2U W=0.5U AS=0.14P AD=0.14P PS=1.06U PD=1.06U
M$171 VDD VDD VDD VDD pfet_03v3 L=2U W=0.5U AS=0.14P AD=0.14P PS=1.06U PD=1.06U
M$172 VDD VDD VDD VDD pfet_03v3 L=2U W=0.5U AS=0.14P AD=0.14P PS=1.06U PD=1.06U
M$173 VDD VDD VDD VDD pfet_03v3 L=2U W=0.5U AS=0.14P AD=0.14P PS=1.06U PD=1.06U
M$174 VDD VDD VDD VDD pfet_03v3 L=2U W=0.5U AS=0.14P AD=0.14P PS=1.06U PD=1.06U
M$175 VDD VDD VDD VDD pfet_03v3 L=2U W=0.5U AS=0.14P AD=0.14P PS=1.06U PD=1.06U
M$176 VDD VDD VDD VDD pfet_03v3 L=2U W=0.5U AS=0.14P AD=0.14P PS=1.06U PD=1.06U
M$177 VDD VDD VDD VDD pfet_03v3 L=2U W=0.5U AS=0.14P AD=0.14P PS=1.06U PD=1.06U
M$178 VDD VDD VDD VDD pfet_03v3 L=2U W=0.5U AS=0.14P AD=0.14P PS=1.06U PD=1.06U
M$179 VDD VDD VDD VDD pfet_03v3 L=2U W=0.5U AS=0.14P AD=0.14P PS=1.06U PD=1.06U
M$180 VDD VDD VDD VDD pfet_03v3 L=2U W=0.5U AS=0.14P AD=0.14P PS=1.06U PD=1.06U
M$181 VDD VDD VDD VDD pfet_03v3 L=2U W=0.5U AS=0.14P AD=0.14P PS=1.06U PD=1.06U
M$182 VDD VDD VDD VDD pfet_03v3 L=2U W=0.5U AS=0.14P AD=0.14P PS=1.06U PD=1.06U
M$183 VDD VDD VDD VDD pfet_03v3 L=2U W=0.5U AS=0.14P AD=0.14P PS=1.06U PD=1.06U
M$184 VDD VDD VDD VDD pfet_03v3 L=2U W=0.5U AS=0.14P AD=0.14P PS=1.06U PD=1.06U
M$185 VDD VDD VDD VDD pfet_03v3 L=2U W=0.5U AS=0.14P AD=0.14P PS=1.06U PD=1.06U
M$186 VDD VDD VDD VDD pfet_03v3 L=2U W=0.5U AS=0.14P AD=0.14P PS=1.06U PD=1.06U
M$187 VDD VDD VDD VDD pfet_03v3 L=2U W=0.5U AS=0.14P AD=0.14P PS=1.06U PD=1.06U
M$188 VDD VDD VDD VDD pfet_03v3 L=2U W=0.5U AS=0.14P AD=0.14P PS=1.06U PD=1.06U
M$189 VDD VDD VDD VDD pfet_03v3 L=2U W=0.5U AS=0.14P AD=0.14P PS=1.06U PD=1.06U
M$190 VDD VDD VDD VDD pfet_03v3 L=2U W=0.5U AS=0.14P AD=0.14P PS=1.06U PD=1.06U
M$191 VDD VDD VDD VDD pfet_03v3 L=2U W=0.5U AS=0.14P AD=0.14P PS=1.06U PD=1.06U
M$192 VDD VDD VDD VDD pfet_03v3 L=2U W=0.5U AS=0.14P AD=0.14P PS=1.06U PD=1.06U
M$193 VDD VDD VDD VDD pfet_03v3 L=2U W=0.5U AS=0.14P AD=0.14P PS=1.06U PD=1.06U
M$194 VDD VDD VDD VDD pfet_03v3 L=2U W=0.5U AS=0.14P AD=0.14P PS=1.06U PD=1.06U
M$195 VDD VDD VDD VDD pfet_03v3 L=2U W=0.5U AS=0.14P AD=0.14P PS=1.06U PD=1.06U
M$196 VDD VDD VDD VDD pfet_03v3 L=2U W=0.5U AS=0.14P AD=0.14P PS=1.06U PD=1.06U
M$197 VDD VDD VDD VDD pfet_03v3 L=2U W=0.5U AS=0.14P AD=0.14P PS=1.06U PD=1.06U
M$198 VDD VDD VDD VDD pfet_03v3 L=2U W=0.5U AS=0.14P AD=0.14P PS=1.06U PD=1.06U
M$199 VDD VDD VDD VDD pfet_03v3 L=2U W=0.5U AS=0.14P AD=0.14P PS=1.06U PD=1.06U
M$200 VDD VDD VDD VDD pfet_03v3 L=2U W=0.5U AS=0.14P AD=0.14P PS=1.06U PD=1.06U
M$201 VDD VDD VDD VDD pfet_03v3 L=2U W=0.5U AS=0.14P AD=0.14P PS=1.06U PD=1.06U
M$202 VDD VDD VDD VDD pfet_03v3 L=2U W=0.5U AS=0.14P AD=0.14P PS=1.06U PD=1.06U
M$203 VDD VDD VDD VDD pfet_03v3 L=2U W=0.5U AS=0.14P AD=0.14P PS=1.06U PD=1.06U
M$204 VDD VDD VDD VDD pfet_03v3 L=2U W=0.5U AS=0.14P AD=0.14P PS=1.06U PD=1.06U
M$205 VDD VDD VDD VDD pfet_03v3 L=2U W=0.5U AS=0.14P AD=0.14P PS=1.06U PD=1.06U
M$206 VDD VDD VDD VDD pfet_03v3 L=2U W=0.5U AS=0.14P AD=0.14P PS=1.06U PD=1.06U
M$207 VDD VDD VDD VDD pfet_03v3 L=2U W=0.5U AS=0.14P AD=0.14P PS=1.06U PD=1.06U
M$208 VDD VDD VDD VDD pfet_03v3 L=2U W=0.5U AS=0.14P AD=0.14P PS=1.06U PD=1.06U
M$209 VDD VDD VDD VDD pfet_03v3 L=2U W=0.5U AS=0.14P AD=0.14P PS=1.06U PD=1.06U
M$210 VDD VDD VDD VDD pfet_03v3 L=2U W=0.5U AS=0.14P AD=0.14P PS=1.06U PD=1.06U
M$211 VDD VDD VDD VDD pfet_03v3 L=2U W=0.5U AS=0.14P AD=0.14P PS=1.06U PD=1.06U
M$212 VDD VDD VDD VDD pfet_03v3 L=2U W=0.5U AS=0.14P AD=0.14P PS=1.06U PD=1.06U
M$213 VDD VDD VDD VDD pfet_03v3 L=2U W=12.94U AS=7.764P AD=7.764P PS=27.08U
+ PD=27.08U
M$214 VDD VDD VDD VDD pfet_03v3 L=2U W=0.5U AS=0.14P AD=0.14P PS=1.06U PD=1.06U
M$215 VDD VDD VDD VDD pfet_03v3 L=2U W=0.5U AS=0.14P AD=0.14P PS=1.06U PD=1.06U
M$216 VDD VDD VDD VDD pfet_03v3 L=2U W=0.5U AS=0.14P AD=0.14P PS=1.06U PD=1.06U
M$217 VDD VDD VDD VDD pfet_03v3 L=2U W=0.5U AS=0.14P AD=0.14P PS=1.06U PD=1.06U
M$218 VDD VDD VDD VDD pfet_03v3 L=2U W=0.5U AS=0.14P AD=0.14P PS=1.06U PD=1.06U
M$219 VDD VDD VDD VDD pfet_03v3 L=2U W=0.5U AS=0.14P AD=0.14P PS=1.06U PD=1.06U
M$220 VDD VDD VDD VDD pfet_03v3 L=2U W=0.5U AS=0.14P AD=0.14P PS=1.06U PD=1.06U
M$221 VDD VDD VDD VDD pfet_03v3 L=2U W=0.5U AS=0.14P AD=0.14P PS=1.06U PD=1.06U
M$222 VDD VDD VDD VDD pfet_03v3 L=2U W=0.5U AS=0.14P AD=0.14P PS=1.06U PD=1.06U
M$223 VDD VDD VDD VDD pfet_03v3 L=2U W=0.5U AS=0.14P AD=0.14P PS=1.06U PD=1.06U
M$224 VDD VDD VDD VDD pfet_03v3 L=2U W=0.5U AS=0.14P AD=0.14P PS=1.06U PD=1.06U
M$225 VDD VDD VDD VDD pfet_03v3 L=2U W=0.5U AS=0.14P AD=0.14P PS=1.06U PD=1.06U
M$226 VDD VDD VDD VDD pfet_03v3 L=2U W=0.5U AS=0.14P AD=0.14P PS=1.06U PD=1.06U
M$227 VDD VDD VDD VDD pfet_03v3 L=2U W=0.5U AS=0.14P AD=0.14P PS=1.06U PD=1.06U
M$228 VDD VDD VDD VDD pfet_03v3 L=2U W=0.5U AS=0.14P AD=0.14P PS=1.06U PD=1.06U
M$229 VDD VDD VDD VDD pfet_03v3 L=2U W=0.5U AS=0.14P AD=0.14P PS=1.06U PD=1.06U
M$230 VDD VDD VDD VDD pfet_03v3 L=2U W=0.5U AS=0.14P AD=0.14P PS=1.06U PD=1.06U
M$231 VDD VDD VDD VDD pfet_03v3 L=2U W=0.5U AS=0.14P AD=0.14P PS=1.06U PD=1.06U
M$232 VDD VDD VDD VDD pfet_03v3 L=2U W=0.5U AS=0.14P AD=0.14P PS=1.06U PD=1.06U
M$233 VDD VDD VDD VDD pfet_03v3 L=2U W=0.5U AS=0.14P AD=0.14P PS=1.06U PD=1.06U
M$234 VDD VDD VDD VDD pfet_03v3 L=2U W=0.5U AS=0.14P AD=0.14P PS=1.06U PD=1.06U
M$235 VDD VDD VDD VDD pfet_03v3 L=2U W=0.5U AS=0.14P AD=0.14P PS=1.06U PD=1.06U
M$236 VDD VDD VDD VDD pfet_03v3 L=2U W=0.5U AS=0.14P AD=0.14P PS=1.06U PD=1.06U
M$237 VDD VDD VDD VDD pfet_03v3 L=2U W=0.5U AS=0.14P AD=0.14P PS=1.06U PD=1.06U
M$238 VDD VDD VDD VDD pfet_03v3 L=2U W=0.5U AS=0.14P AD=0.14P PS=1.06U PD=1.06U
M$239 VDD VDD VDD VDD pfet_03v3 L=2U W=0.5U AS=0.14P AD=0.14P PS=1.06U PD=1.06U
M$240 VDD VDD VDD VDD pfet_03v3 L=2U W=0.5U AS=0.14P AD=0.14P PS=1.06U PD=1.06U
M$241 VDD VDD VDD VDD pfet_03v3 L=2U W=0.5U AS=0.14P AD=0.14P PS=1.06U PD=1.06U
M$242 VDD VDD VDD VDD pfet_03v3 L=2U W=0.5U AS=0.14P AD=0.14P PS=1.06U PD=1.06U
M$243 VDD VDD VDD VDD pfet_03v3 L=2U W=0.5U AS=0.14P AD=0.14P PS=1.06U PD=1.06U
M$244 VDD VDD VDD VDD pfet_03v3 L=2U W=0.5U AS=0.14P AD=0.14P PS=1.06U PD=1.06U
M$245 VDD VDD VDD VDD pfet_03v3 L=2U W=0.5U AS=0.14P AD=0.14P PS=1.06U PD=1.06U
M$246 VDD VDD VDD VDD pfet_03v3 L=2U W=0.5U AS=0.14P AD=0.14P PS=1.06U PD=1.06U
M$247 VDD VDD VDD VDD pfet_03v3 L=2U W=0.5U AS=0.14P AD=0.14P PS=1.06U PD=1.06U
M$248 VDD VDD VDD VDD pfet_03v3 L=2U W=0.5U AS=0.14P AD=0.14P PS=1.06U PD=1.06U
M$249 VDD VDD VDD VDD pfet_03v3 L=2U W=0.5U AS=0.14P AD=0.14P PS=1.06U PD=1.06U
M$250 VDD VDD VDD VDD pfet_03v3 L=2U W=0.5U AS=0.14P AD=0.14P PS=1.06U PD=1.06U
M$251 VDD VDD VDD VDD pfet_03v3 L=2U W=0.5U AS=0.14P AD=0.14P PS=1.06U PD=1.06U
M$252 VDD VDD VDD VDD pfet_03v3 L=2U W=0.5U AS=0.14P AD=0.14P PS=1.06U PD=1.06U
M$253 VDD VDD VDD VDD pfet_03v3 L=2U W=0.5U AS=0.14P AD=0.14P PS=1.06U PD=1.06U
M$254 VDD VDD VDD VDD pfet_03v3 L=2U W=0.5U AS=0.14P AD=0.14P PS=1.06U PD=1.06U
M$255 VDD VDD VDD VDD pfet_03v3 L=2U W=0.5U AS=0.14P AD=0.14P PS=1.06U PD=1.06U
M$256 VDD VDD VDD VDD pfet_03v3 L=2U W=0.5U AS=0.14P AD=0.14P PS=1.06U PD=1.06U
M$257 VDD VDD VDD VDD pfet_03v3 L=2U W=0.5U AS=0.14P AD=0.14P PS=1.06U PD=1.06U
M$258 VDD VDD VDD VDD pfet_03v3 L=2U W=0.5U AS=0.14P AD=0.14P PS=1.06U PD=1.06U
M$259 VDD VDD VDD VDD pfet_03v3 L=2U W=0.5U AS=0.14P AD=0.14P PS=1.06U PD=1.06U
M$260 VDD VDD VDD VDD pfet_03v3 L=2U W=0.5U AS=0.14P AD=0.14P PS=1.06U PD=1.06U
M$261 VDD VDD VDD VDD pfet_03v3 L=2U W=0.5U AS=0.14P AD=0.14P PS=1.06U PD=1.06U
M$262 VDD VDD VDD VDD pfet_03v3 L=2U W=0.5U AS=0.14P AD=0.14P PS=1.06U PD=1.06U
M$263 VDD VDD VDD VDD pfet_03v3 L=2U W=0.5U AS=0.14P AD=0.14P PS=1.06U PD=1.06U
M$264 VDD VDD VDD VDD pfet_03v3 L=2U W=0.5U AS=0.14P AD=0.14P PS=1.06U PD=1.06U
M$265 VDD VDD VDD VDD pfet_03v3 L=2U W=0.5U AS=0.14P AD=0.14P PS=1.06U PD=1.06U
M$266 VDD VDD VDD VDD pfet_03v3 L=2U W=0.5U AS=0.14P AD=0.3P PS=1.06U PD=2.2U
M$267 VDD VDD VDD VDD pfet_03v3 L=2U W=0.5U AS=0.14P AD=0.14P PS=1.06U PD=1.06U
M$268 VDD VDD VDD VDD pfet_03v3 L=2U W=0.5U AS=0.14P AD=0.14P PS=1.06U PD=1.06U
M$269 VDD VDD VDD VDD pfet_03v3 L=2U W=0.5U AS=0.14P AD=0.14P PS=1.06U PD=1.06U
M$270 VDD VDD VDD VDD pfet_03v3 L=2U W=0.5U AS=0.14P AD=0.14P PS=1.06U PD=1.06U
M$271 VDD VDD VDD VDD pfet_03v3 L=2U W=0.5U AS=0.14P AD=0.14P PS=1.06U PD=1.06U
M$272 VDD VDD VDD VDD pfet_03v3 L=2U W=0.5U AS=0.14P AD=0.14P PS=1.06U PD=1.06U
M$273 VDD VDD VDD VDD pfet_03v3 L=2U W=0.5U AS=0.14P AD=0.14P PS=1.06U PD=1.06U
M$274 VDD VDD VDD VDD pfet_03v3 L=2U W=0.5U AS=0.14P AD=0.14P PS=1.06U PD=1.06U
M$275 VDD VDD VDD VDD pfet_03v3 L=2U W=0.5U AS=0.14P AD=0.14P PS=1.06U PD=1.06U
M$276 VDD VDD VDD VDD pfet_03v3 L=2U W=0.5U AS=0.14P AD=0.14P PS=1.06U PD=1.06U
M$277 VDD VDD VDD VDD pfet_03v3 L=2U W=0.5U AS=0.14P AD=0.14P PS=1.06U PD=1.06U
M$278 VDD VDD VDD VDD pfet_03v3 L=2U W=0.5U AS=0.14P AD=0.14P PS=1.06U PD=1.06U
M$279 VDD VDD VDD VDD pfet_03v3 L=2U W=0.5U AS=0.14P AD=0.14P PS=1.06U PD=1.06U
M$280 VDD VDD VDD VDD pfet_03v3 L=2U W=0.5U AS=0.14P AD=0.14P PS=1.06U PD=1.06U
M$281 VDD VDD VDD VDD pfet_03v3 L=2U W=0.5U AS=0.14P AD=0.14P PS=1.06U PD=1.06U
M$282 VDD VDD VDD VDD pfet_03v3 L=2U W=0.5U AS=0.14P AD=0.14P PS=1.06U PD=1.06U
M$283 VDD VDD VDD VDD pfet_03v3 L=2U W=0.5U AS=0.14P AD=0.14P PS=1.06U PD=1.06U
M$284 VDD VDD VDD VDD pfet_03v3 L=2U W=0.5U AS=0.14P AD=0.14P PS=1.06U PD=1.06U
M$285 VDD VDD VDD VDD pfet_03v3 L=2U W=0.5U AS=0.14P AD=0.14P PS=1.06U PD=1.06U
M$286 VDD VDD VDD VDD pfet_03v3 L=2U W=0.5U AS=0.14P AD=0.14P PS=1.06U PD=1.06U
M$287 VDD VDD VDD VDD pfet_03v3 L=2U W=0.5U AS=0.14P AD=0.14P PS=1.06U PD=1.06U
M$288 VDD VDD VDD VDD pfet_03v3 L=2U W=0.5U AS=0.14P AD=0.14P PS=1.06U PD=1.06U
M$289 VDD VDD VDD VDD pfet_03v3 L=2U W=0.5U AS=0.14P AD=0.14P PS=1.06U PD=1.06U
M$290 VDD VDD VDD VDD pfet_03v3 L=2U W=0.5U AS=0.14P AD=0.14P PS=1.06U PD=1.06U
M$291 VDD VDD VDD VDD pfet_03v3 L=2U W=0.5U AS=0.14P AD=0.14P PS=1.06U PD=1.06U
M$292 VDD VDD VDD VDD pfet_03v3 L=2U W=0.5U AS=0.14P AD=0.14P PS=1.06U PD=1.06U
M$293 VDD VDD VDD VDD pfet_03v3 L=2U W=0.5U AS=0.14P AD=0.14P PS=1.06U PD=1.06U
M$294 VDD VDD VDD VDD pfet_03v3 L=2U W=0.5U AS=0.14P AD=0.14P PS=1.06U PD=1.06U
M$295 VDD VDD VDD VDD pfet_03v3 L=2U W=0.5U AS=0.14P AD=0.14P PS=1.06U PD=1.06U
M$296 VDD VDD VDD VDD pfet_03v3 L=2U W=0.5U AS=0.14P AD=0.14P PS=1.06U PD=1.06U
M$297 VDD VDD VDD VDD pfet_03v3 L=2U W=0.5U AS=0.14P AD=0.14P PS=1.06U PD=1.06U
M$298 VDD VDD VDD VDD pfet_03v3 L=2U W=0.5U AS=0.14P AD=0.14P PS=1.06U PD=1.06U
M$299 VDD VDD VDD VDD pfet_03v3 L=2U W=0.5U AS=0.14P AD=0.14P PS=1.06U PD=1.06U
M$300 VDD VDD VDD VDD pfet_03v3 L=2U W=0.5U AS=0.14P AD=0.14P PS=1.06U PD=1.06U
M$301 VDD VDD VDD VDD pfet_03v3 L=2U W=0.5U AS=0.14P AD=0.14P PS=1.06U PD=1.06U
M$302 VDD VDD VDD VDD pfet_03v3 L=2U W=0.5U AS=0.14P AD=0.14P PS=1.06U PD=1.06U
M$303 VDD VDD VDD VDD pfet_03v3 L=2U W=0.5U AS=0.14P AD=0.14P PS=1.06U PD=1.06U
M$304 VDD VDD VDD VDD pfet_03v3 L=2U W=0.5U AS=0.14P AD=0.14P PS=1.06U PD=1.06U
M$305 VDD VDD VDD VDD pfet_03v3 L=2U W=0.5U AS=0.14P AD=0.14P PS=1.06U PD=1.06U
M$306 VDD VDD VDD VDD pfet_03v3 L=2U W=0.5U AS=0.14P AD=0.14P PS=1.06U PD=1.06U
M$307 VDD VDD VDD VDD pfet_03v3 L=2U W=0.5U AS=0.14P AD=0.14P PS=1.06U PD=1.06U
M$308 VDD VDD VDD VDD pfet_03v3 L=2U W=0.5U AS=0.14P AD=0.14P PS=1.06U PD=1.06U
M$309 VDD VDD VDD VDD pfet_03v3 L=2U W=0.5U AS=0.14P AD=0.14P PS=1.06U PD=1.06U
M$310 VDD VDD VDD VDD pfet_03v3 L=2U W=0.5U AS=0.14P AD=0.14P PS=1.06U PD=1.06U
M$311 VDD VDD VDD VDD pfet_03v3 L=2U W=0.5U AS=0.14P AD=0.14P PS=1.06U PD=1.06U
M$312 VDD VDD VDD VDD pfet_03v3 L=2U W=0.5U AS=0.14P AD=0.14P PS=1.06U PD=1.06U
M$313 VDD VDD VDD VDD pfet_03v3 L=2U W=0.5U AS=0.14P AD=0.14P PS=1.06U PD=1.06U
M$314 VDD VDD VDD VDD pfet_03v3 L=2U W=0.5U AS=0.14P AD=0.14P PS=1.06U PD=1.06U
M$315 VDD VDD VDD VDD pfet_03v3 L=2U W=0.5U AS=0.14P AD=0.14P PS=1.06U PD=1.06U
M$316 VDD VDD VDD VDD pfet_03v3 L=2U W=0.5U AS=0.14P AD=0.14P PS=1.06U PD=1.06U
M$317 VDD VDD VDD VDD pfet_03v3 L=2U W=0.5U AS=0.14P AD=0.14P PS=1.06U PD=1.06U
M$318 VDD VDD VDD VDD pfet_03v3 L=2U W=0.5U AS=0.14P AD=0.14P PS=1.06U PD=1.06U
M$319 VDD VDD VDD VDD pfet_03v3 L=2U W=0.5U AS=0.14P AD=0.14P PS=1.06U PD=1.06U
M$320 VDD VDD VDD VDD pfet_03v3 L=2U W=0.5U AS=0.14P AD=0.14P PS=1.06U PD=1.06U
M$321 VDD VDD VDD VDD pfet_03v3 L=2U W=0.5U AS=0.14P AD=0.14P PS=1.06U PD=1.06U
M$322 VDD VDD VDD VDD pfet_03v3 L=2U W=0.5U AS=0.14P AD=0.14P PS=1.06U PD=1.06U
M$323 VDD VDD VDD VDD pfet_03v3 L=2U W=0.5U AS=0.14P AD=0.14P PS=1.06U PD=1.06U
M$324 VDD VDD VDD VDD pfet_03v3 L=2U W=0.5U AS=0.14P AD=0.14P PS=1.06U PD=1.06U
M$325 VDD VDD VDD VDD pfet_03v3 L=2U W=0.5U AS=0.14P AD=0.14P PS=1.06U PD=1.06U
M$326 VDD VDD VDD VDD pfet_03v3 L=2U W=0.5U AS=0.14P AD=0.14P PS=1.06U PD=1.06U
M$327 VDD VDD VDD VDD pfet_03v3 L=2U W=0.5U AS=0.14P AD=0.14P PS=1.06U PD=1.06U
M$328 VDD VDD VDD VDD pfet_03v3 L=2U W=0.5U AS=0.14P AD=0.14P PS=1.06U PD=1.06U
M$329 VDD VDD VDD VDD pfet_03v3 L=2U W=0.5U AS=0.14P AD=0.14P PS=1.06U PD=1.06U
M$330 VDD VDD VDD VDD pfet_03v3 L=2U W=0.5U AS=0.14P AD=0.14P PS=1.06U PD=1.06U
M$331 VDD VDD VDD VDD pfet_03v3 L=2U W=0.5U AS=0.14P AD=0.14P PS=1.06U PD=1.06U
M$332 VDD VDD VDD VDD pfet_03v3 L=2U W=0.5U AS=0.14P AD=0.14P PS=1.06U PD=1.06U
M$333 VDD VDD VDD VDD pfet_03v3 L=2U W=0.5U AS=0.14P AD=0.14P PS=1.06U PD=1.06U
M$334 VDD VDD VDD VDD pfet_03v3 L=2U W=0.5U AS=0.14P AD=0.14P PS=1.06U PD=1.06U
M$335 VDD VDD VDD VDD pfet_03v3 L=2U W=0.5U AS=0.14P AD=0.14P PS=1.06U PD=1.06U
M$336 VDD VDD VDD VDD pfet_03v3 L=2U W=0.5U AS=0.14P AD=0.14P PS=1.06U PD=1.06U
M$337 VDD VDD VDD VDD pfet_03v3 L=2U W=0.5U AS=0.14P AD=0.14P PS=1.06U PD=1.06U
M$338 VDD VDD VDD VDD pfet_03v3 L=2U W=0.5U AS=0.14P AD=0.14P PS=1.06U PD=1.06U
M$339 VDD VDD VDD VDD pfet_03v3 L=2U W=0.5U AS=0.14P AD=0.14P PS=1.06U PD=1.06U
M$340 VDD VDD VDD VDD pfet_03v3 L=2U W=0.5U AS=0.14P AD=0.14P PS=1.06U PD=1.06U
M$341 VDD VDD VDD VDD pfet_03v3 L=2U W=0.5U AS=0.14P AD=0.14P PS=1.06U PD=1.06U
M$342 VDD VDD VDD VDD pfet_03v3 L=2U W=0.5U AS=0.14P AD=0.14P PS=1.06U PD=1.06U
M$343 VDD VDD VDD VDD pfet_03v3 L=2U W=0.5U AS=0.14P AD=0.14P PS=1.06U PD=1.06U
M$344 VDD VDD VDD VDD pfet_03v3 L=2U W=0.5U AS=0.14P AD=0.14P PS=1.06U PD=1.06U
M$345 VDD VDD VDD VDD pfet_03v3 L=2U W=0.5U AS=0.14P AD=0.14P PS=1.06U PD=1.06U
M$346 VDD VDD VDD VDD pfet_03v3 L=2U W=0.5U AS=0.14P AD=0.14P PS=1.06U PD=1.06U
M$347 VDD VDD VDD VDD pfet_03v3 L=2U W=0.5U AS=0.14P AD=0.14P PS=1.06U PD=1.06U
M$348 VDD VDD VDD VDD pfet_03v3 L=2U W=0.5U AS=0.14P AD=0.14P PS=1.06U PD=1.06U
M$349 VDD VDD VDD VDD pfet_03v3 L=2U W=0.5U AS=0.14P AD=0.14P PS=1.06U PD=1.06U
M$350 VDD VDD VDD VDD pfet_03v3 L=2U W=0.5U AS=0.14P AD=0.14P PS=1.06U PD=1.06U
M$351 VDD VDD VDD VDD pfet_03v3 L=2U W=0.5U AS=0.14P AD=0.14P PS=1.06U PD=1.06U
M$352 VDD VDD VDD VDD pfet_03v3 L=2U W=0.5U AS=0.14P AD=0.14P PS=1.06U PD=1.06U
M$353 VDD VDD VDD VDD pfet_03v3 L=2U W=0.5U AS=0.14P AD=0.14P PS=1.06U PD=1.06U
M$354 VDD VDD VDD VDD pfet_03v3 L=2U W=0.5U AS=0.14P AD=0.14P PS=1.06U PD=1.06U
M$355 VDD VDD VDD VDD pfet_03v3 L=2U W=0.5U AS=0.14P AD=0.14P PS=1.06U PD=1.06U
M$356 VDD VDD VDD VDD pfet_03v3 L=2U W=0.5U AS=0.14P AD=0.14P PS=1.06U PD=1.06U
M$357 VDD VDD VDD VDD pfet_03v3 L=2U W=0.5U AS=0.14P AD=0.14P PS=1.06U PD=1.06U
M$358 VDD VDD VDD VDD pfet_03v3 L=2U W=0.5U AS=0.14P AD=0.14P PS=1.06U PD=1.06U
M$359 VDD VDD VDD VDD pfet_03v3 L=2U W=0.5U AS=0.14P AD=0.14P PS=1.06U PD=1.06U
M$360 VDD VDD VDD VDD pfet_03v3 L=2U W=0.5U AS=0.14P AD=0.14P PS=1.06U PD=1.06U
M$361 VDD VDD VDD VDD pfet_03v3 L=2U W=0.5U AS=0.14P AD=0.14P PS=1.06U PD=1.06U
M$362 VDD VDD VDD VDD pfet_03v3 L=2U W=0.5U AS=0.14P AD=0.14P PS=1.06U PD=1.06U
M$363 VDD VDD VDD VDD pfet_03v3 L=2U W=0.5U AS=0.14P AD=0.14P PS=1.06U PD=1.06U
M$364 VDD VDD VDD VDD pfet_03v3 L=2U W=0.5U AS=0.14P AD=0.14P PS=1.06U PD=1.06U
M$365 VDD VDD VDD VDD pfet_03v3 L=2U W=0.5U AS=0.14P AD=0.14P PS=1.06U PD=1.06U
M$366 VDD VDD VDD VDD pfet_03v3 L=2U W=0.5U AS=0.14P AD=0.14P PS=1.06U PD=1.06U
M$367 VDD VDD VDD VDD pfet_03v3 L=2U W=0.5U AS=0.14P AD=0.14P PS=1.06U PD=1.06U
M$368 VDD VDD VDD VDD pfet_03v3 L=2U W=0.5U AS=0.14P AD=0.14P PS=1.06U PD=1.06U
M$369 VDD VDD VDD VDD pfet_03v3 L=2U W=0.5U AS=0.14P AD=0.14P PS=1.06U PD=1.06U
M$370 VDD VDD VDD VDD pfet_03v3 L=2U W=0.5U AS=0.14P AD=0.14P PS=1.06U PD=1.06U
M$371 VDD VDD VDD VDD pfet_03v3 L=2U W=0.5U AS=0.14P AD=0.14P PS=1.06U PD=1.06U
M$372 VDD VDD VDD VDD pfet_03v3 L=2U W=0.5U AS=0.14P AD=0.14P PS=1.06U PD=1.06U
M$373 VDD VDD VDD VDD pfet_03v3 L=2U W=0.5U AS=0.3P AD=0.14P PS=2.2U PD=1.06U
M$374 VDD VDD VDD VDD pfet_03v3 L=2U W=0.5U AS=0.14P AD=0.14P PS=1.06U PD=1.06U
M$375 VDD VDD VDD VDD pfet_03v3 L=2U W=0.5U AS=0.14P AD=0.14P PS=1.06U PD=1.06U
M$376 VDD VDD VDD VDD pfet_03v3 L=2U W=0.5U AS=0.14P AD=0.14P PS=1.06U PD=1.06U
M$377 VDD VDD VDD VDD pfet_03v3 L=2U W=0.5U AS=0.14P AD=0.14P PS=1.06U PD=1.06U
M$378 VDD VDD VDD VDD pfet_03v3 L=2U W=0.5U AS=0.14P AD=0.14P PS=1.06U PD=1.06U
M$379 VDD VDD VDD VDD pfet_03v3 L=2U W=0.5U AS=0.14P AD=0.14P PS=1.06U PD=1.06U
M$380 VDD VDD VDD VDD pfet_03v3 L=2U W=0.5U AS=0.14P AD=0.14P PS=1.06U PD=1.06U
M$381 VDD VDD VDD VDD pfet_03v3 L=2U W=0.5U AS=0.14P AD=0.14P PS=1.06U PD=1.06U
M$382 VDD VDD VDD VDD pfet_03v3 L=2U W=0.5U AS=0.14P AD=0.14P PS=1.06U PD=1.06U
M$383 VDD VDD VDD VDD pfet_03v3 L=2U W=0.5U AS=0.14P AD=0.14P PS=1.06U PD=1.06U
M$384 VDD VDD VDD VDD pfet_03v3 L=2U W=0.5U AS=0.14P AD=0.14P PS=1.06U PD=1.06U
M$385 VDD VDD VDD VDD pfet_03v3 L=2U W=0.5U AS=0.14P AD=0.14P PS=1.06U PD=1.06U
M$386 VDD VDD VDD VDD pfet_03v3 L=2U W=0.5U AS=0.14P AD=0.14P PS=1.06U PD=1.06U
M$387 VDD VDD VDD VDD pfet_03v3 L=2U W=0.5U AS=0.14P AD=0.14P PS=1.06U PD=1.06U
M$388 VDD VDD VDD VDD pfet_03v3 L=2U W=0.5U AS=0.14P AD=0.14P PS=1.06U PD=1.06U
M$389 VDD VDD VDD VDD pfet_03v3 L=2U W=0.5U AS=0.14P AD=0.14P PS=1.06U PD=1.06U
M$390 VDD VDD VDD VDD pfet_03v3 L=2U W=0.5U AS=0.14P AD=0.14P PS=1.06U PD=1.06U
M$391 VDD VDD VDD VDD pfet_03v3 L=2U W=0.5U AS=0.14P AD=0.14P PS=1.06U PD=1.06U
M$392 VDD VDD VDD VDD pfet_03v3 L=2U W=0.5U AS=0.14P AD=0.14P PS=1.06U PD=1.06U
M$393 VDD VDD VDD VDD pfet_03v3 L=2U W=0.5U AS=0.14P AD=0.14P PS=1.06U PD=1.06U
M$394 VDD VDD VDD VDD pfet_03v3 L=2U W=0.5U AS=0.14P AD=0.14P PS=1.06U PD=1.06U
M$395 VDD VDD VDD VDD pfet_03v3 L=2U W=0.5U AS=0.14P AD=0.14P PS=1.06U PD=1.06U
M$396 VDD VDD VDD VDD pfet_03v3 L=2U W=0.5U AS=0.14P AD=0.14P PS=1.06U PD=1.06U
M$397 VDD VDD VDD VDD pfet_03v3 L=2U W=0.5U AS=0.14P AD=0.14P PS=1.06U PD=1.06U
M$398 VDD VDD VDD VDD pfet_03v3 L=2U W=0.5U AS=0.14P AD=0.14P PS=1.06U PD=1.06U
M$399 VDD VDD VDD VDD pfet_03v3 L=2U W=0.5U AS=0.14P AD=0.14P PS=1.06U PD=1.06U
M$400 VDD VDD VDD VDD pfet_03v3 L=2U W=0.5U AS=0.14P AD=0.14P PS=1.06U PD=1.06U
M$401 VDD VDD VDD VDD pfet_03v3 L=2U W=0.5U AS=0.14P AD=0.14P PS=1.06U PD=1.06U
M$402 VDD VDD VDD VDD pfet_03v3 L=2U W=0.5U AS=0.14P AD=0.14P PS=1.06U PD=1.06U
M$403 VDD VDD VDD VDD pfet_03v3 L=2U W=0.5U AS=0.14P AD=0.14P PS=1.06U PD=1.06U
M$404 VDD VDD VDD VDD pfet_03v3 L=2U W=0.5U AS=0.14P AD=0.14P PS=1.06U PD=1.06U
M$405 VDD VDD VDD VDD pfet_03v3 L=2U W=0.5U AS=0.14P AD=0.14P PS=1.06U PD=1.06U
M$406 VDD VDD VDD VDD pfet_03v3 L=2U W=0.5U AS=0.14P AD=0.14P PS=1.06U PD=1.06U
M$407 VDD VDD VDD VDD pfet_03v3 L=2U W=0.5U AS=0.14P AD=0.14P PS=1.06U PD=1.06U
M$408 VDD VDD VDD VDD pfet_03v3 L=2U W=0.5U AS=0.14P AD=0.14P PS=1.06U PD=1.06U
M$409 VDD VDD VDD VDD pfet_03v3 L=2U W=0.5U AS=0.14P AD=0.14P PS=1.06U PD=1.06U
M$410 VDD VDD VDD VDD pfet_03v3 L=2U W=0.5U AS=0.14P AD=0.14P PS=1.06U PD=1.06U
M$411 VDD VDD VDD VDD pfet_03v3 L=2U W=0.5U AS=0.14P AD=0.14P PS=1.06U PD=1.06U
M$412 VDD VDD VDD VDD pfet_03v3 L=2U W=0.5U AS=0.14P AD=0.14P PS=1.06U PD=1.06U
M$413 VDD VDD VDD VDD pfet_03v3 L=2U W=0.5U AS=0.14P AD=0.14P PS=1.06U PD=1.06U
M$414 VDD VDD VDD VDD pfet_03v3 L=2U W=0.5U AS=0.14P AD=0.14P PS=1.06U PD=1.06U
M$415 VDD VDD VDD VDD pfet_03v3 L=2U W=0.5U AS=0.14P AD=0.14P PS=1.06U PD=1.06U
M$416 VDD VDD VDD VDD pfet_03v3 L=2U W=0.5U AS=0.14P AD=0.14P PS=1.06U PD=1.06U
M$417 VDD VDD VDD VDD pfet_03v3 L=2U W=0.5U AS=0.14P AD=0.14P PS=1.06U PD=1.06U
M$418 VDD VDD VDD VDD pfet_03v3 L=2U W=0.5U AS=0.14P AD=0.14P PS=1.06U PD=1.06U
M$419 VDD VDD VDD VDD pfet_03v3 L=2U W=0.5U AS=0.14P AD=0.14P PS=1.06U PD=1.06U
M$420 VDD VDD VDD VDD pfet_03v3 L=2U W=0.5U AS=0.14P AD=0.14P PS=1.06U PD=1.06U
M$421 VDD VDD VDD VDD pfet_03v3 L=2U W=0.5U AS=0.14P AD=0.14P PS=1.06U PD=1.06U
M$422 VDD VDD VDD VDD pfet_03v3 L=2U W=0.5U AS=0.14P AD=0.14P PS=1.06U PD=1.06U
M$423 VDD VDD VDD VDD pfet_03v3 L=2U W=0.5U AS=0.14P AD=0.14P PS=1.06U PD=1.06U
M$424 VDD VDD VDD VDD pfet_03v3 L=2U W=0.5U AS=0.14P AD=0.14P PS=1.06U PD=1.06U
M$425 VDD VDD VDD VDD pfet_03v3 L=2U W=0.5U AS=0.14P AD=0.14P PS=1.06U PD=1.06U
M$426 VDD \$65 Vb VDD pfet_03v3 L=8U W=1.44U AS=0.864P AD=0.864P PS=4.08U
+ PD=4.08U
M$427 VDD \$65 VKdn VDD pfet_03v3 L=8U W=12.94U AS=7.764P AD=7.764P PS=27.08U
+ PD=27.08U
M$428 VDD \$65 \$65 VDD pfet_03v3 L=8U W=10U AS=6P AD=6P PS=21.2U PD=21.2U
M$429 VDD \$65 VIp VDD pfet_03v3 L=8U W=2.34U AS=1.404P AD=1.404P PS=5.88U
+ PD=5.88U
M$430 VDD \$65 Vamp_bias VDD pfet_03v3 L=8U W=9.14U AS=5.484P AD=5.484P
+ PS=19.48U PD=19.48U
M$431 VDD \$65 VK VDD pfet_03v3 L=8U W=10.45U AS=6.27P AD=6.27P PS=22.1U
+ PD=22.1U
M$432 VDD \$65 Vlk VDD pfet_03v3 L=16U W=0.84U AS=0.504P AD=0.504P PS=2.88U
+ PD=2.88U
M$433 VDD VNA VNA VDD pfet_03v3 L=45.45U W=0.5U AS=0.3P AD=0.3P PS=2.2U PD=2.2U
M$434 VDD VKup VKup VDD pfet_03v3 L=8U W=1U AS=0.6P AD=0.6P PS=3.2U PD=3.2U
M$435 Vthr Vthr VDD VDD pfet_03v3 L=5.12U W=4U AS=2.4P AD=1.12P PS=9.2U PD=4.56U
M$436 VDD Vthr Vthr VDD pfet_03v3 L=5.12U W=4U AS=1.12P AD=1.12P PS=4.56U
+ PD=4.56U
M$437 Vthr Vthr VDD VDD pfet_03v3 L=5.12U W=4U AS=1.12P AD=1.12P PS=4.56U
+ PD=4.56U
M$438 VDD Vthr Vthr VDD pfet_03v3 L=5.12U W=4U AS=1.12P AD=1.12P PS=4.56U
+ PD=4.56U
M$439 Vthr Vthr VDD VDD pfet_03v3 L=5.12U W=4U AS=1.12P AD=1.12P PS=4.56U
+ PD=4.56U
M$440 VDD Vthr Vthr VDD pfet_03v3 L=5.12U W=4U AS=1.12P AD=1.12P PS=4.56U
+ PD=4.56U
M$441 Vthr Vthr VDD VDD pfet_03v3 L=5.12U W=4U AS=1.12P AD=1.12P PS=4.56U
+ PD=4.56U
M$442 VDD Vthr Vthr VDD pfet_03v3 L=5.12U W=4U AS=1.12P AD=1.12P PS=4.56U
+ PD=4.56U
M$443 Vthr Vthr VDD VDD pfet_03v3 L=5.12U W=4U AS=1.12P AD=1.12P PS=4.56U
+ PD=4.56U
M$444 VDD Vthr Vthr VDD pfet_03v3 L=5.12U W=4U AS=1.12P AD=1.12P PS=4.56U
+ PD=4.56U
M$445 Vthr Vthr VDD VDD pfet_03v3 L=5.12U W=4U AS=1.12P AD=1.12P PS=4.56U
+ PD=4.56U
M$446 VDD Vthr Vthr VDD pfet_03v3 L=5.12U W=4U AS=1.12P AD=1.12P PS=4.56U
+ PD=4.56U
M$447 Vthr Vthr VDD VDD pfet_03v3 L=5.12U W=4U AS=1.12P AD=1.12P PS=4.56U
+ PD=4.56U
M$448 VDD Vthr Vthr VDD pfet_03v3 L=5.12U W=4U AS=1.12P AD=1.12P PS=4.56U
+ PD=4.56U
M$449 Vthr Vthr VDD VDD pfet_03v3 L=5.12U W=4U AS=1.12P AD=1.12P PS=4.56U
+ PD=4.56U
M$450 VDD Vthr Vthr VDD pfet_03v3 L=5.12U W=4U AS=1.12P AD=1.12P PS=4.56U
+ PD=4.56U
M$451 Vthr Vthr VDD VDD pfet_03v3 L=5.12U W=4U AS=1.12P AD=1.12P PS=4.56U
+ PD=4.56U
M$452 VDD Vthr Vthr VDD pfet_03v3 L=5.12U W=4U AS=1.12P AD=1.12P PS=4.56U
+ PD=4.56U
M$453 Vthr Vthr VDD VDD pfet_03v3 L=5.12U W=4U AS=1.12P AD=1.12P PS=4.56U
+ PD=4.56U
M$454 VDD Vthr Vthr VDD pfet_03v3 L=5.12U W=4U AS=1.12P AD=1.12P PS=4.56U
+ PD=4.56U
M$455 Vthr Vthr VDD VDD pfet_03v3 L=5.12U W=4U AS=1.12P AD=1.12P PS=4.56U
+ PD=4.56U
M$456 VDD Vthr Vthr VDD pfet_03v3 L=5.12U W=4U AS=1.12P AD=1.12P PS=4.56U
+ PD=4.56U
M$457 Vthr Vthr VDD VDD pfet_03v3 L=5.12U W=4U AS=1.12P AD=1.12P PS=4.56U
+ PD=4.56U
M$458 VDD Vthr Vthr VDD pfet_03v3 L=5.12U W=4U AS=1.12P AD=1.12P PS=4.56U
+ PD=4.56U
M$459 Vthr Vthr VDD VDD pfet_03v3 L=5.12U W=4U AS=1.12P AD=1.12P PS=4.56U
+ PD=4.56U
M$460 VDD Vthr Vthr VDD pfet_03v3 L=5.12U W=4U AS=1.12P AD=1.12P PS=4.56U
+ PD=4.56U
M$461 Vthr Vthr VDD VDD pfet_03v3 L=5.12U W=4U AS=1.12P AD=1.12P PS=4.56U
+ PD=4.56U
M$462 VDD Vthr Vthr VDD pfet_03v3 L=5.12U W=4U AS=1.12P AD=1.12P PS=4.56U
+ PD=4.56U
M$463 Vthr Vthr VDD VDD pfet_03v3 L=5.12U W=4U AS=1.12P AD=1.12P PS=4.56U
+ PD=4.56U
M$464 VDD Vthr Vthr VDD pfet_03v3 L=5.12U W=4U AS=1.12P AD=1.12P PS=4.56U
+ PD=4.56U
M$465 Vthr Vthr VDD VDD pfet_03v3 L=5.12U W=4U AS=1.12P AD=1.12P PS=4.56U
+ PD=4.56U
M$466 VDD Vthr Vthr VDD pfet_03v3 L=5.12U W=4U AS=1.12P AD=2.4P PS=4.56U PD=9.2U
M$467 VT_dpi VT_dpi VDD VDD pfet_03v3 L=5.12U W=4U AS=2.4P AD=1.12P PS=9.2U
+ PD=4.56U
M$468 VDD VT_dpi VT_dpi VDD pfet_03v3 L=5.12U W=4U AS=1.12P AD=1.12P PS=4.56U
+ PD=4.56U
M$469 VT_dpi VT_dpi VDD VDD pfet_03v3 L=5.12U W=4U AS=1.12P AD=1.12P PS=4.56U
+ PD=4.56U
M$470 VDD VT_dpi VT_dpi VDD pfet_03v3 L=5.12U W=4U AS=1.12P AD=1.12P PS=4.56U
+ PD=4.56U
M$471 VT_dpi VT_dpi VDD VDD pfet_03v3 L=5.12U W=4U AS=1.12P AD=1.12P PS=4.56U
+ PD=4.56U
M$472 VDD VT_dpi VT_dpi VDD pfet_03v3 L=5.12U W=4U AS=1.12P AD=1.12P PS=4.56U
+ PD=4.56U
M$473 VT_dpi VT_dpi VDD VDD pfet_03v3 L=5.12U W=4U AS=1.12P AD=1.12P PS=4.56U
+ PD=4.56U
M$474 VDD VT_dpi VT_dpi VDD pfet_03v3 L=5.12U W=4U AS=1.12P AD=1.12P PS=4.56U
+ PD=4.56U
M$475 VT_dpi VT_dpi VDD VDD pfet_03v3 L=5.12U W=4U AS=1.12P AD=1.12P PS=4.56U
+ PD=4.56U
M$476 VDD VT_dpi VT_dpi VDD pfet_03v3 L=5.12U W=4U AS=1.12P AD=1.12P PS=4.56U
+ PD=4.56U
M$477 VT_dpi VT_dpi VDD VDD pfet_03v3 L=5.12U W=4U AS=1.12P AD=1.12P PS=4.56U
+ PD=4.56U
M$478 VDD VT_dpi VT_dpi VDD pfet_03v3 L=5.12U W=4U AS=1.12P AD=1.12P PS=4.56U
+ PD=4.56U
M$479 VT_dpi VT_dpi VDD VDD pfet_03v3 L=5.12U W=4U AS=1.12P AD=1.12P PS=4.56U
+ PD=4.56U
M$480 VDD VT_dpi VT_dpi VDD pfet_03v3 L=5.12U W=4U AS=1.12P AD=1.12P PS=4.56U
+ PD=4.56U
M$481 VT_dpi VT_dpi VDD VDD pfet_03v3 L=5.12U W=4U AS=1.12P AD=1.12P PS=4.56U
+ PD=4.56U
M$482 VDD VT_dpi VT_dpi VDD pfet_03v3 L=5.12U W=4U AS=1.12P AD=1.12P PS=4.56U
+ PD=4.56U
M$483 VT_dpi VT_dpi VDD VDD pfet_03v3 L=5.12U W=4U AS=1.12P AD=1.12P PS=4.56U
+ PD=4.56U
M$484 VDD VT_dpi VT_dpi VDD pfet_03v3 L=5.12U W=4U AS=1.12P AD=1.12P PS=4.56U
+ PD=4.56U
M$485 VT_dpi VT_dpi VDD VDD pfet_03v3 L=5.12U W=4U AS=1.12P AD=1.12P PS=4.56U
+ PD=4.56U
M$486 VDD VT_dpi VT_dpi VDD pfet_03v3 L=5.12U W=4U AS=1.12P AD=1.12P PS=4.56U
+ PD=4.56U
M$487 VT_dpi VT_dpi VDD VDD pfet_03v3 L=5.12U W=4U AS=1.12P AD=1.12P PS=4.56U
+ PD=4.56U
M$488 VDD VT_dpi VT_dpi VDD pfet_03v3 L=5.12U W=4U AS=1.12P AD=1.12P PS=4.56U
+ PD=4.56U
M$489 VT_dpi VT_dpi VDD VDD pfet_03v3 L=5.12U W=4U AS=1.12P AD=1.12P PS=4.56U
+ PD=4.56U
M$490 VDD VT_dpi VT_dpi VDD pfet_03v3 L=5.12U W=4U AS=1.12P AD=1.12P PS=4.56U
+ PD=4.56U
M$491 VT_dpi VT_dpi VDD VDD pfet_03v3 L=5.12U W=4U AS=1.12P AD=1.12P PS=4.56U
+ PD=4.56U
M$492 VDD VT_dpi VT_dpi VDD pfet_03v3 L=5.12U W=4U AS=1.12P AD=1.12P PS=4.56U
+ PD=4.56U
M$493 VT_dpi VT_dpi VDD VDD pfet_03v3 L=5.12U W=4U AS=1.12P AD=1.12P PS=4.56U
+ PD=4.56U
M$494 VDD VT_dpi VT_dpi VDD pfet_03v3 L=5.12U W=4U AS=1.12P AD=1.12P PS=4.56U
+ PD=4.56U
M$495 VT_dpi VT_dpi VDD VDD pfet_03v3 L=5.12U W=4U AS=1.12P AD=1.12P PS=4.56U
+ PD=4.56U
M$496 VDD VT_dpi VT_dpi VDD pfet_03v3 L=5.12U W=4U AS=1.12P AD=1.12P PS=4.56U
+ PD=4.56U
M$497 VT_dpi VT_dpi VDD VDD pfet_03v3 L=5.12U W=4U AS=1.12P AD=1.12P PS=4.56U
+ PD=4.56U
M$498 VDD VT_dpi VT_dpi VDD pfet_03v3 L=5.12U W=4U AS=1.12P AD=2.4P PS=4.56U
+ PD=9.2U
M$499 VT_inh VT_inh VDD VDD pfet_03v3 L=1.12U W=0.88U AS=0.528P AD=0.2464P
+ PS=2.96U PD=1.44U
M$500 VDD VT_inh VT_inh VDD pfet_03v3 L=1.12U W=0.88U AS=0.2464P AD=0.2464P
+ PS=1.44U PD=1.44U
M$501 VT_inh VT_inh VDD VDD pfet_03v3 L=1.12U W=0.88U AS=0.2464P AD=0.2464P
+ PS=1.44U PD=1.44U
M$502 VDD VT_inh VT_inh VDD pfet_03v3 L=1.12U W=0.88U AS=0.2464P AD=0.2464P
+ PS=1.44U PD=1.44U
M$503 VT_inh VT_inh VDD VDD pfet_03v3 L=1.12U W=0.88U AS=0.2464P AD=0.2464P
+ PS=1.44U PD=1.44U
M$504 VDD VT_inh VT_inh VDD pfet_03v3 L=1.12U W=0.88U AS=0.2464P AD=0.2464P
+ PS=1.44U PD=1.44U
M$505 VT_inh VT_inh VDD VDD pfet_03v3 L=1.12U W=0.88U AS=0.2464P AD=0.2464P
+ PS=1.44U PD=1.44U
M$506 VDD VT_inh VT_inh VDD pfet_03v3 L=1.12U W=0.88U AS=0.2464P AD=0.2464P
+ PS=1.44U PD=1.44U
M$507 VT_inh VT_inh VDD VDD pfet_03v3 L=1.12U W=0.88U AS=0.2464P AD=0.2464P
+ PS=1.44U PD=1.44U
M$508 VDD VT_inh VT_inh VDD pfet_03v3 L=1.12U W=0.88U AS=0.2464P AD=0.2464P
+ PS=1.44U PD=1.44U
M$509 VT_inh VT_inh VDD VDD pfet_03v3 L=1.12U W=0.88U AS=0.2464P AD=0.2464P
+ PS=1.44U PD=1.44U
M$510 VDD VT_inh VT_inh VDD pfet_03v3 L=1.12U W=0.88U AS=0.2464P AD=0.2464P
+ PS=1.44U PD=1.44U
M$511 VT_inh VT_inh VDD VDD pfet_03v3 L=1.12U W=0.88U AS=0.2464P AD=0.2464P
+ PS=1.44U PD=1.44U
M$512 VDD VT_inh VT_inh VDD pfet_03v3 L=1.12U W=0.88U AS=0.2464P AD=0.2464P
+ PS=1.44U PD=1.44U
M$513 VT_inh VT_inh VDD VDD pfet_03v3 L=1.12U W=0.88U AS=0.2464P AD=0.2464P
+ PS=1.44U PD=1.44U
M$514 VDD VT_inh VT_inh VDD pfet_03v3 L=1.12U W=0.88U AS=0.2464P AD=0.528P
+ PS=1.44U PD=2.96U
M$515 VDD VDD VDD VDD pfet_03v3 L=2U W=12.94U AS=7.764P AD=7.764P PS=27.08U
+ PD=27.08U
M$516 VSS VSS VSS VSS nfet_03v3 L=2U W=0.5U AS=0.14P AD=0.14P PS=1.06U PD=1.06U
M$517 VSS VSS VSS VSS nfet_03v3 L=2U W=0.5U AS=0.14P AD=0.14P PS=1.06U PD=1.06U
M$518 VSS VSS VSS VSS nfet_03v3 L=2U W=0.5U AS=0.14P AD=0.14P PS=1.06U PD=1.06U
M$519 VSS VSS VSS VSS nfet_03v3 L=2U W=0.5U AS=0.14P AD=0.14P PS=1.06U PD=1.06U
M$520 VSS VSS VSS VSS nfet_03v3 L=2U W=0.5U AS=0.14P AD=0.14P PS=1.06U PD=1.06U
M$521 VSS VSS VSS VSS nfet_03v3 L=2U W=0.5U AS=0.14P AD=0.14P PS=1.06U PD=1.06U
M$522 VSS VSS VSS VSS nfet_03v3 L=2U W=0.5U AS=0.14P AD=0.14P PS=1.06U PD=1.06U
M$523 VSS VSS VSS VSS nfet_03v3 L=2U W=0.5U AS=0.14P AD=0.14P PS=1.06U PD=1.06U
M$524 VSS VSS VSS VSS nfet_03v3 L=2U W=0.5U AS=0.14P AD=0.14P PS=1.06U PD=1.06U
M$525 VSS VSS VSS VSS nfet_03v3 L=2U W=0.5U AS=0.14P AD=0.14P PS=1.06U PD=1.06U
M$526 VSS VSS VSS VSS nfet_03v3 L=2U W=0.5U AS=0.14P AD=0.14P PS=1.06U PD=1.06U
M$527 VSS VSS VSS VSS nfet_03v3 L=2U W=0.5U AS=0.14P AD=0.14P PS=1.06U PD=1.06U
M$528 VSS VSS VSS VSS nfet_03v3 L=2U W=0.5U AS=0.14P AD=0.14P PS=1.06U PD=1.06U
M$529 VSS VSS VSS VSS nfet_03v3 L=2U W=0.5U AS=0.14P AD=0.14P PS=1.06U PD=1.06U
M$530 VSS VSS VSS VSS nfet_03v3 L=2U W=0.5U AS=0.14P AD=0.14P PS=1.06U PD=1.06U
M$531 VSS VSS VSS VSS nfet_03v3 L=2U W=0.5U AS=0.14P AD=0.14P PS=1.06U PD=1.06U
M$532 VSS VSS VSS VSS nfet_03v3 L=2U W=0.5U AS=0.14P AD=0.14P PS=1.06U PD=1.06U
M$533 VSS VSS VSS VSS nfet_03v3 L=2U W=0.5U AS=0.14P AD=0.14P PS=1.06U PD=1.06U
M$534 VSS VSS VSS VSS nfet_03v3 L=2U W=0.5U AS=0.14P AD=0.14P PS=1.06U PD=1.06U
M$535 VSS VSS VSS VSS nfet_03v3 L=2U W=0.5U AS=0.14P AD=0.14P PS=1.06U PD=1.06U
M$536 VSS VSS VSS VSS nfet_03v3 L=2U W=0.5U AS=0.14P AD=0.14P PS=1.06U PD=1.06U
M$537 VSS VSS VSS VSS nfet_03v3 L=2U W=0.5U AS=0.14P AD=0.14P PS=1.06U PD=1.06U
M$538 VSS VSS VSS VSS nfet_03v3 L=2U W=0.5U AS=0.14P AD=0.14P PS=1.06U PD=1.06U
M$539 VSS VSS VSS VSS nfet_03v3 L=2U W=0.5U AS=0.14P AD=0.14P PS=1.06U PD=1.06U
M$540 VSS VSS VSS VSS nfet_03v3 L=2U W=0.5U AS=0.14P AD=0.14P PS=1.06U PD=1.06U
M$541 VSS VSS VSS VSS nfet_03v3 L=2U W=0.5U AS=0.14P AD=0.14P PS=1.06U PD=1.06U
M$542 VSS VSS VSS VSS nfet_03v3 L=2U W=0.5U AS=0.14P AD=0.14P PS=1.06U PD=1.06U
M$543 VSS VSS VSS VSS nfet_03v3 L=2U W=0.5U AS=0.14P AD=0.14P PS=1.06U PD=1.06U
M$544 VSS VSS VSS VSS nfet_03v3 L=2U W=0.5U AS=0.14P AD=0.14P PS=1.06U PD=1.06U
M$545 VSS VSS VSS VSS nfet_03v3 L=2U W=0.5U AS=0.14P AD=0.14P PS=1.06U PD=1.06U
M$546 VSS VSS VSS VSS nfet_03v3 L=2U W=0.5U AS=0.14P AD=0.14P PS=1.06U PD=1.06U
M$547 VSS VSS VSS VSS nfet_03v3 L=2U W=0.5U AS=0.14P AD=0.14P PS=1.06U PD=1.06U
M$548 VSS VSS VSS VSS nfet_03v3 L=2U W=0.5U AS=0.14P AD=0.14P PS=1.06U PD=1.06U
M$549 VSS VSS VSS VSS nfet_03v3 L=2U W=0.5U AS=0.14P AD=0.14P PS=1.06U PD=1.06U
M$550 VSS VSS VSS VSS nfet_03v3 L=2U W=0.5U AS=0.14P AD=0.14P PS=1.06U PD=1.06U
M$551 VSS VSS VSS VSS nfet_03v3 L=2U W=0.5U AS=0.14P AD=0.14P PS=1.06U PD=1.06U
M$552 VSS VSS VSS VSS nfet_03v3 L=2U W=0.5U AS=0.14P AD=0.14P PS=1.06U PD=1.06U
M$553 VSS VSS VSS VSS nfet_03v3 L=2U W=0.5U AS=0.14P AD=0.14P PS=1.06U PD=1.06U
M$554 VSS VSS VSS VSS nfet_03v3 L=2U W=0.5U AS=0.14P AD=0.14P PS=1.06U PD=1.06U
M$555 VSS VSS VSS VSS nfet_03v3 L=2U W=0.5U AS=0.14P AD=0.14P PS=1.06U PD=1.06U
M$556 VSS VSS VSS VSS nfet_03v3 L=2U W=0.5U AS=0.14P AD=0.14P PS=1.06U PD=1.06U
M$557 VSS VSS VSS VSS nfet_03v3 L=2U W=0.5U AS=0.14P AD=0.14P PS=1.06U PD=1.06U
M$558 VSS VSS VSS VSS nfet_03v3 L=2U W=0.5U AS=0.14P AD=0.14P PS=1.06U PD=1.06U
M$559 VSS VSS VSS VSS nfet_03v3 L=2U W=0.5U AS=0.14P AD=0.14P PS=1.06U PD=1.06U
M$560 VSS VSS VSS VSS nfet_03v3 L=2U W=0.5U AS=0.14P AD=0.14P PS=1.06U PD=1.06U
M$561 VSS VSS VSS VSS nfet_03v3 L=2U W=0.5U AS=0.14P AD=0.14P PS=1.06U PD=1.06U
M$562 VSS VSS VSS VSS nfet_03v3 L=2U W=0.5U AS=0.14P AD=0.14P PS=1.06U PD=1.06U
M$563 VSS VSS VSS VSS nfet_03v3 L=2U W=0.5U AS=0.14P AD=0.14P PS=1.06U PD=1.06U
M$564 VSS VSS VSS VSS nfet_03v3 L=2U W=0.5U AS=0.14P AD=0.14P PS=1.06U PD=1.06U
M$565 VSS VSS VSS VSS nfet_03v3 L=2U W=0.5U AS=0.14P AD=0.14P PS=1.06U PD=1.06U
M$566 VSS VSS VSS VSS nfet_03v3 L=2U W=0.5U AS=0.14P AD=0.14P PS=1.06U PD=1.06U
M$567 VSS VSS VSS VSS nfet_03v3 L=2U W=0.5U AS=0.14P AD=0.14P PS=1.06U PD=1.06U
M$568 VSS VSS VSS VSS nfet_03v3 L=2U W=0.5U AS=0.14P AD=0.14P PS=1.06U PD=1.06U
M$569 VSS VSS VSS VSS nfet_03v3 L=2U W=0.5U AS=0.14P AD=0.14P PS=1.06U PD=1.06U
M$570 VSS VSS VSS VSS nfet_03v3 L=2U W=0.5U AS=0.14P AD=0.14P PS=1.06U PD=1.06U
M$571 VSS VSS VSS VSS nfet_03v3 L=2U W=0.5U AS=0.14P AD=0.14P PS=1.06U PD=1.06U
M$572 VSS VSS VSS VSS nfet_03v3 L=2U W=0.5U AS=0.14P AD=0.14P PS=1.06U PD=1.06U
M$573 VSS VSS VSS VSS nfet_03v3 L=2U W=0.5U AS=0.14P AD=0.3P PS=1.06U PD=2.2U
M$574 VSS VSS VSS VSS nfet_03v3 L=2U W=0.5U AS=0.3P AD=0.14P PS=2.2U PD=1.06U
M$575 VSS VSS VSS VSS nfet_03v3 L=2U W=0.5U AS=0.14P AD=0.14P PS=1.06U PD=1.06U
M$576 VSS VSS VSS VSS nfet_03v3 L=2U W=0.5U AS=0.14P AD=0.14P PS=1.06U PD=1.06U
M$577 VSS VSS VSS VSS nfet_03v3 L=2U W=0.5U AS=0.14P AD=0.14P PS=1.06U PD=1.06U
M$578 VSS VSS VSS VSS nfet_03v3 L=2U W=0.5U AS=0.14P AD=0.14P PS=1.06U PD=1.06U
M$579 VSS VSS VSS VSS nfet_03v3 L=2U W=0.5U AS=0.14P AD=0.14P PS=1.06U PD=1.06U
M$580 VSS VSS VSS VSS nfet_03v3 L=2U W=0.5U AS=0.14P AD=0.14P PS=1.06U PD=1.06U
M$581 VSS VSS VSS VSS nfet_03v3 L=2U W=0.5U AS=0.14P AD=0.14P PS=1.06U PD=1.06U
M$582 VSS VSS VSS VSS nfet_03v3 L=2U W=0.5U AS=0.14P AD=0.14P PS=1.06U PD=1.06U
M$583 VSS VSS VSS VSS nfet_03v3 L=2U W=0.5U AS=0.14P AD=0.14P PS=1.06U PD=1.06U
M$584 VSS VSS VSS VSS nfet_03v3 L=2U W=0.5U AS=0.14P AD=0.14P PS=1.06U PD=1.06U
M$585 VSS VSS VSS VSS nfet_03v3 L=2U W=0.5U AS=0.14P AD=0.14P PS=1.06U PD=1.06U
M$586 VSS VSS VSS VSS nfet_03v3 L=2U W=0.5U AS=0.14P AD=0.14P PS=1.06U PD=1.06U
M$587 VSS VSS VSS VSS nfet_03v3 L=2U W=0.5U AS=0.14P AD=0.14P PS=1.06U PD=1.06U
M$588 VSS VSS VSS VSS nfet_03v3 L=2U W=0.5U AS=0.14P AD=0.14P PS=1.06U PD=1.06U
M$589 VSS VSS VSS VSS nfet_03v3 L=2U W=0.5U AS=0.14P AD=0.14P PS=1.06U PD=1.06U
M$590 VSS VSS VSS VSS nfet_03v3 L=2U W=0.5U AS=0.14P AD=0.14P PS=1.06U PD=1.06U
M$591 VSS VSS VSS VSS nfet_03v3 L=2U W=0.5U AS=0.14P AD=0.14P PS=1.06U PD=1.06U
M$592 VSS VSS VSS VSS nfet_03v3 L=2U W=0.5U AS=0.14P AD=0.14P PS=1.06U PD=1.06U
M$593 VSS VSS VSS VSS nfet_03v3 L=2U W=0.5U AS=0.14P AD=0.14P PS=1.06U PD=1.06U
M$594 VSS VSS VSS VSS nfet_03v3 L=2U W=0.5U AS=0.14P AD=0.14P PS=1.06U PD=1.06U
M$595 VSS VSS VSS VSS nfet_03v3 L=2U W=0.5U AS=0.14P AD=0.14P PS=1.06U PD=1.06U
M$596 VSS VSS VSS VSS nfet_03v3 L=2U W=0.5U AS=0.14P AD=0.14P PS=1.06U PD=1.06U
M$597 VSS VSS VSS VSS nfet_03v3 L=2U W=0.5U AS=0.14P AD=0.14P PS=1.06U PD=1.06U
M$598 VSS VSS VSS VSS nfet_03v3 L=2U W=0.5U AS=0.14P AD=0.14P PS=1.06U PD=1.06U
M$599 VSS VSS VSS VSS nfet_03v3 L=2U W=0.5U AS=0.14P AD=0.14P PS=1.06U PD=1.06U
M$600 VSS VSS VSS VSS nfet_03v3 L=2U W=0.5U AS=0.14P AD=0.14P PS=1.06U PD=1.06U
M$601 VSS VSS VSS VSS nfet_03v3 L=2U W=0.5U AS=0.14P AD=0.14P PS=1.06U PD=1.06U
M$602 VSS VSS VSS VSS nfet_03v3 L=2U W=0.5U AS=0.14P AD=0.14P PS=1.06U PD=1.06U
M$603 VSS VSS VSS VSS nfet_03v3 L=2U W=0.5U AS=0.14P AD=0.14P PS=1.06U PD=1.06U
M$604 VSS VSS VSS VSS nfet_03v3 L=2U W=0.5U AS=0.14P AD=0.14P PS=1.06U PD=1.06U
M$605 VSS VSS VSS VSS nfet_03v3 L=2U W=0.5U AS=0.14P AD=0.14P PS=1.06U PD=1.06U
M$606 VSS VSS VSS VSS nfet_03v3 L=2U W=0.5U AS=0.14P AD=0.14P PS=1.06U PD=1.06U
M$607 VSS VSS VSS VSS nfet_03v3 L=2U W=0.5U AS=0.14P AD=0.14P PS=1.06U PD=1.06U
M$608 VSS VSS VSS VSS nfet_03v3 L=2U W=0.5U AS=0.14P AD=0.14P PS=1.06U PD=1.06U
M$609 VSS VSS VSS VSS nfet_03v3 L=2U W=0.5U AS=0.14P AD=0.14P PS=1.06U PD=1.06U
M$610 VSS VSS VSS VSS nfet_03v3 L=2U W=0.5U AS=0.14P AD=0.14P PS=1.06U PD=1.06U
M$611 VSS VSS VSS VSS nfet_03v3 L=2U W=0.5U AS=0.14P AD=0.14P PS=1.06U PD=1.06U
M$612 VSS VSS VSS VSS nfet_03v3 L=2U W=0.5U AS=0.14P AD=0.14P PS=1.06U PD=1.06U
M$613 VSS VSS VSS VSS nfet_03v3 L=2U W=0.5U AS=0.14P AD=0.14P PS=1.06U PD=1.06U
M$614 VSS VSS VSS VSS nfet_03v3 L=2U W=0.5U AS=0.14P AD=0.14P PS=1.06U PD=1.06U
M$615 VSS VSS VSS VSS nfet_03v3 L=2U W=0.5U AS=0.14P AD=0.14P PS=1.06U PD=1.06U
M$616 VSS VSS VSS VSS nfet_03v3 L=2U W=0.5U AS=0.14P AD=0.14P PS=1.06U PD=1.06U
M$617 VSS VSS VSS VSS nfet_03v3 L=2U W=0.5U AS=0.14P AD=0.14P PS=1.06U PD=1.06U
M$618 VSS VSS VSS VSS nfet_03v3 L=2U W=0.5U AS=0.14P AD=0.14P PS=1.06U PD=1.06U
M$619 VSS VSS VSS VSS nfet_03v3 L=2U W=0.5U AS=0.14P AD=0.14P PS=1.06U PD=1.06U
M$620 VSS VSS VSS VSS nfet_03v3 L=2U W=0.5U AS=0.14P AD=0.14P PS=1.06U PD=1.06U
M$621 VSS VSS VSS VSS nfet_03v3 L=2U W=0.5U AS=0.14P AD=0.14P PS=1.06U PD=1.06U
M$622 VSS VSS VSS VSS nfet_03v3 L=2U W=0.5U AS=0.14P AD=0.14P PS=1.06U PD=1.06U
M$623 VSS VSS VSS VSS nfet_03v3 L=2U W=0.5U AS=0.14P AD=0.14P PS=1.06U PD=1.06U
M$624 VSS VSS VSS VSS nfet_03v3 L=2U W=0.5U AS=0.14P AD=0.14P PS=1.06U PD=1.06U
M$625 VSS VSS VSS VSS nfet_03v3 L=2U W=0.5U AS=0.14P AD=0.14P PS=1.06U PD=1.06U
M$626 VSS VSS VSS VSS nfet_03v3 L=2U W=0.5U AS=0.14P AD=0.14P PS=1.06U PD=1.06U
M$627 VSS VSS VSS VSS nfet_03v3 L=2U W=0.5U AS=0.14P AD=0.14P PS=1.06U PD=1.06U
M$628 VSS VSS VSS VSS nfet_03v3 L=2U W=0.5U AS=0.14P AD=0.14P PS=1.06U PD=1.06U
M$629 VSS VSS VSS VSS nfet_03v3 L=2U W=0.5U AS=0.14P AD=0.14P PS=1.06U PD=1.06U
M$630 VSS VSS VSS VSS nfet_03v3 L=2U W=0.5U AS=0.14P AD=0.14P PS=1.06U PD=1.06U
M$631 VSS VSS VSS VSS nfet_03v3 L=2U W=0.5U AS=0.14P AD=0.14P PS=1.06U PD=1.06U
M$632 VSS VSS VSS VSS nfet_03v3 L=2U W=10U AS=6P AD=6P PS=21.2U PD=21.2U
M$633 VSS VSS VSS VSS nfet_03v3 L=2U W=0.5U AS=0.14P AD=0.14P PS=1.06U PD=1.06U
M$634 VSS VSS VSS VSS nfet_03v3 L=2U W=0.5U AS=0.14P AD=0.14P PS=1.06U PD=1.06U
M$635 VSS VSS VSS VSS nfet_03v3 L=2U W=0.5U AS=0.14P AD=0.14P PS=1.06U PD=1.06U
M$636 VSS VSS VSS VSS nfet_03v3 L=2U W=0.5U AS=0.14P AD=0.14P PS=1.06U PD=1.06U
M$637 VSS VSS VSS VSS nfet_03v3 L=2U W=0.5U AS=0.14P AD=0.14P PS=1.06U PD=1.06U
M$638 VSS VSS VSS VSS nfet_03v3 L=2U W=0.5U AS=0.14P AD=0.14P PS=1.06U PD=1.06U
M$639 VSS VSS VSS VSS nfet_03v3 L=2U W=0.5U AS=0.14P AD=0.14P PS=1.06U PD=1.06U
M$640 VSS VSS VSS VSS nfet_03v3 L=2U W=0.5U AS=0.14P AD=0.14P PS=1.06U PD=1.06U
M$641 VSS VSS VSS VSS nfet_03v3 L=2U W=0.5U AS=0.14P AD=0.14P PS=1.06U PD=1.06U
M$642 VSS VSS VSS VSS nfet_03v3 L=2U W=0.5U AS=0.14P AD=0.14P PS=1.06U PD=1.06U
M$643 VSS VSS VSS VSS nfet_03v3 L=2U W=0.5U AS=0.14P AD=0.14P PS=1.06U PD=1.06U
M$644 VSS VSS VSS VSS nfet_03v3 L=2U W=0.5U AS=0.14P AD=0.14P PS=1.06U PD=1.06U
M$645 VSS VSS VSS VSS nfet_03v3 L=2U W=0.5U AS=0.14P AD=0.14P PS=1.06U PD=1.06U
M$646 VSS VSS VSS VSS nfet_03v3 L=2U W=0.5U AS=0.14P AD=0.14P PS=1.06U PD=1.06U
M$647 VSS VSS VSS VSS nfet_03v3 L=2U W=0.5U AS=0.14P AD=0.14P PS=1.06U PD=1.06U
M$648 VSS VSS VSS VSS nfet_03v3 L=2U W=0.5U AS=0.14P AD=0.14P PS=1.06U PD=1.06U
M$649 VSS VSS VSS VSS nfet_03v3 L=2U W=0.5U AS=0.14P AD=0.14P PS=1.06U PD=1.06U
M$650 VSS VSS VSS VSS nfet_03v3 L=2U W=0.5U AS=0.14P AD=0.14P PS=1.06U PD=1.06U
M$651 VSS VSS VSS VSS nfet_03v3 L=2U W=0.5U AS=0.14P AD=0.14P PS=1.06U PD=1.06U
M$652 VSS VSS VSS VSS nfet_03v3 L=2U W=0.5U AS=0.14P AD=0.14P PS=1.06U PD=1.06U
M$653 VSS VSS VSS VSS nfet_03v3 L=2U W=0.5U AS=0.14P AD=0.14P PS=1.06U PD=1.06U
M$654 VSS VSS VSS VSS nfet_03v3 L=2U W=0.5U AS=0.14P AD=0.14P PS=1.06U PD=1.06U
M$655 VSS VSS VSS VSS nfet_03v3 L=2U W=0.5U AS=0.14P AD=0.14P PS=1.06U PD=1.06U
M$656 VSS VSS VSS VSS nfet_03v3 L=2U W=0.5U AS=0.14P AD=0.14P PS=1.06U PD=1.06U
M$657 VSS VSS VSS VSS nfet_03v3 L=2U W=0.5U AS=0.14P AD=0.14P PS=1.06U PD=1.06U
M$658 VSS VSS VSS VSS nfet_03v3 L=2U W=0.5U AS=0.14P AD=0.14P PS=1.06U PD=1.06U
M$659 VSS VSS VSS VSS nfet_03v3 L=2U W=0.5U AS=0.14P AD=0.14P PS=1.06U PD=1.06U
M$660 VSS VSS VSS VSS nfet_03v3 L=2U W=0.5U AS=0.14P AD=0.14P PS=1.06U PD=1.06U
M$661 VSS VSS VSS VSS nfet_03v3 L=2U W=0.5U AS=0.14P AD=0.14P PS=1.06U PD=1.06U
M$662 VSS VSS VSS VSS nfet_03v3 L=2U W=0.5U AS=0.14P AD=0.14P PS=1.06U PD=1.06U
M$663 VSS VSS VSS VSS nfet_03v3 L=2U W=0.5U AS=0.14P AD=0.14P PS=1.06U PD=1.06U
M$664 VSS VSS VSS VSS nfet_03v3 L=2U W=0.5U AS=0.14P AD=0.14P PS=1.06U PD=1.06U
M$665 VSS VSS VSS VSS nfet_03v3 L=2U W=0.5U AS=0.14P AD=0.14P PS=1.06U PD=1.06U
M$666 VSS VSS VSS VSS nfet_03v3 L=2U W=0.5U AS=0.14P AD=0.14P PS=1.06U PD=1.06U
M$667 VSS VSS VSS VSS nfet_03v3 L=2U W=0.5U AS=0.14P AD=0.14P PS=1.06U PD=1.06U
M$668 VSS VSS VSS VSS nfet_03v3 L=2U W=0.5U AS=0.14P AD=0.14P PS=1.06U PD=1.06U
M$669 VSS VSS VSS VSS nfet_03v3 L=2U W=0.5U AS=0.14P AD=0.14P PS=1.06U PD=1.06U
M$670 VSS VSS VSS VSS nfet_03v3 L=2U W=0.5U AS=0.14P AD=0.14P PS=1.06U PD=1.06U
M$671 VSS VSS VSS VSS nfet_03v3 L=2U W=0.5U AS=0.14P AD=0.14P PS=1.06U PD=1.06U
M$672 VSS VSS VSS VSS nfet_03v3 L=2U W=0.5U AS=0.14P AD=0.14P PS=1.06U PD=1.06U
M$673 VSS VSS VSS VSS nfet_03v3 L=2U W=0.5U AS=0.14P AD=0.14P PS=1.06U PD=1.06U
M$674 VSS VSS VSS VSS nfet_03v3 L=2U W=0.5U AS=0.14P AD=0.14P PS=1.06U PD=1.06U
M$675 VSS VSS VSS VSS nfet_03v3 L=2U W=0.5U AS=0.14P AD=0.14P PS=1.06U PD=1.06U
M$676 VSS VSS VSS VSS nfet_03v3 L=2U W=0.5U AS=0.14P AD=0.14P PS=1.06U PD=1.06U
M$677 VSS VSS VSS VSS nfet_03v3 L=2U W=0.5U AS=0.14P AD=0.14P PS=1.06U PD=1.06U
M$678 VSS VSS VSS VSS nfet_03v3 L=2U W=0.5U AS=0.14P AD=0.14P PS=1.06U PD=1.06U
M$679 VSS VSS VSS VSS nfet_03v3 L=2U W=0.5U AS=0.14P AD=0.14P PS=1.06U PD=1.06U
M$680 VSS VSS VSS VSS nfet_03v3 L=2U W=0.5U AS=0.14P AD=0.14P PS=1.06U PD=1.06U
M$681 VSS VSS VSS VSS nfet_03v3 L=2U W=0.5U AS=0.14P AD=0.14P PS=1.06U PD=1.06U
M$682 VSS VSS VSS VSS nfet_03v3 L=2U W=0.5U AS=0.14P AD=0.14P PS=1.06U PD=1.06U
M$683 VSS VSS VSS VSS nfet_03v3 L=2U W=0.5U AS=0.14P AD=0.14P PS=1.06U PD=1.06U
M$684 VSS VSS VSS VSS nfet_03v3 L=2U W=0.5U AS=0.14P AD=0.14P PS=1.06U PD=1.06U
M$685 VSS VSS VSS VSS nfet_03v3 L=2U W=0.5U AS=0.14P AD=0.14P PS=1.06U PD=1.06U
M$686 VSS VSS VSS VSS nfet_03v3 L=2U W=0.5U AS=0.14P AD=0.14P PS=1.06U PD=1.06U
M$687 VSS VSS VSS VSS nfet_03v3 L=2U W=0.5U AS=0.14P AD=0.14P PS=1.06U PD=1.06U
M$688 VSS VSS VSS VSS nfet_03v3 L=2U W=0.5U AS=0.14P AD=0.14P PS=1.06U PD=1.06U
M$689 VSS VSS VSS VSS nfet_03v3 L=2U W=0.5U AS=0.14P AD=0.14P PS=1.06U PD=1.06U
M$690 VSS VSS VSS VSS nfet_03v3 L=2U W=0.5U AS=0.14P AD=0.3P PS=1.06U PD=2.2U
M$691 VSS VSS VSS VSS nfet_03v3 L=2U W=0.5U AS=0.3P AD=0.14P PS=2.2U PD=1.06U
M$692 VSS VSS VSS VSS nfet_03v3 L=2U W=0.5U AS=0.14P AD=0.14P PS=1.06U PD=1.06U
M$693 VSS VSS VSS VSS nfet_03v3 L=2U W=0.5U AS=0.14P AD=0.14P PS=1.06U PD=1.06U
M$694 VSS VSS VSS VSS nfet_03v3 L=2U W=0.5U AS=0.14P AD=0.14P PS=1.06U PD=1.06U
M$695 VSS VSS VSS VSS nfet_03v3 L=2U W=0.5U AS=0.14P AD=0.14P PS=1.06U PD=1.06U
M$696 VSS VSS VSS VSS nfet_03v3 L=2U W=0.5U AS=0.14P AD=0.14P PS=1.06U PD=1.06U
M$697 VSS VSS VSS VSS nfet_03v3 L=2U W=0.5U AS=0.14P AD=0.14P PS=1.06U PD=1.06U
M$698 VSS VSS VSS VSS nfet_03v3 L=2U W=0.5U AS=0.14P AD=0.14P PS=1.06U PD=1.06U
M$699 VSS VSS VSS VSS nfet_03v3 L=2U W=0.5U AS=0.14P AD=0.14P PS=1.06U PD=1.06U
M$700 VSS VSS VSS VSS nfet_03v3 L=2U W=0.5U AS=0.14P AD=0.14P PS=1.06U PD=1.06U
M$701 VSS VSS VSS VSS nfet_03v3 L=2U W=0.5U AS=0.14P AD=0.14P PS=1.06U PD=1.06U
M$702 VSS VSS VSS VSS nfet_03v3 L=2U W=0.5U AS=0.14P AD=0.14P PS=1.06U PD=1.06U
M$703 VSS VSS VSS VSS nfet_03v3 L=2U W=0.5U AS=0.14P AD=0.14P PS=1.06U PD=1.06U
M$704 VSS VSS VSS VSS nfet_03v3 L=2U W=0.5U AS=0.14P AD=0.14P PS=1.06U PD=1.06U
M$705 VSS VSS VSS VSS nfet_03v3 L=2U W=0.5U AS=0.14P AD=0.14P PS=1.06U PD=1.06U
M$706 VSS VSS VSS VSS nfet_03v3 L=2U W=0.5U AS=0.14P AD=0.14P PS=1.06U PD=1.06U
M$707 VSS VSS VSS VSS nfet_03v3 L=2U W=0.5U AS=0.14P AD=0.14P PS=1.06U PD=1.06U
M$708 VSS VSS VSS VSS nfet_03v3 L=2U W=0.5U AS=0.14P AD=0.14P PS=1.06U PD=1.06U
M$709 VSS VSS VSS VSS nfet_03v3 L=2U W=0.5U AS=0.14P AD=0.14P PS=1.06U PD=1.06U
M$710 VSS VSS VSS VSS nfet_03v3 L=2U W=0.5U AS=0.14P AD=0.14P PS=1.06U PD=1.06U
M$711 VSS VSS VSS VSS nfet_03v3 L=2U W=0.5U AS=0.14P AD=0.14P PS=1.06U PD=1.06U
M$712 VSS VSS VSS VSS nfet_03v3 L=2U W=0.5U AS=0.14P AD=0.14P PS=1.06U PD=1.06U
M$713 VSS VSS VSS VSS nfet_03v3 L=2U W=0.5U AS=0.14P AD=0.14P PS=1.06U PD=1.06U
M$714 VSS VSS VSS VSS nfet_03v3 L=2U W=0.5U AS=0.14P AD=0.14P PS=1.06U PD=1.06U
M$715 VSS VSS VSS VSS nfet_03v3 L=2U W=0.5U AS=0.14P AD=0.14P PS=1.06U PD=1.06U
M$716 VSS VSS VSS VSS nfet_03v3 L=2U W=0.5U AS=0.14P AD=0.14P PS=1.06U PD=1.06U
M$717 VSS VSS VSS VSS nfet_03v3 L=2U W=0.5U AS=0.14P AD=0.14P PS=1.06U PD=1.06U
M$718 VSS VSS VSS VSS nfet_03v3 L=2U W=0.5U AS=0.14P AD=0.14P PS=1.06U PD=1.06U
M$719 VSS VSS VSS VSS nfet_03v3 L=2U W=0.5U AS=0.14P AD=0.14P PS=1.06U PD=1.06U
M$720 VSS VSS VSS VSS nfet_03v3 L=2U W=0.5U AS=0.14P AD=0.14P PS=1.06U PD=1.06U
M$721 VSS VSS VSS VSS nfet_03v3 L=2U W=0.5U AS=0.14P AD=0.14P PS=1.06U PD=1.06U
M$722 VSS VSS VSS VSS nfet_03v3 L=2U W=0.5U AS=0.14P AD=0.14P PS=1.06U PD=1.06U
M$723 VSS VSS VSS VSS nfet_03v3 L=2U W=0.5U AS=0.14P AD=0.14P PS=1.06U PD=1.06U
M$724 VSS VSS VSS VSS nfet_03v3 L=2U W=0.5U AS=0.14P AD=0.14P PS=1.06U PD=1.06U
M$725 VSS VSS VSS VSS nfet_03v3 L=2U W=0.5U AS=0.14P AD=0.14P PS=1.06U PD=1.06U
M$726 VSS VSS VSS VSS nfet_03v3 L=2U W=0.5U AS=0.14P AD=0.14P PS=1.06U PD=1.06U
M$727 VSS VSS VSS VSS nfet_03v3 L=2U W=0.5U AS=0.14P AD=0.14P PS=1.06U PD=1.06U
M$728 VSS VSS VSS VSS nfet_03v3 L=2U W=0.5U AS=0.14P AD=0.14P PS=1.06U PD=1.06U
M$729 VSS VSS VSS VSS nfet_03v3 L=2U W=0.5U AS=0.14P AD=0.14P PS=1.06U PD=1.06U
M$730 VSS VSS VSS VSS nfet_03v3 L=2U W=0.5U AS=0.14P AD=0.14P PS=1.06U PD=1.06U
M$731 VSS VSS VSS VSS nfet_03v3 L=2U W=0.5U AS=0.14P AD=0.14P PS=1.06U PD=1.06U
M$732 VSS VSS VSS VSS nfet_03v3 L=2U W=0.5U AS=0.14P AD=0.14P PS=1.06U PD=1.06U
M$733 VSS VSS VSS VSS nfet_03v3 L=2U W=0.5U AS=0.14P AD=0.14P PS=1.06U PD=1.06U
M$734 VSS VSS VSS VSS nfet_03v3 L=2U W=0.5U AS=0.14P AD=0.14P PS=1.06U PD=1.06U
M$735 VSS VSS VSS VSS nfet_03v3 L=2U W=0.5U AS=0.14P AD=0.14P PS=1.06U PD=1.06U
M$736 VSS VSS VSS VSS nfet_03v3 L=2U W=0.5U AS=0.14P AD=0.14P PS=1.06U PD=1.06U
M$737 VSS VSS VSS VSS nfet_03v3 L=2U W=0.5U AS=0.14P AD=0.14P PS=1.06U PD=1.06U
M$738 VSS VSS VSS VSS nfet_03v3 L=2U W=0.5U AS=0.14P AD=0.14P PS=1.06U PD=1.06U
M$739 VSS VSS VSS VSS nfet_03v3 L=2U W=0.5U AS=0.14P AD=0.14P PS=1.06U PD=1.06U
M$740 VSS VSS VSS VSS nfet_03v3 L=2U W=0.5U AS=0.14P AD=0.14P PS=1.06U PD=1.06U
M$741 VSS VSS VSS VSS nfet_03v3 L=2U W=0.5U AS=0.14P AD=0.14P PS=1.06U PD=1.06U
M$742 VSS VSS VSS VSS nfet_03v3 L=2U W=0.5U AS=0.14P AD=0.14P PS=1.06U PD=1.06U
M$743 VSS VSS VSS VSS nfet_03v3 L=2U W=0.5U AS=0.14P AD=0.14P PS=1.06U PD=1.06U
M$744 VSS VSS VSS VSS nfet_03v3 L=2U W=0.5U AS=0.14P AD=0.14P PS=1.06U PD=1.06U
M$745 VSS VSS VSS VSS nfet_03v3 L=2U W=0.5U AS=0.14P AD=0.14P PS=1.06U PD=1.06U
M$746 VSS VSS VSS VSS nfet_03v3 L=2U W=0.5U AS=0.14P AD=0.14P PS=1.06U PD=1.06U
M$747 VSS VSS VSS VSS nfet_03v3 L=2U W=0.5U AS=0.14P AD=0.14P PS=1.06U PD=1.06U
M$748 VSS VSS VSS VSS nfet_03v3 L=2U W=0.5U AS=0.14P AD=0.14P PS=1.06U PD=1.06U
M$749 \$65 Iref VSS VSS nfet_03v3 L=8U W=10U AS=6P AD=6P PS=21.2U PD=21.2U
M$750 VNA Iref VSS VSS nfet_03v3 L=8U W=5.76U AS=3.456P AD=3.456P PS=12.72U
+ PD=12.72U
M$751 Iref Iref VSS VSS nfet_03v3 L=8U W=10U AS=6P AD=6P PS=21.2U PD=21.2U
M$752 VKup Iref VSS VSS nfet_03v3 L=8U W=6.01U AS=3.606P AD=3.606P PS=13.22U
+ PD=13.22U
M$753 Imon Iref VSS VSS nfet_03v3 L=8U W=10U AS=6P AD=6P PS=21.2U PD=21.2U
M$754 Vthr Iref VSS VSS nfet_03v3 L=32U W=0.91U AS=0.546P AD=0.546P PS=3.02U
+ PD=3.02U
M$755 VT_dpi Iref VSS VSS nfet_03v3 L=32U W=1.17U AS=0.702P AD=0.702P PS=3.54U
+ PD=3.54U
M$756 VT_inh Iref VSS VSS nfet_03v3 L=32U W=0.63U AS=0.378P AD=0.378P PS=2.46U
+ PD=2.46U
M$757 Vb Vb VSS VSS nfet_03v3 L=8U W=1U AS=0.6P AD=0.6P PS=3.2U PD=3.2U
M$758 Vlk Vlk VSS VSS nfet_03v3 L=1U W=1U AS=0.6P AD=0.28P PS=3.2U PD=1.56U
M$759 VSS Vlk Vlk VSS nfet_03v3 L=1U W=1U AS=0.28P AD=0.28P PS=1.56U PD=1.56U
M$760 Vlk Vlk VSS VSS nfet_03v3 L=1U W=1U AS=0.28P AD=0.28P PS=1.56U PD=1.56U
M$761 VSS Vlk Vlk VSS nfet_03v3 L=1U W=1U AS=0.28P AD=0.28P PS=1.56U PD=1.56U
M$762 Vlk Vlk VSS VSS nfet_03v3 L=1U W=1U AS=0.28P AD=0.28P PS=1.56U PD=1.56U
M$763 VSS Vlk Vlk VSS nfet_03v3 L=1U W=1U AS=0.28P AD=0.28P PS=1.56U PD=1.56U
M$764 Vlk Vlk VSS VSS nfet_03v3 L=1U W=1U AS=0.28P AD=0.28P PS=1.56U PD=1.56U
M$765 VSS Vlk Vlk VSS nfet_03v3 L=1U W=1U AS=0.28P AD=0.6P PS=1.56U PD=3.2U
M$766 VKdn VKdn VSS VSS nfet_03v3 L=1U W=1U AS=0.6P AD=0.28P PS=3.2U PD=1.56U
M$767 VSS VKdn VKdn VSS nfet_03v3 L=1U W=1U AS=0.28P AD=0.28P PS=1.56U PD=1.56U
M$768 VKdn VKdn VSS VSS nfet_03v3 L=1U W=1U AS=0.28P AD=0.28P PS=1.56U PD=1.56U
M$769 VSS VKdn VKdn VSS nfet_03v3 L=1U W=1U AS=0.28P AD=0.6P PS=1.56U PD=3.2U
M$770 VIp VIp VSS VSS nfet_03v3 L=1U W=1U AS=0.6P AD=0.6P PS=3.2U PD=3.2U
M$771 Vamp_bias Vamp_bias VSS VSS nfet_03v3 L=0.64U W=0.5U AS=0.3P AD=0.3P
+ PS=2.2U PD=2.2U
M$772 VK VK \$130 VSS nfet_03v3 L=45.45U W=0.5U AS=0.3P AD=0.3P PS=2.2U PD=2.2U
M$773 \$130 VK VSS VSS nfet_03v3 L=45.45U W=0.5U AS=0.3P AD=0.3P PS=2.2U PD=2.2U
M$774 VSS VSS VSS VSS nfet_03v3 L=2U W=10U AS=6P AD=6P PS=21.2U PD=21.2U
.ENDS bias

.SUBCKT DPI_inh VDD Isum Vthr Iout VT VSS
M$1 VDD VDD VDD VDD pfet_03v3 L=2U W=0.5U AS=0.3P AD=0.14P PS=2.2U PD=1.06U
M$2 VDD VDD VDD VDD pfet_03v3 L=2U W=0.5U AS=0.14P AD=0.14P PS=1.06U PD=1.06U
M$3 VDD VDD VDD VDD pfet_03v3 L=2U W=0.5U AS=0.14P AD=0.14P PS=1.06U PD=1.06U
M$4 VDD VDD VDD VDD pfet_03v3 L=2U W=0.5U AS=0.14P AD=0.14P PS=1.06U PD=1.06U
M$5 VDD VDD VDD VDD pfet_03v3 L=2U W=0.5U AS=0.14P AD=0.14P PS=1.06U PD=1.06U
M$6 VDD VDD VDD VDD pfet_03v3 L=2U W=0.5U AS=0.14P AD=0.14P PS=1.06U PD=1.06U
M$7 VDD VDD VDD VDD pfet_03v3 L=2U W=0.5U AS=0.14P AD=0.14P PS=1.06U PD=1.06U
M$8 VDD VDD VDD VDD pfet_03v3 L=2U W=0.5U AS=0.14P AD=0.3P PS=1.06U PD=2.2U
M$9 VDD VDD VDD VDD pfet_03v3 L=2U W=0.5U AS=0.3P AD=0.14P PS=2.2U PD=1.06U
M$10 VDD VDD VDD VDD pfet_03v3 L=2U W=0.5U AS=0.14P AD=0.14P PS=1.06U PD=1.06U
M$11 VDD VDD VDD VDD pfet_03v3 L=2U W=0.5U AS=0.14P AD=0.14P PS=1.06U PD=1.06U
M$12 VDD VDD VDD VDD pfet_03v3 L=2U W=0.5U AS=0.14P AD=0.14P PS=1.06U PD=1.06U
M$13 VDD VDD VDD VDD pfet_03v3 L=2U W=0.5U AS=0.14P AD=0.14P PS=1.06U PD=1.06U
M$14 VDD VDD VDD VDD pfet_03v3 L=2U W=0.5U AS=0.14P AD=0.14P PS=1.06U PD=1.06U
M$15 VDD VDD VDD VDD pfet_03v3 L=2U W=0.5U AS=0.14P AD=0.14P PS=1.06U PD=1.06U
M$16 VDD VDD VDD VDD pfet_03v3 L=2U W=0.5U AS=0.14P AD=0.3P PS=1.06U PD=2.2U
M$17 VDD VT \$180 VDD pfet_03v3 L=5.12U W=4U AS=2.4P AD=2.4P PS=9.2U PD=9.2U
M$18 VDD \$180 \$1 VDD pfet_03v3 L=5.12U W=4U AS=2.4P AD=2.4P PS=9.2U PD=9.2U
M$19 VDD VDD VDD VDD pfet_03v3 L=2U W=4U AS=2.4P AD=2.4P PS=9.2U PD=9.2U
M$20 VDD VDD VDD VDD pfet_03v3 L=2U W=4U AS=2.4P AD=2.4P PS=9.2U PD=9.2U
M$21 Isum Isum Isum Isum nfet_03v3 L=2U W=0.5U AS=0.3P AD=0.14P PS=2.2U PD=1.06U
M$22 Isum Isum Isum Isum nfet_03v3 L=2U W=0.5U AS=0.14P AD=0.14P PS=1.06U
+ PD=1.06U
M$23 Isum Isum Isum Isum nfet_03v3 L=2U W=0.5U AS=0.14P AD=0.14P PS=1.06U
+ PD=1.06U
M$24 Isum Isum Isum Isum nfet_03v3 L=2U W=0.5U AS=0.14P AD=0.14P PS=1.06U
+ PD=1.06U
M$25 Isum Isum Isum Isum nfet_03v3 L=2U W=0.5U AS=0.14P AD=0.14P PS=1.06U
+ PD=1.06U
M$26 Isum Isum Isum Isum nfet_03v3 L=2U W=0.5U AS=0.14P AD=0.14P PS=1.06U
+ PD=1.06U
M$27 Isum Isum Isum Isum nfet_03v3 L=2U W=0.5U AS=0.14P AD=0.14P PS=1.06U
+ PD=1.06U
M$28 Isum Isum Isum Isum nfet_03v3 L=2U W=0.5U AS=0.14P AD=0.3P PS=1.06U PD=2.2U
M$29 VSS VSS VSS VSS nfet_03v3 L=2U W=2.4U AS=1.44P AD=1.44P PS=6U PD=6U
M$30 Iout \$1 VSS VSS nfet_03v3 L=8U W=2.4U AS=1.44P AD=1.44P PS=6U PD=6U
M$31 Isum Isum Isum Isum nfet_03v3 L=2U W=0.5U AS=0.3P AD=0.14P PS=2.2U PD=1.06U
M$32 Isum Isum Isum Isum nfet_03v3 L=2U W=0.5U AS=0.14P AD=0.14P PS=1.06U
+ PD=1.06U
M$33 Isum Isum Isum Isum nfet_03v3 L=2U W=0.5U AS=0.14P AD=0.14P PS=1.06U
+ PD=1.06U
M$34 Isum Isum Isum Isum nfet_03v3 L=2U W=0.5U AS=0.14P AD=0.14P PS=1.06U
+ PD=1.06U
M$35 Isum Isum Isum Isum nfet_03v3 L=2U W=0.5U AS=0.14P AD=0.14P PS=1.06U
+ PD=1.06U
M$36 Isum Isum Isum Isum nfet_03v3 L=2U W=0.5U AS=0.14P AD=0.14P PS=1.06U
+ PD=1.06U
M$37 Isum Isum Isum Isum nfet_03v3 L=2U W=0.5U AS=0.14P AD=0.14P PS=1.06U
+ PD=1.06U
M$38 Isum Isum Isum Isum nfet_03v3 L=2U W=0.5U AS=0.14P AD=0.3P PS=1.06U PD=2.2U
M$39 VSS VSS VSS VSS nfet_03v3 L=2U W=0.5U AS=0.3P AD=0.14P PS=2.2U PD=1.06U
M$40 VSS VSS VSS VSS nfet_03v3 L=2U W=0.5U AS=0.14P AD=0.14P PS=1.06U PD=1.06U
M$41 VSS VSS VSS VSS nfet_03v3 L=2U W=0.5U AS=0.14P AD=0.14P PS=1.06U PD=1.06U
M$42 VSS VSS VSS VSS nfet_03v3 L=2U W=0.5U AS=0.14P AD=0.14P PS=1.06U PD=1.06U
M$43 VSS VSS VSS VSS nfet_03v3 L=2U W=0.5U AS=0.14P AD=0.14P PS=1.06U PD=1.06U
M$44 VSS VSS VSS VSS nfet_03v3 L=2U W=0.5U AS=0.14P AD=0.14P PS=1.06U PD=1.06U
M$45 VSS VSS VSS VSS nfet_03v3 L=2U W=0.5U AS=0.14P AD=0.14P PS=1.06U PD=1.06U
M$46 VSS VSS VSS VSS nfet_03v3 L=2U W=0.5U AS=0.14P AD=0.14P PS=1.06U PD=1.06U
M$47 VSS VSS VSS VSS nfet_03v3 L=2U W=0.5U AS=0.14P AD=0.14P PS=1.06U PD=1.06U
M$48 VSS VSS VSS VSS nfet_03v3 L=2U W=0.5U AS=0.14P AD=0.3P PS=1.06U PD=2.2U
M$49 Isum Isum Isum Isum nfet_03v3 L=2U W=4U AS=2.4P AD=2.4P PS=9.2U PD=9.2U
M$50 \$180 \$180 Isum Isum nfet_03v3 L=5.12U W=4U AS=2.4P AD=2.4P PS=9.2U
+ PD=9.2U
M$51 VSS VSS VSS VSS nfet_03v3 L=2U W=0.5U AS=0.3P AD=0.14P PS=2.2U PD=1.06U
M$52 VSS VSS VSS VSS nfet_03v3 L=2U W=0.5U AS=0.14P AD=0.14P PS=1.06U PD=1.06U
M$53 VSS VSS VSS VSS nfet_03v3 L=2U W=0.5U AS=0.14P AD=0.14P PS=1.06U PD=1.06U
M$54 VSS VSS VSS VSS nfet_03v3 L=2U W=0.5U AS=0.14P AD=0.14P PS=1.06U PD=1.06U
M$55 VSS VSS VSS VSS nfet_03v3 L=2U W=0.5U AS=0.14P AD=0.14P PS=1.06U PD=1.06U
M$56 VSS VSS VSS VSS nfet_03v3 L=2U W=0.5U AS=0.14P AD=0.14P PS=1.06U PD=1.06U
M$57 VSS VSS VSS VSS nfet_03v3 L=2U W=0.5U AS=0.14P AD=0.14P PS=1.06U PD=1.06U
M$58 VSS VSS VSS VSS nfet_03v3 L=2U W=0.5U AS=0.14P AD=0.14P PS=1.06U PD=1.06U
M$59 VSS VSS VSS VSS nfet_03v3 L=2U W=0.5U AS=0.14P AD=0.14P PS=1.06U PD=1.06U
M$60 VSS VSS VSS VSS nfet_03v3 L=2U W=0.5U AS=0.14P AD=0.3P PS=1.06U PD=2.2U
M$61 \$1 \$1 VSS VSS nfet_03v3 L=8U W=2U AS=1.2P AD=1.2P PS=5.2U PD=5.2U
M$62 VDD Vthr Isum Isum nfet_03v3 L=5.12U W=4U AS=2.4P AD=2.4P PS=9.2U PD=9.2U
M$63 Isum Isum Isum Isum nfet_03v3 L=2U W=4U AS=2.4P AD=2.4P PS=9.2U PD=9.2U
M$64 VSS VSS VSS VSS nfet_03v3 L=2U W=2.4U AS=1.44P AD=1.44P PS=6U PD=6U
C$65 \$180 VDD 9.839048e-13 cap_mim_2f0fF A=491.9524P P=88.72U
.ENDS DPI_inh

.SUBCKT neuron Vamp_bias VT VKdn VIp VK Vlk VDD VMEM spike VNA VKup VSS
M$1 VDD \$217 \$217 VDD pfet_03v3 L=8U W=0.5U AS=0.3P AD=0.3P PS=2.2U PD=2.2U
M$2 \$768 \$7 VMEM VDD pfet_03v3 L=0.64U W=0.5U AS=0.3P AD=0.3P PS=2.2U PD=2.2U
M$3 VDD VDD VDD VDD pfet_03v3 L=2U W=0.5U AS=0.3P AD=0.14P PS=2.2U PD=1.06U
M$4 VDD VDD VDD VDD pfet_03v3 L=2U W=0.5U AS=0.14P AD=0.14P PS=1.06U PD=1.06U
M$5 VDD VDD VDD VDD pfet_03v3 L=2U W=0.5U AS=0.14P AD=0.14P PS=1.06U PD=1.06U
M$6 VDD VDD VDD VDD pfet_03v3 L=2U W=0.5U AS=0.14P AD=0.14P PS=1.06U PD=1.06U
M$7 VDD VDD VDD VDD pfet_03v3 L=2U W=0.5U AS=0.14P AD=0.14P PS=1.06U PD=1.06U
M$8 VDD VDD VDD VDD pfet_03v3 L=2U W=0.5U AS=0.14P AD=0.14P PS=1.06U PD=1.06U
M$9 VDD VDD VDD VDD pfet_03v3 L=2U W=0.5U AS=0.14P AD=0.14P PS=1.06U PD=1.06U
M$10 VDD VDD VDD VDD pfet_03v3 L=2U W=0.5U AS=0.14P AD=0.14P PS=1.06U PD=1.06U
M$11 VDD VDD VDD VDD pfet_03v3 L=2U W=0.5U AS=0.14P AD=0.14P PS=1.06U PD=1.06U
M$12 VDD VDD VDD VDD pfet_03v3 L=2U W=0.5U AS=0.14P AD=0.14P PS=1.06U PD=1.06U
M$13 VDD VDD VDD VDD pfet_03v3 L=2U W=0.5U AS=0.14P AD=0.14P PS=1.06U PD=1.06U
M$14 VDD VDD VDD VDD pfet_03v3 L=2U W=0.5U AS=0.14P AD=0.14P PS=1.06U PD=1.06U
M$15 VDD VDD VDD VDD pfet_03v3 L=2U W=0.5U AS=0.14P AD=0.14P PS=1.06U PD=1.06U
M$16 VDD VDD VDD VDD pfet_03v3 L=2U W=0.5U AS=0.14P AD=0.14P PS=1.06U PD=1.06U
M$17 VDD VDD VDD VDD pfet_03v3 L=2U W=0.5U AS=0.14P AD=0.14P PS=1.06U PD=1.06U
M$18 VDD VDD VDD VDD pfet_03v3 L=2U W=0.5U AS=0.14P AD=0.14P PS=1.06U PD=1.06U
M$19 VDD VDD VDD VDD pfet_03v3 L=2U W=0.5U AS=0.14P AD=0.3P PS=1.06U PD=2.2U
M$20 \$766 \$7 spike VDD pfet_03v3 L=0.64U W=0.5U AS=0.3P AD=0.3P PS=2.2U
+ PD=2.2U
M$21 VDD VDD VDD VDD pfet_03v3 L=2U W=0.5U AS=0.3P AD=0.14P PS=2.2U PD=1.06U
M$22 VDD VDD VDD VDD pfet_03v3 L=2U W=0.5U AS=0.14P AD=0.14P PS=1.06U PD=1.06U
M$23 VDD VDD VDD VDD pfet_03v3 L=2U W=0.5U AS=0.14P AD=0.14P PS=1.06U PD=1.06U
M$24 VDD VDD VDD VDD pfet_03v3 L=2U W=0.5U AS=0.14P AD=0.14P PS=1.06U PD=1.06U
M$25 VDD VDD VDD VDD pfet_03v3 L=2U W=0.5U AS=0.14P AD=0.14P PS=1.06U PD=1.06U
M$26 VDD VDD VDD VDD pfet_03v3 L=2U W=0.5U AS=0.14P AD=0.14P PS=1.06U PD=1.06U
M$27 VDD VDD VDD VDD pfet_03v3 L=2U W=0.5U AS=0.14P AD=0.14P PS=1.06U PD=1.06U
M$28 VDD VDD VDD VDD pfet_03v3 L=2U W=0.5U AS=0.14P AD=0.14P PS=1.06U PD=1.06U
M$29 VDD VDD VDD VDD pfet_03v3 L=2U W=0.5U AS=0.14P AD=0.14P PS=1.06U PD=1.06U
M$30 VDD VDD VDD VDD pfet_03v3 L=2U W=0.5U AS=0.14P AD=0.14P PS=1.06U PD=1.06U
M$31 VDD VDD VDD VDD pfet_03v3 L=2U W=0.5U AS=0.14P AD=0.14P PS=1.06U PD=1.06U
M$32 VDD VDD VDD VDD pfet_03v3 L=2U W=0.5U AS=0.14P AD=0.14P PS=1.06U PD=1.06U
M$33 VDD VDD VDD VDD pfet_03v3 L=2U W=0.5U AS=0.14P AD=0.14P PS=1.06U PD=1.06U
M$34 VDD VDD VDD VDD pfet_03v3 L=2U W=0.5U AS=0.14P AD=0.14P PS=1.06U PD=1.06U
M$35 VDD VDD VDD VDD pfet_03v3 L=2U W=0.5U AS=0.14P AD=0.14P PS=1.06U PD=1.06U
M$36 VDD VDD VDD VDD pfet_03v3 L=2U W=0.5U AS=0.14P AD=0.14P PS=1.06U PD=1.06U
M$37 VDD VDD VDD VDD pfet_03v3 L=2U W=0.5U AS=0.14P AD=0.3P PS=1.06U PD=2.2U
M$38 VDD \$217 \$218 VDD pfet_03v3 L=8U W=0.5U AS=0.3P AD=0.3P PS=2.2U PD=2.2U
M$39 VDD VDD VDD VDD pfet_03v3 L=2U W=1U AS=0.6P AD=0.6P PS=3.2U PD=3.2U
M$40 VDD VKup \$766 VDD pfet_03v3 L=1U W=1U AS=0.6P AD=0.6P PS=3.2U PD=3.2U
M$41 VDD \$218 \$7 VDD pfet_03v3 L=0.64U W=0.5U AS=0.3P AD=0.3P PS=2.2U PD=2.2U
M$42 VDD VDD VDD VDD pfet_03v3 L=2U W=1U AS=0.6P AD=0.6P PS=3.2U PD=3.2U
M$43 VDD VNA \$768 VDD pfet_03v3 L=1U W=1U AS=0.6P AD=0.6P PS=3.2U PD=3.2U
M$44 VSS VSS VSS VSS nfet_03v3 L=2U W=0.5U AS=0.3P AD=0.14P PS=2.2U PD=1.06U
M$45 VSS VSS VSS VSS nfet_03v3 L=2U W=0.5U AS=0.14P AD=0.14P PS=1.06U PD=1.06U
M$46 VSS VSS VSS VSS nfet_03v3 L=2U W=0.5U AS=0.14P AD=0.14P PS=1.06U PD=1.06U
M$47 VSS VSS VSS VSS nfet_03v3 L=2U W=0.5U AS=0.14P AD=0.14P PS=1.06U PD=1.06U
M$48 VSS VSS VSS VSS nfet_03v3 L=2U W=0.5U AS=0.14P AD=0.14P PS=1.06U PD=1.06U
M$49 VSS VSS VSS VSS nfet_03v3 L=2U W=0.5U AS=0.14P AD=0.14P PS=1.06U PD=1.06U
M$50 VSS VSS VSS VSS nfet_03v3 L=2U W=0.5U AS=0.14P AD=0.14P PS=1.06U PD=1.06U
M$51 VSS VSS VSS VSS nfet_03v3 L=2U W=0.5U AS=0.14P AD=0.14P PS=1.06U PD=1.06U
M$52 VSS VSS VSS VSS nfet_03v3 L=2U W=0.5U AS=0.14P AD=0.14P PS=1.06U PD=1.06U
M$53 VSS VSS VSS VSS nfet_03v3 L=2U W=0.5U AS=0.14P AD=0.14P PS=1.06U PD=1.06U
M$54 VSS VSS VSS VSS nfet_03v3 L=2U W=0.5U AS=0.14P AD=0.14P PS=1.06U PD=1.06U
M$55 VSS VSS VSS VSS nfet_03v3 L=2U W=0.5U AS=0.14P AD=0.14P PS=1.06U PD=1.06U
M$56 VSS VSS VSS VSS nfet_03v3 L=2U W=0.5U AS=0.14P AD=0.14P PS=1.06U PD=1.06U
M$57 VSS VSS VSS VSS nfet_03v3 L=2U W=0.5U AS=0.14P AD=0.14P PS=1.06U PD=1.06U
M$58 VSS VSS VSS VSS nfet_03v3 L=2U W=0.5U AS=0.14P AD=0.14P PS=1.06U PD=1.06U
M$59 VSS VSS VSS VSS nfet_03v3 L=2U W=0.5U AS=0.14P AD=0.14P PS=1.06U PD=1.06U
M$60 VSS VSS VSS VSS nfet_03v3 L=2U W=0.5U AS=0.14P AD=0.14P PS=1.06U PD=1.06U
M$61 VSS VSS VSS VSS nfet_03v3 L=2U W=0.5U AS=0.14P AD=0.14P PS=1.06U PD=1.06U
M$62 VSS VSS VSS VSS nfet_03v3 L=2U W=0.5U AS=0.14P AD=0.14P PS=1.06U PD=1.06U
M$63 VSS VSS VSS VSS nfet_03v3 L=2U W=0.5U AS=0.14P AD=0.3P PS=1.06U PD=2.2U
M$64 VSS VSS VSS VSS nfet_03v3 L=2U W=4U AS=2.4P AD=2.4P PS=9.2U PD=9.2U
M$65 VSS VSS VSS VSS nfet_03v3 L=2U W=0.5U AS=0.3P AD=0.14P PS=2.2U PD=1.06U
M$66 VSS VSS VSS VSS nfet_03v3 L=2U W=0.5U AS=0.14P AD=0.14P PS=1.06U PD=1.06U
M$67 VSS VSS VSS VSS nfet_03v3 L=2U W=0.5U AS=0.14P AD=0.14P PS=1.06U PD=1.06U
M$68 VSS VSS VSS VSS nfet_03v3 L=2U W=0.5U AS=0.14P AD=0.14P PS=1.06U PD=1.06U
M$69 VSS VSS VSS VSS nfet_03v3 L=2U W=0.5U AS=0.14P AD=0.14P PS=1.06U PD=1.06U
M$70 VSS VSS VSS VSS nfet_03v3 L=2U W=0.5U AS=0.14P AD=0.14P PS=1.06U PD=1.06U
M$71 VSS VSS VSS VSS nfet_03v3 L=2U W=0.5U AS=0.14P AD=0.14P PS=1.06U PD=1.06U
M$72 VSS VSS VSS VSS nfet_03v3 L=2U W=0.5U AS=0.14P AD=0.14P PS=1.06U PD=1.06U
M$73 VSS VSS VSS VSS nfet_03v3 L=2U W=0.5U AS=0.14P AD=0.14P PS=1.06U PD=1.06U
M$74 VSS VSS VSS VSS nfet_03v3 L=2U W=0.5U AS=0.14P AD=0.14P PS=1.06U PD=1.06U
M$75 VSS VSS VSS VSS nfet_03v3 L=2U W=0.5U AS=0.14P AD=0.14P PS=1.06U PD=1.06U
M$76 VSS VSS VSS VSS nfet_03v3 L=2U W=0.5U AS=0.14P AD=0.14P PS=1.06U PD=1.06U
M$77 VSS VSS VSS VSS nfet_03v3 L=2U W=0.5U AS=0.14P AD=0.14P PS=1.06U PD=1.06U
M$78 VSS VSS VSS VSS nfet_03v3 L=2U W=0.5U AS=0.14P AD=0.14P PS=1.06U PD=1.06U
M$79 VSS VSS VSS VSS nfet_03v3 L=2U W=0.5U AS=0.14P AD=0.14P PS=1.06U PD=1.06U
M$80 VSS VSS VSS VSS nfet_03v3 L=2U W=0.5U AS=0.14P AD=0.14P PS=1.06U PD=1.06U
M$81 VSS VSS VSS VSS nfet_03v3 L=2U W=0.5U AS=0.14P AD=0.14P PS=1.06U PD=1.06U
M$82 VSS VSS VSS VSS nfet_03v3 L=2U W=0.5U AS=0.14P AD=0.14P PS=1.06U PD=1.06U
M$83 VSS VSS VSS VSS nfet_03v3 L=2U W=0.5U AS=0.14P AD=0.14P PS=1.06U PD=1.06U
M$84 VSS VSS VSS VSS nfet_03v3 L=2U W=0.5U AS=0.14P AD=0.3P PS=1.06U PD=2.2U
M$85 \$216 Vamp_bias VSS VSS nfet_03v3 L=0.64U W=0.5U AS=0.3P AD=0.3P PS=2.2U
+ PD=2.2U
M$86 \$217 VMEM \$216 VSS nfet_03v3 L=2U W=4U AS=2.4P AD=2.4P PS=9.2U PD=9.2U
M$87 \$218 VT \$216 VSS nfet_03v3 L=2U W=4U AS=2.4P AD=2.4P PS=9.2U PD=9.2U
M$88 \$7 \$218 \$272 VSS nfet_03v3 L=0.64U W=0.5U AS=0.3P AD=0.3P PS=2.2U
+ PD=2.2U
M$89 spike \$7 \$273 VSS nfet_03v3 L=0.64U W=0.5U AS=0.3P AD=0.3P PS=2.2U
+ PD=2.2U
M$90 VMEM spike \$274 VSS nfet_03v3 L=11.36U W=0.5U AS=0.3P AD=0.3P PS=2.2U
+ PD=2.2U
M$91 \$273 VKdn VSS VSS nfet_03v3 L=1U W=1U AS=0.6P AD=0.6P PS=3.2U PD=3.2U
M$92 \$272 VIp VSS VSS nfet_03v3 L=1U W=1U AS=0.6P AD=0.6P PS=3.2U PD=3.2U
M$93 \$274 VK VSS VSS nfet_03v3 L=1U W=1U AS=0.6P AD=0.6P PS=3.2U PD=3.2U
M$94 VMEM Vlk VSS VSS nfet_03v3 L=1U W=1U AS=0.6P AD=0.6P PS=3.2U PD=3.2U
M$95 VSS VSS VSS VSS nfet_03v3 L=2U W=4U AS=2.4P AD=2.4P PS=9.2U PD=9.2U
C$96 VSS VMEM 9.839048e-13 cap_mim_2f0fF A=491.9524P P=88.72U
C$97 VSS spike 2e-13 cap_mim_2f0fF A=100P P=40U
.ENDS neuron

.SUBCKT DPI VDD Isum Vthr Isyn VT VSS
M$1 VDD VDD VDD VDD pfet_03v3 L=2U W=0.5U AS=0.3P AD=0.14P PS=2.2U PD=1.06U
M$2 VDD VDD VDD VDD pfet_03v3 L=2U W=0.5U AS=0.14P AD=0.14P PS=1.06U PD=1.06U
M$3 VDD VDD VDD VDD pfet_03v3 L=2U W=0.5U AS=0.14P AD=0.14P PS=1.06U PD=1.06U
M$4 VDD VDD VDD VDD pfet_03v3 L=2U W=0.5U AS=0.14P AD=0.14P PS=1.06U PD=1.06U
M$5 VDD VDD VDD VDD pfet_03v3 L=2U W=0.5U AS=0.14P AD=0.14P PS=1.06U PD=1.06U
M$6 VDD VDD VDD VDD pfet_03v3 L=2U W=0.5U AS=0.14P AD=0.14P PS=1.06U PD=1.06U
M$7 VDD VDD VDD VDD pfet_03v3 L=2U W=0.5U AS=0.14P AD=0.14P PS=1.06U PD=1.06U
M$8 VDD VDD VDD VDD pfet_03v3 L=2U W=0.5U AS=0.14P AD=0.3P PS=1.06U PD=2.2U
M$9 VDD VDD VDD VDD pfet_03v3 L=2U W=4U AS=2.4P AD=2.4P PS=9.2U PD=9.2U
M$10 VDD \$172 Isyn VDD pfet_03v3 L=5.12U W=4U AS=2.4P AD=2.4P PS=9.2U PD=9.2U
M$11 VDD VDD VDD VDD pfet_03v3 L=2U W=0.5U AS=0.3P AD=0.14P PS=2.2U PD=1.06U
M$12 VDD VDD VDD VDD pfet_03v3 L=2U W=0.5U AS=0.14P AD=0.14P PS=1.06U PD=1.06U
M$13 VDD VDD VDD VDD pfet_03v3 L=2U W=0.5U AS=0.14P AD=0.14P PS=1.06U PD=1.06U
M$14 VDD VDD VDD VDD pfet_03v3 L=2U W=0.5U AS=0.14P AD=0.14P PS=1.06U PD=1.06U
M$15 VDD VDD VDD VDD pfet_03v3 L=2U W=0.5U AS=0.14P AD=0.14P PS=1.06U PD=1.06U
M$16 VDD VDD VDD VDD pfet_03v3 L=2U W=0.5U AS=0.14P AD=0.14P PS=1.06U PD=1.06U
M$17 VDD VDD VDD VDD pfet_03v3 L=2U W=0.5U AS=0.14P AD=0.14P PS=1.06U PD=1.06U
M$18 VDD VDD VDD VDD pfet_03v3 L=2U W=0.5U AS=0.14P AD=0.3P PS=1.06U PD=2.2U
M$19 VDD VDD VDD VDD pfet_03v3 L=2U W=4U AS=2.4P AD=2.4P PS=9.2U PD=9.2U
M$20 VDD VT \$172 VDD pfet_03v3 L=5.12U W=4U AS=2.4P AD=2.4P PS=9.2U PD=9.2U
M$21 Isum Isum Isum Isum nfet_03v3 L=2U W=4U AS=2.4P AD=2.4P PS=9.2U PD=9.2U
M$22 Isum Isum Isum Isum nfet_03v3 L=2U W=0.5U AS=0.3P AD=0.14P PS=2.2U PD=1.06U
M$23 Isum Isum Isum Isum nfet_03v3 L=2U W=0.5U AS=0.14P AD=0.14P PS=1.06U
+ PD=1.06U
M$24 Isum Isum Isum Isum nfet_03v3 L=2U W=0.5U AS=0.14P AD=0.14P PS=1.06U
+ PD=1.06U
M$25 Isum Isum Isum Isum nfet_03v3 L=2U W=0.5U AS=0.14P AD=0.14P PS=1.06U
+ PD=1.06U
M$26 Isum Isum Isum Isum nfet_03v3 L=2U W=0.5U AS=0.14P AD=0.14P PS=1.06U
+ PD=1.06U
M$27 Isum Isum Isum Isum nfet_03v3 L=2U W=0.5U AS=0.14P AD=0.14P PS=1.06U
+ PD=1.06U
M$28 Isum Isum Isum Isum nfet_03v3 L=2U W=0.5U AS=0.14P AD=0.14P PS=1.06U
+ PD=1.06U
M$29 Isum Isum Isum Isum nfet_03v3 L=2U W=0.5U AS=0.14P AD=0.3P PS=1.06U PD=2.2U
M$30 \$172 \$172 Isum Isum nfet_03v3 L=5.12U W=4U AS=2.4P AD=2.4P PS=9.2U
+ PD=9.2U
M$31 VDD Vthr Isum Isum nfet_03v3 L=5.12U W=4U AS=2.4P AD=2.4P PS=9.2U PD=9.2U
M$32 Isum Isum Isum Isum nfet_03v3 L=2U W=4U AS=2.4P AD=2.4P PS=9.2U PD=9.2U
M$33 Isum Isum Isum Isum nfet_03v3 L=2U W=0.5U AS=0.3P AD=0.14P PS=2.2U PD=1.06U
M$34 Isum Isum Isum Isum nfet_03v3 L=2U W=0.5U AS=0.14P AD=0.14P PS=1.06U
+ PD=1.06U
M$35 Isum Isum Isum Isum nfet_03v3 L=2U W=0.5U AS=0.14P AD=0.14P PS=1.06U
+ PD=1.06U
M$36 Isum Isum Isum Isum nfet_03v3 L=2U W=0.5U AS=0.14P AD=0.14P PS=1.06U
+ PD=1.06U
M$37 Isum Isum Isum Isum nfet_03v3 L=2U W=0.5U AS=0.14P AD=0.14P PS=1.06U
+ PD=1.06U
M$38 Isum Isum Isum Isum nfet_03v3 L=2U W=0.5U AS=0.14P AD=0.14P PS=1.06U
+ PD=1.06U
M$39 Isum Isum Isum Isum nfet_03v3 L=2U W=0.5U AS=0.14P AD=0.14P PS=1.06U
+ PD=1.06U
M$40 Isum Isum Isum Isum nfet_03v3 L=2U W=0.5U AS=0.14P AD=0.3P PS=1.06U PD=2.2U
C$41 \$172 VDD 9.839048e-13 cap_mim_2f0fF A=491.9524P P=88.72U
.ENDS DPI

.SUBCKT DAC en s Vb w[0] w[1] VDD Isum_e Isum_i w[2] w[3] VSS
M$1 VDD VDD VDD VDD pfet_03v3 L=2U W=0.5U AS=0.3P AD=0.14P PS=2.2U PD=1.06U
M$2 VDD VDD VDD VDD pfet_03v3 L=2U W=0.5U AS=0.14P AD=0.14P PS=1.06U PD=1.06U
M$3 VDD VDD VDD VDD pfet_03v3 L=2U W=0.5U AS=0.14P AD=0.3P PS=1.06U PD=2.2U
M$4 VDD VDD VDD VDD pfet_03v3 L=2U W=0.5U AS=0.3P AD=0.3P PS=2.2U PD=2.2U
M$5 VDD VDD VDD VDD pfet_03v3 L=2U W=0.5U AS=0.3P AD=0.3P PS=2.2U PD=2.2U
M$6 VDD s \$6 VDD pfet_03v3 L=0.32U W=0.5U AS=0.3P AD=0.3P PS=2.2U PD=2.2U
M$7 VDD VDD VDD VDD pfet_03v3 L=2U W=0.5U AS=0.3P AD=0.14P PS=2.2U PD=1.06U
M$8 VDD VDD VDD VDD pfet_03v3 L=2U W=0.5U AS=0.14P AD=0.14P PS=1.06U PD=1.06U
M$9 VDD VDD VDD VDD pfet_03v3 L=2U W=0.5U AS=0.14P AD=0.3P PS=1.06U PD=2.2U
M$10 VSS VSS VSS VSS nfet_03v3 L=2U W=0.5U AS=0.3P AD=0.14P PS=2.2U PD=1.06U
M$11 VSS VSS VSS VSS nfet_03v3 L=2U W=0.5U AS=0.14P AD=0.14P PS=1.06U PD=1.06U
M$12 VSS VSS VSS VSS nfet_03v3 L=2U W=0.5U AS=0.14P AD=0.14P PS=1.06U PD=1.06U
M$13 VSS VSS VSS VSS nfet_03v3 L=2U W=0.5U AS=0.14P AD=0.14P PS=1.06U PD=1.06U
M$14 VSS VSS VSS VSS nfet_03v3 L=2U W=0.5U AS=0.14P AD=0.14P PS=1.06U PD=1.06U
M$15 VSS VSS VSS VSS nfet_03v3 L=2U W=0.5U AS=0.14P AD=0.14P PS=1.06U PD=1.06U
M$16 VSS VSS VSS VSS nfet_03v3 L=2U W=0.5U AS=0.14P AD=0.14P PS=1.06U PD=1.06U
M$17 VSS VSS VSS VSS nfet_03v3 L=2U W=0.5U AS=0.14P AD=0.14P PS=1.06U PD=1.06U
M$18 VSS VSS VSS VSS nfet_03v3 L=2U W=0.5U AS=0.14P AD=0.14P PS=1.06U PD=1.06U
M$19 VSS VSS VSS VSS nfet_03v3 L=2U W=0.5U AS=0.14P AD=0.14P PS=1.06U PD=1.06U
M$20 VSS VSS VSS VSS nfet_03v3 L=2U W=0.5U AS=0.14P AD=0.14P PS=1.06U PD=1.06U
M$21 VSS VSS VSS VSS nfet_03v3 L=2U W=0.5U AS=0.14P AD=0.14P PS=1.06U PD=1.06U
M$22 VSS VSS VSS VSS nfet_03v3 L=2U W=0.5U AS=0.14P AD=0.14P PS=1.06U PD=1.06U
M$23 VSS VSS VSS VSS nfet_03v3 L=2U W=0.5U AS=0.14P AD=0.14P PS=1.06U PD=1.06U
M$24 VSS VSS VSS VSS nfet_03v3 L=2U W=0.5U AS=0.14P AD=0.14P PS=1.06U PD=1.06U
M$25 VSS VSS VSS VSS nfet_03v3 L=2U W=0.5U AS=0.14P AD=0.14P PS=1.06U PD=1.06U
M$26 VSS VSS VSS VSS nfet_03v3 L=2U W=0.5U AS=0.14P AD=0.14P PS=1.06U PD=1.06U
M$27 VSS VSS VSS VSS nfet_03v3 L=2U W=0.5U AS=0.14P AD=0.14P PS=1.06U PD=1.06U
M$28 VSS VSS VSS VSS nfet_03v3 L=2U W=0.5U AS=0.14P AD=0.14P PS=1.06U PD=1.06U
M$29 VSS VSS VSS VSS nfet_03v3 L=2U W=0.5U AS=0.14P AD=0.14P PS=1.06U PD=1.06U
M$30 VSS VSS VSS VSS nfet_03v3 L=2U W=0.5U AS=0.14P AD=0.14P PS=1.06U PD=1.06U
M$31 VSS VSS VSS VSS nfet_03v3 L=2U W=0.5U AS=0.14P AD=0.14P PS=1.06U PD=1.06U
M$32 VSS VSS VSS VSS nfet_03v3 L=2U W=0.5U AS=0.14P AD=0.14P PS=1.06U PD=1.06U
M$33 VSS VSS VSS VSS nfet_03v3 L=2U W=0.5U AS=0.14P AD=0.14P PS=1.06U PD=1.06U
M$34 VSS VSS VSS VSS nfet_03v3 L=2U W=0.5U AS=0.14P AD=0.14P PS=1.06U PD=1.06U
M$35 VSS VSS VSS VSS nfet_03v3 L=2U W=0.5U AS=0.14P AD=0.14P PS=1.06U PD=1.06U
M$36 VSS VSS VSS VSS nfet_03v3 L=2U W=0.5U AS=0.14P AD=0.14P PS=1.06U PD=1.06U
M$37 VSS VSS VSS VSS nfet_03v3 L=2U W=0.5U AS=0.14P AD=0.14P PS=1.06U PD=1.06U
M$38 VSS VSS VSS VSS nfet_03v3 L=2U W=0.5U AS=0.14P AD=0.14P PS=1.06U PD=1.06U
M$39 VSS VSS VSS VSS nfet_03v3 L=2U W=0.5U AS=0.14P AD=0.14P PS=1.06U PD=1.06U
M$40 VSS VSS VSS VSS nfet_03v3 L=2U W=0.5U AS=0.14P AD=0.14P PS=1.06U PD=1.06U
M$41 VSS VSS VSS VSS nfet_03v3 L=2U W=0.5U AS=0.14P AD=0.14P PS=1.06U PD=1.06U
M$42 VSS VSS VSS VSS nfet_03v3 L=2U W=0.5U AS=0.14P AD=0.14P PS=1.06U PD=1.06U
M$43 VSS VSS VSS VSS nfet_03v3 L=2U W=0.5U AS=0.14P AD=0.14P PS=1.06U PD=1.06U
M$44 VSS VSS VSS VSS nfet_03v3 L=2U W=0.5U AS=0.14P AD=0.14P PS=1.06U PD=1.06U
M$45 VSS VSS VSS VSS nfet_03v3 L=2U W=0.5U AS=0.14P AD=0.14P PS=1.06U PD=1.06U
M$46 VSS VSS VSS VSS nfet_03v3 L=2U W=0.5U AS=0.14P AD=0.14P PS=1.06U PD=1.06U
M$47 VSS VSS VSS VSS nfet_03v3 L=2U W=0.5U AS=0.14P AD=0.14P PS=1.06U PD=1.06U
M$48 VSS VSS VSS VSS nfet_03v3 L=2U W=0.5U AS=0.14P AD=0.14P PS=1.06U PD=1.06U
M$49 VSS VSS VSS VSS nfet_03v3 L=2U W=0.5U AS=0.14P AD=0.14P PS=1.06U PD=1.06U
M$50 VSS VSS VSS VSS nfet_03v3 L=2U W=0.5U AS=0.14P AD=0.14P PS=1.06U PD=1.06U
M$51 VSS VSS VSS VSS nfet_03v3 L=2U W=0.5U AS=0.14P AD=0.14P PS=1.06U PD=1.06U
M$52 VSS VSS VSS VSS nfet_03v3 L=2U W=0.5U AS=0.14P AD=0.14P PS=1.06U PD=1.06U
M$53 VSS VSS VSS VSS nfet_03v3 L=2U W=0.5U AS=0.14P AD=0.14P PS=1.06U PD=1.06U
M$54 VSS VSS VSS VSS nfet_03v3 L=2U W=0.5U AS=0.14P AD=0.14P PS=1.06U PD=1.06U
M$55 VSS VSS VSS VSS nfet_03v3 L=2U W=0.5U AS=0.14P AD=0.14P PS=1.06U PD=1.06U
M$56 VSS VSS VSS VSS nfet_03v3 L=2U W=0.5U AS=0.14P AD=0.14P PS=1.06U PD=1.06U
M$57 VSS VSS VSS VSS nfet_03v3 L=2U W=0.5U AS=0.14P AD=0.14P PS=1.06U PD=1.06U
M$58 VSS VSS VSS VSS nfet_03v3 L=2U W=0.5U AS=0.14P AD=0.14P PS=1.06U PD=1.06U
M$59 VSS VSS VSS VSS nfet_03v3 L=2U W=0.5U AS=0.14P AD=0.14P PS=1.06U PD=1.06U
M$60 VSS VSS VSS VSS nfet_03v3 L=2U W=0.5U AS=0.14P AD=0.14P PS=1.06U PD=1.06U
M$61 VSS VSS VSS VSS nfet_03v3 L=2U W=0.5U AS=0.14P AD=0.14P PS=1.06U PD=1.06U
M$62 VSS VSS VSS VSS nfet_03v3 L=2U W=0.5U AS=0.14P AD=0.14P PS=1.06U PD=1.06U
M$63 VSS VSS VSS VSS nfet_03v3 L=2U W=0.5U AS=0.14P AD=0.14P PS=1.06U PD=1.06U
M$64 VSS VSS VSS VSS nfet_03v3 L=2U W=0.5U AS=0.14P AD=0.14P PS=1.06U PD=1.06U
M$65 VSS VSS VSS VSS nfet_03v3 L=2U W=0.5U AS=0.14P AD=0.14P PS=1.06U PD=1.06U
M$66 VSS VSS VSS VSS nfet_03v3 L=2U W=0.5U AS=0.14P AD=0.14P PS=1.06U PD=1.06U
M$67 VSS VSS VSS VSS nfet_03v3 L=2U W=0.5U AS=0.14P AD=0.14P PS=1.06U PD=1.06U
M$68 VSS VSS VSS VSS nfet_03v3 L=2U W=0.5U AS=0.14P AD=0.14P PS=1.06U PD=1.06U
M$69 VSS VSS VSS VSS nfet_03v3 L=2U W=0.5U AS=0.14P AD=0.14P PS=1.06U PD=1.06U
M$70 VSS VSS VSS VSS nfet_03v3 L=2U W=0.5U AS=0.14P AD=0.14P PS=1.06U PD=1.06U
M$71 VSS VSS VSS VSS nfet_03v3 L=2U W=0.5U AS=0.14P AD=0.14P PS=1.06U PD=1.06U
M$72 VSS VSS VSS VSS nfet_03v3 L=2U W=0.5U AS=0.14P AD=0.14P PS=1.06U PD=1.06U
M$73 VSS VSS VSS VSS nfet_03v3 L=2U W=0.5U AS=0.14P AD=0.14P PS=1.06U PD=1.06U
M$74 VSS VSS VSS VSS nfet_03v3 L=2U W=0.5U AS=0.14P AD=0.14P PS=1.06U PD=1.06U
M$75 VSS VSS VSS VSS nfet_03v3 L=2U W=0.5U AS=0.14P AD=0.14P PS=1.06U PD=1.06U
M$76 VSS VSS VSS VSS nfet_03v3 L=2U W=0.5U AS=0.14P AD=0.14P PS=1.06U PD=1.06U
M$77 VSS VSS VSS VSS nfet_03v3 L=2U W=0.5U AS=0.14P AD=0.14P PS=1.06U PD=1.06U
M$78 VSS VSS VSS VSS nfet_03v3 L=2U W=0.5U AS=0.14P AD=0.14P PS=1.06U PD=1.06U
M$79 VSS VSS VSS VSS nfet_03v3 L=2U W=0.5U AS=0.14P AD=0.14P PS=1.06U PD=1.06U
M$80 VSS VSS VSS VSS nfet_03v3 L=2U W=0.5U AS=0.14P AD=0.14P PS=1.06U PD=1.06U
M$81 VSS VSS VSS VSS nfet_03v3 L=2U W=0.5U AS=0.14P AD=0.14P PS=1.06U PD=1.06U
M$82 VSS VSS VSS VSS nfet_03v3 L=2U W=0.5U AS=0.14P AD=0.14P PS=1.06U PD=1.06U
M$83 VSS VSS VSS VSS nfet_03v3 L=2U W=0.5U AS=0.14P AD=0.14P PS=1.06U PD=1.06U
M$84 VSS VSS VSS VSS nfet_03v3 L=2U W=0.5U AS=0.14P AD=0.14P PS=1.06U PD=1.06U
M$85 VSS VSS VSS VSS nfet_03v3 L=2U W=0.5U AS=0.14P AD=0.14P PS=1.06U PD=1.06U
M$86 VSS VSS VSS VSS nfet_03v3 L=2U W=0.5U AS=0.14P AD=0.14P PS=1.06U PD=1.06U
M$87 VSS VSS VSS VSS nfet_03v3 L=2U W=0.5U AS=0.14P AD=0.14P PS=1.06U PD=1.06U
M$88 VSS VSS VSS VSS nfet_03v3 L=2U W=0.5U AS=0.14P AD=0.3P PS=1.06U PD=2.2U
M$89 VSS VSS VSS VSS nfet_03v3 L=2U W=1U AS=0.6P AD=0.6P PS=3.2U PD=3.2U
M$90 VSS VSS VSS VSS nfet_03v3 L=2U W=0.5U AS=0.3P AD=0.14P PS=2.2U PD=1.06U
M$91 VSS VSS VSS VSS nfet_03v3 L=2U W=0.5U AS=0.14P AD=0.14P PS=1.06U PD=1.06U
M$92 VSS VSS VSS VSS nfet_03v3 L=2U W=0.5U AS=0.14P AD=0.14P PS=1.06U PD=1.06U
M$93 VSS VSS VSS VSS nfet_03v3 L=2U W=0.5U AS=0.14P AD=0.14P PS=1.06U PD=1.06U
M$94 VSS VSS VSS VSS nfet_03v3 L=2U W=0.5U AS=0.14P AD=0.14P PS=1.06U PD=1.06U
M$95 VSS VSS VSS VSS nfet_03v3 L=2U W=0.5U AS=0.14P AD=0.14P PS=1.06U PD=1.06U
M$96 VSS VSS VSS VSS nfet_03v3 L=2U W=0.5U AS=0.14P AD=0.14P PS=1.06U PD=1.06U
M$97 VSS VSS VSS VSS nfet_03v3 L=2U W=0.5U AS=0.14P AD=0.14P PS=1.06U PD=1.06U
M$98 VSS VSS VSS VSS nfet_03v3 L=2U W=0.5U AS=0.14P AD=0.14P PS=1.06U PD=1.06U
M$99 VSS VSS VSS VSS nfet_03v3 L=2U W=0.5U AS=0.14P AD=0.14P PS=1.06U PD=1.06U
M$100 VSS VSS VSS VSS nfet_03v3 L=2U W=0.5U AS=0.14P AD=0.14P PS=1.06U PD=1.06U
M$101 VSS VSS VSS VSS nfet_03v3 L=2U W=0.5U AS=0.14P AD=0.14P PS=1.06U PD=1.06U
M$102 VSS VSS VSS VSS nfet_03v3 L=2U W=0.5U AS=0.14P AD=0.14P PS=1.06U PD=1.06U
M$103 VSS VSS VSS VSS nfet_03v3 L=2U W=0.5U AS=0.14P AD=0.14P PS=1.06U PD=1.06U
M$104 VSS VSS VSS VSS nfet_03v3 L=2U W=0.5U AS=0.14P AD=0.14P PS=1.06U PD=1.06U
M$105 VSS VSS VSS VSS nfet_03v3 L=2U W=0.5U AS=0.14P AD=0.14P PS=1.06U PD=1.06U
M$106 VSS VSS VSS VSS nfet_03v3 L=2U W=0.5U AS=0.14P AD=0.14P PS=1.06U PD=1.06U
M$107 VSS VSS VSS VSS nfet_03v3 L=2U W=0.5U AS=0.14P AD=0.14P PS=1.06U PD=1.06U
M$108 VSS VSS VSS VSS nfet_03v3 L=2U W=0.5U AS=0.14P AD=0.14P PS=1.06U PD=1.06U
M$109 VSS VSS VSS VSS nfet_03v3 L=2U W=0.5U AS=0.14P AD=0.14P PS=1.06U PD=1.06U
M$110 VSS VSS VSS VSS nfet_03v3 L=2U W=0.5U AS=0.14P AD=0.14P PS=1.06U PD=1.06U
M$111 VSS VSS VSS VSS nfet_03v3 L=2U W=0.5U AS=0.14P AD=0.14P PS=1.06U PD=1.06U
M$112 VSS VSS VSS VSS nfet_03v3 L=2U W=0.5U AS=0.14P AD=0.14P PS=1.06U PD=1.06U
M$113 VSS VSS VSS VSS nfet_03v3 L=2U W=0.5U AS=0.14P AD=0.14P PS=1.06U PD=1.06U
M$114 VSS VSS VSS VSS nfet_03v3 L=2U W=0.5U AS=0.14P AD=0.14P PS=1.06U PD=1.06U
M$115 VSS VSS VSS VSS nfet_03v3 L=2U W=0.5U AS=0.14P AD=0.14P PS=1.06U PD=1.06U
M$116 VSS VSS VSS VSS nfet_03v3 L=2U W=0.5U AS=0.14P AD=0.14P PS=1.06U PD=1.06U
M$117 VSS VSS VSS VSS nfet_03v3 L=2U W=0.5U AS=0.14P AD=0.14P PS=1.06U PD=1.06U
M$118 VSS VSS VSS VSS nfet_03v3 L=2U W=0.5U AS=0.14P AD=0.14P PS=1.06U PD=1.06U
M$119 VSS VSS VSS VSS nfet_03v3 L=2U W=0.5U AS=0.14P AD=0.14P PS=1.06U PD=1.06U
M$120 VSS VSS VSS VSS nfet_03v3 L=2U W=0.5U AS=0.14P AD=0.14P PS=1.06U PD=1.06U
M$121 VSS VSS VSS VSS nfet_03v3 L=2U W=0.5U AS=0.14P AD=0.14P PS=1.06U PD=1.06U
M$122 VSS VSS VSS VSS nfet_03v3 L=2U W=0.5U AS=0.14P AD=0.14P PS=1.06U PD=1.06U
M$123 VSS VSS VSS VSS nfet_03v3 L=2U W=0.5U AS=0.14P AD=0.14P PS=1.06U PD=1.06U
M$124 VSS VSS VSS VSS nfet_03v3 L=2U W=0.5U AS=0.14P AD=0.14P PS=1.06U PD=1.06U
M$125 VSS VSS VSS VSS nfet_03v3 L=2U W=0.5U AS=0.14P AD=0.14P PS=1.06U PD=1.06U
M$126 VSS VSS VSS VSS nfet_03v3 L=2U W=0.5U AS=0.14P AD=0.14P PS=1.06U PD=1.06U
M$127 VSS VSS VSS VSS nfet_03v3 L=2U W=0.5U AS=0.14P AD=0.14P PS=1.06U PD=1.06U
M$128 VSS VSS VSS VSS nfet_03v3 L=2U W=0.5U AS=0.14P AD=0.14P PS=1.06U PD=1.06U
M$129 VSS VSS VSS VSS nfet_03v3 L=2U W=0.5U AS=0.14P AD=0.14P PS=1.06U PD=1.06U
M$130 VSS VSS VSS VSS nfet_03v3 L=2U W=0.5U AS=0.14P AD=0.14P PS=1.06U PD=1.06U
M$131 VSS VSS VSS VSS nfet_03v3 L=2U W=0.5U AS=0.14P AD=0.14P PS=1.06U PD=1.06U
M$132 VSS VSS VSS VSS nfet_03v3 L=2U W=0.5U AS=0.14P AD=0.14P PS=1.06U PD=1.06U
M$133 VSS VSS VSS VSS nfet_03v3 L=2U W=0.5U AS=0.14P AD=0.14P PS=1.06U PD=1.06U
M$134 VSS VSS VSS VSS nfet_03v3 L=2U W=0.5U AS=0.14P AD=0.14P PS=1.06U PD=1.06U
M$135 VSS VSS VSS VSS nfet_03v3 L=2U W=0.5U AS=0.14P AD=0.14P PS=1.06U PD=1.06U
M$136 VSS VSS VSS VSS nfet_03v3 L=2U W=0.5U AS=0.14P AD=0.14P PS=1.06U PD=1.06U
M$137 VSS VSS VSS VSS nfet_03v3 L=2U W=0.5U AS=0.14P AD=0.14P PS=1.06U PD=1.06U
M$138 VSS VSS VSS VSS nfet_03v3 L=2U W=0.5U AS=0.14P AD=0.14P PS=1.06U PD=1.06U
M$139 VSS VSS VSS VSS nfet_03v3 L=2U W=0.5U AS=0.14P AD=0.14P PS=1.06U PD=1.06U
M$140 VSS VSS VSS VSS nfet_03v3 L=2U W=0.5U AS=0.14P AD=0.14P PS=1.06U PD=1.06U
M$141 VSS VSS VSS VSS nfet_03v3 L=2U W=0.5U AS=0.14P AD=0.14P PS=1.06U PD=1.06U
M$142 VSS VSS VSS VSS nfet_03v3 L=2U W=0.5U AS=0.14P AD=0.14P PS=1.06U PD=1.06U
M$143 VSS VSS VSS VSS nfet_03v3 L=2U W=0.5U AS=0.14P AD=0.14P PS=1.06U PD=1.06U
M$144 VSS VSS VSS VSS nfet_03v3 L=2U W=0.5U AS=0.14P AD=0.14P PS=1.06U PD=1.06U
M$145 VSS VSS VSS VSS nfet_03v3 L=2U W=0.5U AS=0.14P AD=0.14P PS=1.06U PD=1.06U
M$146 VSS VSS VSS VSS nfet_03v3 L=2U W=0.5U AS=0.14P AD=0.14P PS=1.06U PD=1.06U
M$147 VSS VSS VSS VSS nfet_03v3 L=2U W=0.5U AS=0.14P AD=0.14P PS=1.06U PD=1.06U
M$148 VSS VSS VSS VSS nfet_03v3 L=2U W=0.5U AS=0.14P AD=0.14P PS=1.06U PD=1.06U
M$149 VSS VSS VSS VSS nfet_03v3 L=2U W=0.5U AS=0.14P AD=0.14P PS=1.06U PD=1.06U
M$150 VSS VSS VSS VSS nfet_03v3 L=2U W=0.5U AS=0.14P AD=0.14P PS=1.06U PD=1.06U
M$151 VSS VSS VSS VSS nfet_03v3 L=2U W=0.5U AS=0.14P AD=0.14P PS=1.06U PD=1.06U
M$152 VSS VSS VSS VSS nfet_03v3 L=2U W=0.5U AS=0.14P AD=0.14P PS=1.06U PD=1.06U
M$153 VSS VSS VSS VSS nfet_03v3 L=2U W=0.5U AS=0.14P AD=0.14P PS=1.06U PD=1.06U
M$154 VSS VSS VSS VSS nfet_03v3 L=2U W=0.5U AS=0.14P AD=0.14P PS=1.06U PD=1.06U
M$155 VSS VSS VSS VSS nfet_03v3 L=2U W=0.5U AS=0.14P AD=0.14P PS=1.06U PD=1.06U
M$156 VSS VSS VSS VSS nfet_03v3 L=2U W=0.5U AS=0.14P AD=0.14P PS=1.06U PD=1.06U
M$157 VSS VSS VSS VSS nfet_03v3 L=2U W=0.5U AS=0.14P AD=0.14P PS=1.06U PD=1.06U
M$158 VSS VSS VSS VSS nfet_03v3 L=2U W=0.5U AS=0.14P AD=0.14P PS=1.06U PD=1.06U
M$159 VSS VSS VSS VSS nfet_03v3 L=2U W=0.5U AS=0.14P AD=0.14P PS=1.06U PD=1.06U
M$160 VSS VSS VSS VSS nfet_03v3 L=2U W=0.5U AS=0.14P AD=0.14P PS=1.06U PD=1.06U
M$161 VSS VSS VSS VSS nfet_03v3 L=2U W=0.5U AS=0.14P AD=0.14P PS=1.06U PD=1.06U
M$162 VSS VSS VSS VSS nfet_03v3 L=2U W=0.5U AS=0.14P AD=0.14P PS=1.06U PD=1.06U
M$163 VSS VSS VSS VSS nfet_03v3 L=2U W=0.5U AS=0.14P AD=0.14P PS=1.06U PD=1.06U
M$164 VSS VSS VSS VSS nfet_03v3 L=2U W=0.5U AS=0.14P AD=0.14P PS=1.06U PD=1.06U
M$165 VSS VSS VSS VSS nfet_03v3 L=2U W=0.5U AS=0.14P AD=0.14P PS=1.06U PD=1.06U
M$166 VSS VSS VSS VSS nfet_03v3 L=2U W=0.5U AS=0.14P AD=0.14P PS=1.06U PD=1.06U
M$167 VSS VSS VSS VSS nfet_03v3 L=2U W=0.5U AS=0.14P AD=0.14P PS=1.06U PD=1.06U
M$168 VSS VSS VSS VSS nfet_03v3 L=2U W=0.5U AS=0.14P AD=0.3P PS=1.06U PD=2.2U
M$169 \$91 en \$90 VSS nfet_03v3 L=0.64U W=0.5U AS=0.3P AD=0.3P PS=2.2U PD=2.2U
M$170 Isum_e \$6 \$91 VSS nfet_03v3 L=0.64U W=0.5U AS=0.3P AD=0.3P PS=2.2U
+ PD=2.2U
M$171 Isum_i s \$91 VSS nfet_03v3 L=0.64U W=0.5U AS=0.3P AD=0.3P PS=2.2U PD=2.2U
M$172 \$94 Vb VSS VSS nfet_03v3 L=8U W=1U AS=0.6P AD=0.6P PS=3.2U PD=3.2U
M$173 \$95 Vb VSS VSS nfet_03v3 L=8U W=1U AS=0.6P AD=0.6P PS=3.2U PD=3.2U
M$174 \$94 Vb VSS VSS nfet_03v3 L=8U W=1U AS=0.6P AD=0.6P PS=3.2U PD=3.2U
M$175 \$96 Vb VSS VSS nfet_03v3 L=8U W=1U AS=0.6P AD=0.6P PS=3.2U PD=3.2U
M$176 \$94 Vb VSS VSS nfet_03v3 L=8U W=1U AS=0.6P AD=0.6P PS=3.2U PD=3.2U
M$177 \$95 Vb VSS VSS nfet_03v3 L=8U W=1U AS=0.6P AD=0.6P PS=3.2U PD=3.2U
M$178 \$94 Vb VSS VSS nfet_03v3 L=8U W=1U AS=0.6P AD=0.6P PS=3.2U PD=3.2U
M$179 \$97 Vb VSS VSS nfet_03v3 L=8U W=1U AS=0.6P AD=0.6P PS=3.2U PD=3.2U
M$180 \$94 Vb VSS VSS nfet_03v3 L=8U W=1U AS=0.6P AD=0.6P PS=3.2U PD=3.2U
M$181 \$95 Vb VSS VSS nfet_03v3 L=8U W=1U AS=0.6P AD=0.6P PS=3.2U PD=3.2U
M$182 \$94 Vb VSS VSS nfet_03v3 L=8U W=1U AS=0.6P AD=0.6P PS=3.2U PD=3.2U
M$183 \$96 Vb VSS VSS nfet_03v3 L=8U W=1U AS=0.6P AD=0.6P PS=3.2U PD=3.2U
M$184 \$94 Vb VSS VSS nfet_03v3 L=8U W=1U AS=0.6P AD=0.6P PS=3.2U PD=3.2U
M$185 \$95 Vb VSS VSS nfet_03v3 L=8U W=1U AS=0.6P AD=0.6P PS=3.2U PD=3.2U
M$186 \$94 Vb VSS VSS nfet_03v3 L=8U W=1U AS=0.6P AD=0.6P PS=3.2U PD=3.2U
M$187 \$6 s VSS VSS nfet_03v3 L=0.64U W=0.5U AS=0.3P AD=0.3P PS=2.2U PD=2.2U
M$188 \$90 w[0] \$97 VSS nfet_03v3 L=0.64U W=0.5U AS=0.3P AD=0.3P PS=2.2U
+ PD=2.2U
M$189 \$90 w[1] \$96 VSS nfet_03v3 L=0.64U W=0.5U AS=0.3P AD=0.14P PS=2.2U
+ PD=1.06U
M$190 \$96 w[1] \$90 VSS nfet_03v3 L=0.64U W=0.5U AS=0.14P AD=0.3P PS=1.06U
+ PD=2.2U
M$191 \$90 w[2] \$95 VSS nfet_03v3 L=0.64U W=0.5U AS=0.3P AD=0.14P PS=2.2U
+ PD=1.06U
M$192 \$95 w[2] \$90 VSS nfet_03v3 L=0.64U W=0.5U AS=0.14P AD=0.14P PS=1.06U
+ PD=1.06U
M$193 \$90 w[2] \$95 VSS nfet_03v3 L=0.64U W=0.5U AS=0.14P AD=0.14P PS=1.06U
+ PD=1.06U
M$194 \$95 w[2] \$90 VSS nfet_03v3 L=0.64U W=0.5U AS=0.14P AD=0.3P PS=1.06U
+ PD=2.2U
M$195 \$90 w[3] \$94 VSS nfet_03v3 L=0.64U W=0.5U AS=0.3P AD=0.14P PS=2.2U
+ PD=1.06U
M$196 \$94 w[3] \$90 VSS nfet_03v3 L=0.64U W=0.5U AS=0.14P AD=0.14P PS=1.06U
+ PD=1.06U
M$197 \$90 w[3] \$94 VSS nfet_03v3 L=0.64U W=0.5U AS=0.14P AD=0.14P PS=1.06U
+ PD=1.06U
M$198 \$94 w[3] \$90 VSS nfet_03v3 L=0.64U W=0.5U AS=0.14P AD=0.14P PS=1.06U
+ PD=1.06U
M$199 \$90 w[3] \$94 VSS nfet_03v3 L=0.64U W=0.5U AS=0.14P AD=0.14P PS=1.06U
+ PD=1.06U
M$200 \$94 w[3] \$90 VSS nfet_03v3 L=0.64U W=0.5U AS=0.14P AD=0.14P PS=1.06U
+ PD=1.06U
M$201 \$90 w[3] \$94 VSS nfet_03v3 L=0.64U W=0.5U AS=0.14P AD=0.14P PS=1.06U
+ PD=1.06U
M$202 \$94 w[3] \$90 VSS nfet_03v3 L=0.64U W=0.5U AS=0.14P AD=0.3P PS=1.06U
+ PD=2.2U
M$203 VSS VSS VSS VSS nfet_03v3 L=2U W=1U AS=0.6P AD=0.6P PS=3.2U PD=3.2U
.ENDS DAC
