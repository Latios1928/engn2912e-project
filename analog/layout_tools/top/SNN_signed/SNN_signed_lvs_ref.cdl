* LVS reference for DAC.gds (glayout_floorplan.two_row)
* note: x1_M1: 0.22/0.28 -> 0.5/0.64 (W/L kept)
* note: x1_M3: 0.22/0.28 -> 0.5/0.64 (W/L kept)
* note: x1_M5: 0.22/0.28 -> 0.5/0.64 (W/L kept)
* note: x1_M7: 0.22/0.28 -> 0.5/0.64 (W/L kept)
* note: x1_Men: 0.22/0.28 -> 0.5/0.64 (W/L kept)
* note: Mse: 0.22/0.28 -> 0.5/0.64 (W/L kept)
* note: Msi: 0.22/0.28 -> 0.5/0.64 (W/L kept)
* note: Mpi: 0.44/0.28 -> 0.5/0.32 (W/L kept)
* note: Mni: 0.22/0.28 -> 0.5/0.64 (W/L kept)
* note: G3 common-centroid, 15 units: D C D B D C D A D C D B D C D (A=x1_M2 x1, B=x1_M4 x2, C=x1_M6 x4, D=x1_M8 x8)
* note: ground net GND drawn as VSS
.subckt DAC Isum_e w[3] w[2] w[1] w[0] en s Vb Isum_i VDD VSS
Mx1_Men Y en x1_X VSS nfet_03v3 L=0.64u W=0.5u nf=1
MMse Isum_e sb Y VSS nfet_03v3 L=0.64u W=0.5u nf=1
MMsi Isum_i s Y VSS nfet_03v3 L=0.64u W=0.5u nf=1
Mx1_M8_u0 x1_net1 Vb VSS VSS nfet_03v3 L=8u W=1u nf=1
Mx1_M6_u0 x1_net3 Vb VSS VSS nfet_03v3 L=8u W=1u nf=1
Mx1_M8_u1 x1_net1 Vb VSS VSS nfet_03v3 L=8u W=1u nf=1
Mx1_M4_u0 x1_net2 Vb VSS VSS nfet_03v3 L=8u W=1u nf=1
Mx1_M8_u2 x1_net1 Vb VSS VSS nfet_03v3 L=8u W=1u nf=1
Mx1_M6_u1 x1_net3 Vb VSS VSS nfet_03v3 L=8u W=1u nf=1
Mx1_M8_u3 x1_net1 Vb VSS VSS nfet_03v3 L=8u W=1u nf=1
Mx1_M2_u0 x1_net4 Vb VSS VSS nfet_03v3 L=8u W=1u nf=1
Mx1_M8_u4 x1_net1 Vb VSS VSS nfet_03v3 L=8u W=1u nf=1
Mx1_M6_u2 x1_net3 Vb VSS VSS nfet_03v3 L=8u W=1u nf=1
Mx1_M8_u5 x1_net1 Vb VSS VSS nfet_03v3 L=8u W=1u nf=1
Mx1_M4_u1 x1_net2 Vb VSS VSS nfet_03v3 L=8u W=1u nf=1
Mx1_M8_u6 x1_net1 Vb VSS VSS nfet_03v3 L=8u W=1u nf=1
Mx1_M6_u3 x1_net3 Vb VSS VSS nfet_03v3 L=8u W=1u nf=1
Mx1_M8_u7 x1_net1 Vb VSS VSS nfet_03v3 L=8u W=1u nf=1
MMni sb s VSS VSS nfet_03v3 L=0.64u W=0.5u nf=1
Mx1_M1 x1_X w[0] x1_net4 VSS nfet_03v3 L=0.64u W=0.5u nf=1
Mx1_M3_f0 x1_X w[1] x1_net2 VSS nfet_03v3 L=0.64u W=0.5u nf=1
Mx1_M3_f1 x1_X w[1] x1_net2 VSS nfet_03v3 L=0.64u W=0.5u nf=1
Mx1_M5_f0 x1_X w[2] x1_net3 VSS nfet_03v3 L=0.64u W=0.5u nf=1
Mx1_M5_f1 x1_X w[2] x1_net3 VSS nfet_03v3 L=0.64u W=0.5u nf=1
Mx1_M5_f2 x1_X w[2] x1_net3 VSS nfet_03v3 L=0.64u W=0.5u nf=1
Mx1_M5_f3 x1_X w[2] x1_net3 VSS nfet_03v3 L=0.64u W=0.5u nf=1
Mx1_M7_f0 x1_X w[3] x1_net1 VSS nfet_03v3 L=0.64u W=0.5u nf=1
Mx1_M7_f1 x1_X w[3] x1_net1 VSS nfet_03v3 L=0.64u W=0.5u nf=1
Mx1_M7_f2 x1_X w[3] x1_net1 VSS nfet_03v3 L=0.64u W=0.5u nf=1
Mx1_M7_f3 x1_X w[3] x1_net1 VSS nfet_03v3 L=0.64u W=0.5u nf=1
Mx1_M7_f4 x1_X w[3] x1_net1 VSS nfet_03v3 L=0.64u W=0.5u nf=1
Mx1_M7_f5 x1_X w[3] x1_net1 VSS nfet_03v3 L=0.64u W=0.5u nf=1
Mx1_M7_f6 x1_X w[3] x1_net1 VSS nfet_03v3 L=0.64u W=0.5u nf=1
Mx1_M7_f7 x1_X w[3] x1_net1 VSS nfet_03v3 L=0.64u W=0.5u nf=1
MMpi sb s VDD VDD pfet_03v3 L=0.32u W=0.5u nf=1
MDNN0 VSS VSS VSS VSS nfet_03v3 L=2u W=0.5u nf=1
MDNN1 VSS VSS VSS VSS nfet_03v3 L=2u W=0.5u nf=1
MDNN2 VSS VSS VSS VSS nfet_03v3 L=2u W=0.5u nf=1
MDNN3 VSS VSS VSS VSS nfet_03v3 L=2u W=0.5u nf=1
MDNN4 VSS VSS VSS VSS nfet_03v3 L=2u W=0.5u nf=1
MDNN5 VSS VSS VSS VSS nfet_03v3 L=2u W=0.5u nf=1
MDNN6 VSS VSS VSS VSS nfet_03v3 L=2u W=0.5u nf=1
MDNN7 VSS VSS VSS VSS nfet_03v3 L=2u W=0.5u nf=1
MDNN8 VSS VSS VSS VSS nfet_03v3 L=2u W=0.5u nf=1
MDNN9 VSS VSS VSS VSS nfet_03v3 L=2u W=0.5u nf=1
MDNN10 VSS VSS VSS VSS nfet_03v3 L=2u W=0.5u nf=1
MDNN11 VSS VSS VSS VSS nfet_03v3 L=2u W=0.5u nf=1
MDNN12 VSS VSS VSS VSS nfet_03v3 L=2u W=0.5u nf=1
MDNN13 VSS VSS VSS VSS nfet_03v3 L=2u W=0.5u nf=1
MDNN14 VSS VSS VSS VSS nfet_03v3 L=2u W=0.5u nf=1
MDNN15 VSS VSS VSS VSS nfet_03v3 L=2u W=0.5u nf=1
MDNN16 VSS VSS VSS VSS nfet_03v3 L=2u W=0.5u nf=1
MDNN17 VSS VSS VSS VSS nfet_03v3 L=2u W=0.5u nf=1
MDNN18 VSS VSS VSS VSS nfet_03v3 L=2u W=0.5u nf=1
MDNN19 VSS VSS VSS VSS nfet_03v3 L=2u W=0.5u nf=1
MDNN20 VSS VSS VSS VSS nfet_03v3 L=2u W=0.5u nf=1
MDNN21 VSS VSS VSS VSS nfet_03v3 L=2u W=0.5u nf=1
MDNN22 VSS VSS VSS VSS nfet_03v3 L=2u W=0.5u nf=1
MDNN23 VSS VSS VSS VSS nfet_03v3 L=2u W=0.5u nf=1
MDNN24 VSS VSS VSS VSS nfet_03v3 L=2u W=0.5u nf=1
MDNN25 VSS VSS VSS VSS nfet_03v3 L=2u W=0.5u nf=1
MDNN26 VSS VSS VSS VSS nfet_03v3 L=2u W=0.5u nf=1
MDNN27 VSS VSS VSS VSS nfet_03v3 L=2u W=0.5u nf=1
MDNN28 VSS VSS VSS VSS nfet_03v3 L=2u W=0.5u nf=1
MDNN29 VSS VSS VSS VSS nfet_03v3 L=2u W=0.5u nf=1
MDNN30 VSS VSS VSS VSS nfet_03v3 L=2u W=0.5u nf=1
MDNN31 VSS VSS VSS VSS nfet_03v3 L=2u W=0.5u nf=1
MDNN32 VSS VSS VSS VSS nfet_03v3 L=2u W=0.5u nf=1
MDNN33 VSS VSS VSS VSS nfet_03v3 L=2u W=0.5u nf=1
MDNN34 VSS VSS VSS VSS nfet_03v3 L=2u W=0.5u nf=1
MDNN35 VSS VSS VSS VSS nfet_03v3 L=2u W=0.5u nf=1
MDNN36 VSS VSS VSS VSS nfet_03v3 L=2u W=0.5u nf=1
MDNN37 VSS VSS VSS VSS nfet_03v3 L=2u W=0.5u nf=1
MDNN38 VSS VSS VSS VSS nfet_03v3 L=2u W=0.5u nf=1
MDNN39 VSS VSS VSS VSS nfet_03v3 L=2u W=0.5u nf=1
MDNN40 VSS VSS VSS VSS nfet_03v3 L=2u W=0.5u nf=1
MDNN41 VSS VSS VSS VSS nfet_03v3 L=2u W=0.5u nf=1
MDNN42 VSS VSS VSS VSS nfet_03v3 L=2u W=0.5u nf=1
MDNN43 VSS VSS VSS VSS nfet_03v3 L=2u W=0.5u nf=1
MDNN44 VSS VSS VSS VSS nfet_03v3 L=2u W=0.5u nf=1
MDNN45 VSS VSS VSS VSS nfet_03v3 L=2u W=0.5u nf=1
MDNN46 VSS VSS VSS VSS nfet_03v3 L=2u W=0.5u nf=1
MDNN47 VSS VSS VSS VSS nfet_03v3 L=2u W=0.5u nf=1
MDNN48 VSS VSS VSS VSS nfet_03v3 L=2u W=0.5u nf=1
MDNN49 VSS VSS VSS VSS nfet_03v3 L=2u W=0.5u nf=1
MDNN50 VSS VSS VSS VSS nfet_03v3 L=2u W=0.5u nf=1
MDNN51 VSS VSS VSS VSS nfet_03v3 L=2u W=0.5u nf=1
MDNN52 VSS VSS VSS VSS nfet_03v3 L=2u W=0.5u nf=1
MDNN53 VSS VSS VSS VSS nfet_03v3 L=2u W=0.5u nf=1
MDNN54 VSS VSS VSS VSS nfet_03v3 L=2u W=0.5u nf=1
MDNN55 VSS VSS VSS VSS nfet_03v3 L=2u W=0.5u nf=1
MDNN56 VSS VSS VSS VSS nfet_03v3 L=2u W=0.5u nf=1
MDNN57 VSS VSS VSS VSS nfet_03v3 L=2u W=0.5u nf=1
MDNN58 VSS VSS VSS VSS nfet_03v3 L=2u W=0.5u nf=1
MDNN59 VSS VSS VSS VSS nfet_03v3 L=2u W=0.5u nf=1
MDNN60 VSS VSS VSS VSS nfet_03v3 L=2u W=0.5u nf=1
MDNN61 VSS VSS VSS VSS nfet_03v3 L=2u W=0.5u nf=1
MDNN62 VSS VSS VSS VSS nfet_03v3 L=2u W=0.5u nf=1
MDNN63 VSS VSS VSS VSS nfet_03v3 L=2u W=0.5u nf=1
MDNN64 VSS VSS VSS VSS nfet_03v3 L=2u W=0.5u nf=1
MDNN65 VSS VSS VSS VSS nfet_03v3 L=2u W=0.5u nf=1
MDNN66 VSS VSS VSS VSS nfet_03v3 L=2u W=0.5u nf=1
MDNN67 VSS VSS VSS VSS nfet_03v3 L=2u W=0.5u nf=1
MDNN68 VSS VSS VSS VSS nfet_03v3 L=2u W=0.5u nf=1
MDNN69 VSS VSS VSS VSS nfet_03v3 L=2u W=0.5u nf=1
MDNN70 VSS VSS VSS VSS nfet_03v3 L=2u W=0.5u nf=1
MDNN71 VSS VSS VSS VSS nfet_03v3 L=2u W=0.5u nf=1
MDNN72 VSS VSS VSS VSS nfet_03v3 L=2u W=0.5u nf=1
MDNN73 VSS VSS VSS VSS nfet_03v3 L=2u W=0.5u nf=1
MDNN74 VSS VSS VSS VSS nfet_03v3 L=2u W=0.5u nf=1
MDNN75 VSS VSS VSS VSS nfet_03v3 L=2u W=0.5u nf=1
MDNN76 VSS VSS VSS VSS nfet_03v3 L=2u W=0.5u nf=1
MDNN77 VSS VSS VSS VSS nfet_03v3 L=2u W=0.5u nf=1
MDNN78 VSS VSS VSS VSS nfet_03v3 L=2u W=0.5u nf=1
MDNS0 VSS VSS VSS VSS nfet_03v3 L=2u W=0.5u nf=1
MDNS1 VSS VSS VSS VSS nfet_03v3 L=2u W=0.5u nf=1
MDNS2 VSS VSS VSS VSS nfet_03v3 L=2u W=0.5u nf=1
MDNS3 VSS VSS VSS VSS nfet_03v3 L=2u W=0.5u nf=1
MDNS4 VSS VSS VSS VSS nfet_03v3 L=2u W=0.5u nf=1
MDNS5 VSS VSS VSS VSS nfet_03v3 L=2u W=0.5u nf=1
MDNS6 VSS VSS VSS VSS nfet_03v3 L=2u W=0.5u nf=1
MDNS7 VSS VSS VSS VSS nfet_03v3 L=2u W=0.5u nf=1
MDNS8 VSS VSS VSS VSS nfet_03v3 L=2u W=0.5u nf=1
MDNS9 VSS VSS VSS VSS nfet_03v3 L=2u W=0.5u nf=1
MDNS10 VSS VSS VSS VSS nfet_03v3 L=2u W=0.5u nf=1
MDNS11 VSS VSS VSS VSS nfet_03v3 L=2u W=0.5u nf=1
MDNS12 VSS VSS VSS VSS nfet_03v3 L=2u W=0.5u nf=1
MDNS13 VSS VSS VSS VSS nfet_03v3 L=2u W=0.5u nf=1
MDNS14 VSS VSS VSS VSS nfet_03v3 L=2u W=0.5u nf=1
MDNS15 VSS VSS VSS VSS nfet_03v3 L=2u W=0.5u nf=1
MDNS16 VSS VSS VSS VSS nfet_03v3 L=2u W=0.5u nf=1
MDNS17 VSS VSS VSS VSS nfet_03v3 L=2u W=0.5u nf=1
MDNS18 VSS VSS VSS VSS nfet_03v3 L=2u W=0.5u nf=1
MDNS19 VSS VSS VSS VSS nfet_03v3 L=2u W=0.5u nf=1
MDNS20 VSS VSS VSS VSS nfet_03v3 L=2u W=0.5u nf=1
MDNS21 VSS VSS VSS VSS nfet_03v3 L=2u W=0.5u nf=1
MDNS22 VSS VSS VSS VSS nfet_03v3 L=2u W=0.5u nf=1
MDNS23 VSS VSS VSS VSS nfet_03v3 L=2u W=0.5u nf=1
MDNS24 VSS VSS VSS VSS nfet_03v3 L=2u W=0.5u nf=1
MDNS25 VSS VSS VSS VSS nfet_03v3 L=2u W=0.5u nf=1
MDNS26 VSS VSS VSS VSS nfet_03v3 L=2u W=0.5u nf=1
MDNS27 VSS VSS VSS VSS nfet_03v3 L=2u W=0.5u nf=1
MDNS28 VSS VSS VSS VSS nfet_03v3 L=2u W=0.5u nf=1
MDNS29 VSS VSS VSS VSS nfet_03v3 L=2u W=0.5u nf=1
MDNS30 VSS VSS VSS VSS nfet_03v3 L=2u W=0.5u nf=1
MDNS31 VSS VSS VSS VSS nfet_03v3 L=2u W=0.5u nf=1
MDNS32 VSS VSS VSS VSS nfet_03v3 L=2u W=0.5u nf=1
MDNS33 VSS VSS VSS VSS nfet_03v3 L=2u W=0.5u nf=1
MDNS34 VSS VSS VSS VSS nfet_03v3 L=2u W=0.5u nf=1
MDNS35 VSS VSS VSS VSS nfet_03v3 L=2u W=0.5u nf=1
MDNS36 VSS VSS VSS VSS nfet_03v3 L=2u W=0.5u nf=1
MDNS37 VSS VSS VSS VSS nfet_03v3 L=2u W=0.5u nf=1
MDNS38 VSS VSS VSS VSS nfet_03v3 L=2u W=0.5u nf=1
MDNS39 VSS VSS VSS VSS nfet_03v3 L=2u W=0.5u nf=1
MDNS40 VSS VSS VSS VSS nfet_03v3 L=2u W=0.5u nf=1
MDNS41 VSS VSS VSS VSS nfet_03v3 L=2u W=0.5u nf=1
MDNS42 VSS VSS VSS VSS nfet_03v3 L=2u W=0.5u nf=1
MDNS43 VSS VSS VSS VSS nfet_03v3 L=2u W=0.5u nf=1
MDNS44 VSS VSS VSS VSS nfet_03v3 L=2u W=0.5u nf=1
MDNS45 VSS VSS VSS VSS nfet_03v3 L=2u W=0.5u nf=1
MDNS46 VSS VSS VSS VSS nfet_03v3 L=2u W=0.5u nf=1
MDNS47 VSS VSS VSS VSS nfet_03v3 L=2u W=0.5u nf=1
MDNS48 VSS VSS VSS VSS nfet_03v3 L=2u W=0.5u nf=1
MDNS49 VSS VSS VSS VSS nfet_03v3 L=2u W=0.5u nf=1
MDNS50 VSS VSS VSS VSS nfet_03v3 L=2u W=0.5u nf=1
MDNS51 VSS VSS VSS VSS nfet_03v3 L=2u W=0.5u nf=1
MDNS52 VSS VSS VSS VSS nfet_03v3 L=2u W=0.5u nf=1
MDNS53 VSS VSS VSS VSS nfet_03v3 L=2u W=0.5u nf=1
MDNS54 VSS VSS VSS VSS nfet_03v3 L=2u W=0.5u nf=1
MDNS55 VSS VSS VSS VSS nfet_03v3 L=2u W=0.5u nf=1
MDNS56 VSS VSS VSS VSS nfet_03v3 L=2u W=0.5u nf=1
MDNS57 VSS VSS VSS VSS nfet_03v3 L=2u W=0.5u nf=1
MDNS58 VSS VSS VSS VSS nfet_03v3 L=2u W=0.5u nf=1
MDNS59 VSS VSS VSS VSS nfet_03v3 L=2u W=0.5u nf=1
MDNS60 VSS VSS VSS VSS nfet_03v3 L=2u W=0.5u nf=1
MDNS61 VSS VSS VSS VSS nfet_03v3 L=2u W=0.5u nf=1
MDNS62 VSS VSS VSS VSS nfet_03v3 L=2u W=0.5u nf=1
MDNS63 VSS VSS VSS VSS nfet_03v3 L=2u W=0.5u nf=1
MDNS64 VSS VSS VSS VSS nfet_03v3 L=2u W=0.5u nf=1
MDNS65 VSS VSS VSS VSS nfet_03v3 L=2u W=0.5u nf=1
MDNS66 VSS VSS VSS VSS nfet_03v3 L=2u W=0.5u nf=1
MDNS67 VSS VSS VSS VSS nfet_03v3 L=2u W=0.5u nf=1
MDNS68 VSS VSS VSS VSS nfet_03v3 L=2u W=0.5u nf=1
MDNS69 VSS VSS VSS VSS nfet_03v3 L=2u W=0.5u nf=1
MDNS70 VSS VSS VSS VSS nfet_03v3 L=2u W=0.5u nf=1
MDNS71 VSS VSS VSS VSS nfet_03v3 L=2u W=0.5u nf=1
MDNS72 VSS VSS VSS VSS nfet_03v3 L=2u W=0.5u nf=1
MDNS73 VSS VSS VSS VSS nfet_03v3 L=2u W=0.5u nf=1
MDNS74 VSS VSS VSS VSS nfet_03v3 L=2u W=0.5u nf=1
MDNS75 VSS VSS VSS VSS nfet_03v3 L=2u W=0.5u nf=1
MDNS76 VSS VSS VSS VSS nfet_03v3 L=2u W=0.5u nf=1
MDNS77 VSS VSS VSS VSS nfet_03v3 L=2u W=0.5u nf=1
MDNS78 VSS VSS VSS VSS nfet_03v3 L=2u W=0.5u nf=1
MDNW0 VSS VSS VSS VSS nfet_03v3 L=2u W=1u nf=1
MDNE0 VSS VSS VSS VSS nfet_03v3 L=2u W=1u nf=1
MDPN0 VDD VDD VDD VDD pfet_03v3 L=2u W=0.5u nf=1
MDPN1 VDD VDD VDD VDD pfet_03v3 L=2u W=0.5u nf=1
MDPN2 VDD VDD VDD VDD pfet_03v3 L=2u W=0.5u nf=1
MDPS0 VDD VDD VDD VDD pfet_03v3 L=2u W=0.5u nf=1
MDPS1 VDD VDD VDD VDD pfet_03v3 L=2u W=0.5u nf=1
MDPS2 VDD VDD VDD VDD pfet_03v3 L=2u W=0.5u nf=1
MDPW0 VDD VDD VDD VDD pfet_03v3 L=2u W=0.5u nf=1
MDPE0 VDD VDD VDD VDD pfet_03v3 L=2u W=0.5u nf=1
.ends

* LVS reference for DPI.gds (glayout_floorplan.two_row)
.subckt DPI VDD Vthr Isyn Isum VT VSS
MM1 VDD Vthr Isum Isum nfet_03v3 L=5.12u W=4u nf=1
MM2 net1 net1 Isum Isum nfet_03v3 L=5.12u W=4u nf=1
MM3 net1 VT VDD VDD pfet_03v3 L=5.12u W=4u nf=1
MM4 Isyn net1 VDD VDD pfet_03v3 L=5.12u W=4u nf=1
C2 VDD net1 cap_mim_2f0fF W=22.18e-6 L=22.18e-6 m=1
MDNI0N0 Isum Isum Isum Isum nfet_03v3 L=2u W=0.5u nf=1
MDNI0N1 Isum Isum Isum Isum nfet_03v3 L=2u W=0.5u nf=1
MDNI0N2 Isum Isum Isum Isum nfet_03v3 L=2u W=0.5u nf=1
MDNI0N3 Isum Isum Isum Isum nfet_03v3 L=2u W=0.5u nf=1
MDNI0N4 Isum Isum Isum Isum nfet_03v3 L=2u W=0.5u nf=1
MDNI0N5 Isum Isum Isum Isum nfet_03v3 L=2u W=0.5u nf=1
MDNI0N6 Isum Isum Isum Isum nfet_03v3 L=2u W=0.5u nf=1
MDNI0N7 Isum Isum Isum Isum nfet_03v3 L=2u W=0.5u nf=1
MDNI0S0 Isum Isum Isum Isum nfet_03v3 L=2u W=0.5u nf=1
MDNI0S1 Isum Isum Isum Isum nfet_03v3 L=2u W=0.5u nf=1
MDNI0S2 Isum Isum Isum Isum nfet_03v3 L=2u W=0.5u nf=1
MDNI0S3 Isum Isum Isum Isum nfet_03v3 L=2u W=0.5u nf=1
MDNI0S4 Isum Isum Isum Isum nfet_03v3 L=2u W=0.5u nf=1
MDNI0S5 Isum Isum Isum Isum nfet_03v3 L=2u W=0.5u nf=1
MDNI0S6 Isum Isum Isum Isum nfet_03v3 L=2u W=0.5u nf=1
MDNI0S7 Isum Isum Isum Isum nfet_03v3 L=2u W=0.5u nf=1
MDNI0W0 Isum Isum Isum Isum nfet_03v3 L=2u W=4u nf=1
MDNI0E0 Isum Isum Isum Isum nfet_03v3 L=2u W=4u nf=1
MDPN0 VDD VDD VDD VDD pfet_03v3 L=2u W=0.5u nf=1
MDPN1 VDD VDD VDD VDD pfet_03v3 L=2u W=0.5u nf=1
MDPN2 VDD VDD VDD VDD pfet_03v3 L=2u W=0.5u nf=1
MDPN3 VDD VDD VDD VDD pfet_03v3 L=2u W=0.5u nf=1
MDPN4 VDD VDD VDD VDD pfet_03v3 L=2u W=0.5u nf=1
MDPN5 VDD VDD VDD VDD pfet_03v3 L=2u W=0.5u nf=1
MDPN6 VDD VDD VDD VDD pfet_03v3 L=2u W=0.5u nf=1
MDPN7 VDD VDD VDD VDD pfet_03v3 L=2u W=0.5u nf=1
MDPS0 VDD VDD VDD VDD pfet_03v3 L=2u W=0.5u nf=1
MDPS1 VDD VDD VDD VDD pfet_03v3 L=2u W=0.5u nf=1
MDPS2 VDD VDD VDD VDD pfet_03v3 L=2u W=0.5u nf=1
MDPS3 VDD VDD VDD VDD pfet_03v3 L=2u W=0.5u nf=1
MDPS4 VDD VDD VDD VDD pfet_03v3 L=2u W=0.5u nf=1
MDPS5 VDD VDD VDD VDD pfet_03v3 L=2u W=0.5u nf=1
MDPS6 VDD VDD VDD VDD pfet_03v3 L=2u W=0.5u nf=1
MDPS7 VDD VDD VDD VDD pfet_03v3 L=2u W=0.5u nf=1
MDPW0 VDD VDD VDD VDD pfet_03v3 L=2u W=4u nf=1
MDPE0 VDD VDD VDD VDD pfet_03v3 L=2u W=4u nf=1
.ends

* LVS reference for neuron.gds (glayout_floorplan.two_row)
* note: M1: 0.22/0.28 -> 0.5/0.64 (W/L kept)
* note: M2: 0.22/0.28 -> 0.5/0.64 (W/L kept)
* note: M3: 0.22/0.28 -> 0.5/0.64 (W/L kept)
* note: M4: 0.22/0.28 -> 0.5/0.64 (W/L kept)
* note: M5: 0.22/0.28 -> 0.5/0.64 (W/L kept)
* note: M6: 0.22/5 -> 0.5/11.36 (W/L kept)
.subckt neuron VSS VDD VMEM VNA Vlk VK VIp VKup VKdn Vamp_bias VT spike
Mx1_M3 x1_net1 Vamp_bias VSS VSS nfet_03v3 L=0.64u W=0.5u nf=1
Mx1_M1 x1_net2 VMEM x1_net1 VSS nfet_03v3 L=2u W=4u nf=1
Mx1_M2 net1 VT x1_net1 VSS nfet_03v3 L=2u W=4u nf=1
MM1 net2 net1 net4 VSS nfet_03v3 L=0.64u W=0.5u nf=1
MM2 spike net2 net5 VSS nfet_03v3 L=0.64u W=0.5u nf=1
MM6 VMEM spike net6 VSS nfet_03v3 L=11.36u W=0.5u nf=1
MM7 net5 VKdn VSS VSS nfet_03v3 L=1u W=1u nf=1
MM8 net4 VIp VSS VSS nfet_03v3 L=1u W=1u nf=1
MM10 net6 VK VSS VSS nfet_03v3 L=1u W=1u nf=1
MM11 VMEM Vlk VSS VSS nfet_03v3 L=1u W=1u nf=1
Mx1_M4 x1_net2 x1_net2 VDD VDD pfet_03v3 L=8u W=0.5u nf=1
Mx1_M5 net1 x1_net2 VDD VDD pfet_03v3 L=8u W=0.5u nf=1
MM3 net2 net1 VDD VDD pfet_03v3 L=0.64u W=0.5u nf=1
MM4 spike net2 net3 VDD pfet_03v3 L=0.64u W=0.5u nf=1
MM5 VMEM net2 net7 VDD pfet_03v3 L=0.64u W=0.5u nf=1
MM9 net7 VNA VDD VDD pfet_03v3 L=1u W=1u nf=1
MM12 net3 VKup VDD VDD pfet_03v3 L=1u W=1u nf=1
C1 spike VSS cap_mim_2f0fF W=10e-6 L=10e-6 m=1
C2 VMEM VSS cap_mim_2f0fF W=22.18e-6 L=22.18e-6 m=1
MDNN0 VSS VSS VSS VSS nfet_03v3 L=2u W=0.5u nf=1
MDNN1 VSS VSS VSS VSS nfet_03v3 L=2u W=0.5u nf=1
MDNN2 VSS VSS VSS VSS nfet_03v3 L=2u W=0.5u nf=1
MDNN3 VSS VSS VSS VSS nfet_03v3 L=2u W=0.5u nf=1
MDNN4 VSS VSS VSS VSS nfet_03v3 L=2u W=0.5u nf=1
MDNN5 VSS VSS VSS VSS nfet_03v3 L=2u W=0.5u nf=1
MDNN6 VSS VSS VSS VSS nfet_03v3 L=2u W=0.5u nf=1
MDNN7 VSS VSS VSS VSS nfet_03v3 L=2u W=0.5u nf=1
MDNN8 VSS VSS VSS VSS nfet_03v3 L=2u W=0.5u nf=1
MDNN9 VSS VSS VSS VSS nfet_03v3 L=2u W=0.5u nf=1
MDNN10 VSS VSS VSS VSS nfet_03v3 L=2u W=0.5u nf=1
MDNN11 VSS VSS VSS VSS nfet_03v3 L=2u W=0.5u nf=1
MDNN12 VSS VSS VSS VSS nfet_03v3 L=2u W=0.5u nf=1
MDNN13 VSS VSS VSS VSS nfet_03v3 L=2u W=0.5u nf=1
MDNN14 VSS VSS VSS VSS nfet_03v3 L=2u W=0.5u nf=1
MDNN15 VSS VSS VSS VSS nfet_03v3 L=2u W=0.5u nf=1
MDNN16 VSS VSS VSS VSS nfet_03v3 L=2u W=0.5u nf=1
MDNN17 VSS VSS VSS VSS nfet_03v3 L=2u W=0.5u nf=1
MDNN18 VSS VSS VSS VSS nfet_03v3 L=2u W=0.5u nf=1
MDNN19 VSS VSS VSS VSS nfet_03v3 L=2u W=0.5u nf=1
MDNS0 VSS VSS VSS VSS nfet_03v3 L=2u W=0.5u nf=1
MDNS1 VSS VSS VSS VSS nfet_03v3 L=2u W=0.5u nf=1
MDNS2 VSS VSS VSS VSS nfet_03v3 L=2u W=0.5u nf=1
MDNS3 VSS VSS VSS VSS nfet_03v3 L=2u W=0.5u nf=1
MDNS4 VSS VSS VSS VSS nfet_03v3 L=2u W=0.5u nf=1
MDNS5 VSS VSS VSS VSS nfet_03v3 L=2u W=0.5u nf=1
MDNS6 VSS VSS VSS VSS nfet_03v3 L=2u W=0.5u nf=1
MDNS7 VSS VSS VSS VSS nfet_03v3 L=2u W=0.5u nf=1
MDNS8 VSS VSS VSS VSS nfet_03v3 L=2u W=0.5u nf=1
MDNS9 VSS VSS VSS VSS nfet_03v3 L=2u W=0.5u nf=1
MDNS10 VSS VSS VSS VSS nfet_03v3 L=2u W=0.5u nf=1
MDNS11 VSS VSS VSS VSS nfet_03v3 L=2u W=0.5u nf=1
MDNS12 VSS VSS VSS VSS nfet_03v3 L=2u W=0.5u nf=1
MDNS13 VSS VSS VSS VSS nfet_03v3 L=2u W=0.5u nf=1
MDNS14 VSS VSS VSS VSS nfet_03v3 L=2u W=0.5u nf=1
MDNS15 VSS VSS VSS VSS nfet_03v3 L=2u W=0.5u nf=1
MDNS16 VSS VSS VSS VSS nfet_03v3 L=2u W=0.5u nf=1
MDNS17 VSS VSS VSS VSS nfet_03v3 L=2u W=0.5u nf=1
MDNS18 VSS VSS VSS VSS nfet_03v3 L=2u W=0.5u nf=1
MDNS19 VSS VSS VSS VSS nfet_03v3 L=2u W=0.5u nf=1
MDNW0 VSS VSS VSS VSS nfet_03v3 L=2u W=4u nf=1
MDNE0 VSS VSS VSS VSS nfet_03v3 L=2u W=4u nf=1
MDPN0 VDD VDD VDD VDD pfet_03v3 L=2u W=0.5u nf=1
MDPN1 VDD VDD VDD VDD pfet_03v3 L=2u W=0.5u nf=1
MDPN2 VDD VDD VDD VDD pfet_03v3 L=2u W=0.5u nf=1
MDPN3 VDD VDD VDD VDD pfet_03v3 L=2u W=0.5u nf=1
MDPN4 VDD VDD VDD VDD pfet_03v3 L=2u W=0.5u nf=1
MDPN5 VDD VDD VDD VDD pfet_03v3 L=2u W=0.5u nf=1
MDPN6 VDD VDD VDD VDD pfet_03v3 L=2u W=0.5u nf=1
MDPN7 VDD VDD VDD VDD pfet_03v3 L=2u W=0.5u nf=1
MDPN8 VDD VDD VDD VDD pfet_03v3 L=2u W=0.5u nf=1
MDPN9 VDD VDD VDD VDD pfet_03v3 L=2u W=0.5u nf=1
MDPN10 VDD VDD VDD VDD pfet_03v3 L=2u W=0.5u nf=1
MDPN11 VDD VDD VDD VDD pfet_03v3 L=2u W=0.5u nf=1
MDPN12 VDD VDD VDD VDD pfet_03v3 L=2u W=0.5u nf=1
MDPN13 VDD VDD VDD VDD pfet_03v3 L=2u W=0.5u nf=1
MDPN14 VDD VDD VDD VDD pfet_03v3 L=2u W=0.5u nf=1
MDPN15 VDD VDD VDD VDD pfet_03v3 L=2u W=0.5u nf=1
MDPN16 VDD VDD VDD VDD pfet_03v3 L=2u W=0.5u nf=1
MDPS0 VDD VDD VDD VDD pfet_03v3 L=2u W=0.5u nf=1
MDPS1 VDD VDD VDD VDD pfet_03v3 L=2u W=0.5u nf=1
MDPS2 VDD VDD VDD VDD pfet_03v3 L=2u W=0.5u nf=1
MDPS3 VDD VDD VDD VDD pfet_03v3 L=2u W=0.5u nf=1
MDPS4 VDD VDD VDD VDD pfet_03v3 L=2u W=0.5u nf=1
MDPS5 VDD VDD VDD VDD pfet_03v3 L=2u W=0.5u nf=1
MDPS6 VDD VDD VDD VDD pfet_03v3 L=2u W=0.5u nf=1
MDPS7 VDD VDD VDD VDD pfet_03v3 L=2u W=0.5u nf=1
MDPS8 VDD VDD VDD VDD pfet_03v3 L=2u W=0.5u nf=1
MDPS9 VDD VDD VDD VDD pfet_03v3 L=2u W=0.5u nf=1
MDPS10 VDD VDD VDD VDD pfet_03v3 L=2u W=0.5u nf=1
MDPS11 VDD VDD VDD VDD pfet_03v3 L=2u W=0.5u nf=1
MDPS12 VDD VDD VDD VDD pfet_03v3 L=2u W=0.5u nf=1
MDPS13 VDD VDD VDD VDD pfet_03v3 L=2u W=0.5u nf=1
MDPS14 VDD VDD VDD VDD pfet_03v3 L=2u W=0.5u nf=1
MDPS15 VDD VDD VDD VDD pfet_03v3 L=2u W=0.5u nf=1
MDPS16 VDD VDD VDD VDD pfet_03v3 L=2u W=0.5u nf=1
MDPW0 VDD VDD VDD VDD pfet_03v3 L=2u W=1u nf=1
MDPE0 VDD VDD VDD VDD pfet_03v3 L=2u W=1u nf=1
.ends

* LVS reference for DPI_inh.gds (glayout_floorplan.two_row)
* note: ground net GND drawn as VSS
.subckt DPI_inh Vthr VT Isum VDD Iout VSS
Mx1_M1 VDD Vthr Isum Isum nfet_03v3 L=5.12u W=4u nf=1
Mx1_M2 x1_net1 x1_net1 Isum Isum nfet_03v3 L=5.12u W=4u nf=1
MMi1 Im Im VSS VSS nfet_03v3 L=8u W=2u nf=1
MMi2 Iout Im VSS VSS nfet_03v3 L=8u W=2.4u nf=1
Mx1_M3 x1_net1 VT VDD VDD pfet_03v3 L=5.12u W=4u nf=1
Mx1_M4 Im x1_net1 VDD VDD pfet_03v3 L=5.12u W=4u nf=1
Cx1_C2 VDD x1_net1 cap_mim_2f0fF W=22.18e-6 L=22.18e-6 m=1
MDNN0 VSS VSS VSS VSS nfet_03v3 L=2u W=0.5u nf=1
MDNN1 VSS VSS VSS VSS nfet_03v3 L=2u W=0.5u nf=1
MDNN2 VSS VSS VSS VSS nfet_03v3 L=2u W=0.5u nf=1
MDNN3 VSS VSS VSS VSS nfet_03v3 L=2u W=0.5u nf=1
MDNN4 VSS VSS VSS VSS nfet_03v3 L=2u W=0.5u nf=1
MDNN5 VSS VSS VSS VSS nfet_03v3 L=2u W=0.5u nf=1
MDNN6 VSS VSS VSS VSS nfet_03v3 L=2u W=0.5u nf=1
MDNN7 VSS VSS VSS VSS nfet_03v3 L=2u W=0.5u nf=1
MDNN8 VSS VSS VSS VSS nfet_03v3 L=2u W=0.5u nf=1
MDNN9 VSS VSS VSS VSS nfet_03v3 L=2u W=0.5u nf=1
MDNS0 VSS VSS VSS VSS nfet_03v3 L=2u W=0.5u nf=1
MDNS1 VSS VSS VSS VSS nfet_03v3 L=2u W=0.5u nf=1
MDNS2 VSS VSS VSS VSS nfet_03v3 L=2u W=0.5u nf=1
MDNS3 VSS VSS VSS VSS nfet_03v3 L=2u W=0.5u nf=1
MDNS4 VSS VSS VSS VSS nfet_03v3 L=2u W=0.5u nf=1
MDNS5 VSS VSS VSS VSS nfet_03v3 L=2u W=0.5u nf=1
MDNS6 VSS VSS VSS VSS nfet_03v3 L=2u W=0.5u nf=1
MDNS7 VSS VSS VSS VSS nfet_03v3 L=2u W=0.5u nf=1
MDNS8 VSS VSS VSS VSS nfet_03v3 L=2u W=0.5u nf=1
MDNS9 VSS VSS VSS VSS nfet_03v3 L=2u W=0.5u nf=1
MDNW0 VSS VSS VSS VSS nfet_03v3 L=2u W=2.4u nf=1
MDNE0 VSS VSS VSS VSS nfet_03v3 L=2u W=2.4u nf=1
MDNI1N0 Isum Isum Isum Isum nfet_03v3 L=2u W=0.5u nf=1
MDNI1N1 Isum Isum Isum Isum nfet_03v3 L=2u W=0.5u nf=1
MDNI1N2 Isum Isum Isum Isum nfet_03v3 L=2u W=0.5u nf=1
MDNI1N3 Isum Isum Isum Isum nfet_03v3 L=2u W=0.5u nf=1
MDNI1N4 Isum Isum Isum Isum nfet_03v3 L=2u W=0.5u nf=1
MDNI1N5 Isum Isum Isum Isum nfet_03v3 L=2u W=0.5u nf=1
MDNI1N6 Isum Isum Isum Isum nfet_03v3 L=2u W=0.5u nf=1
MDNI1N7 Isum Isum Isum Isum nfet_03v3 L=2u W=0.5u nf=1
MDNI1S0 Isum Isum Isum Isum nfet_03v3 L=2u W=0.5u nf=1
MDNI1S1 Isum Isum Isum Isum nfet_03v3 L=2u W=0.5u nf=1
MDNI1S2 Isum Isum Isum Isum nfet_03v3 L=2u W=0.5u nf=1
MDNI1S3 Isum Isum Isum Isum nfet_03v3 L=2u W=0.5u nf=1
MDNI1S4 Isum Isum Isum Isum nfet_03v3 L=2u W=0.5u nf=1
MDNI1S5 Isum Isum Isum Isum nfet_03v3 L=2u W=0.5u nf=1
MDNI1S6 Isum Isum Isum Isum nfet_03v3 L=2u W=0.5u nf=1
MDNI1S7 Isum Isum Isum Isum nfet_03v3 L=2u W=0.5u nf=1
MDNI1W0 Isum Isum Isum Isum nfet_03v3 L=2u W=4u nf=1
MDNI1E0 Isum Isum Isum Isum nfet_03v3 L=2u W=4u nf=1
MDPN0 VDD VDD VDD VDD pfet_03v3 L=2u W=0.5u nf=1
MDPN1 VDD VDD VDD VDD pfet_03v3 L=2u W=0.5u nf=1
MDPN2 VDD VDD VDD VDD pfet_03v3 L=2u W=0.5u nf=1
MDPN3 VDD VDD VDD VDD pfet_03v3 L=2u W=0.5u nf=1
MDPN4 VDD VDD VDD VDD pfet_03v3 L=2u W=0.5u nf=1
MDPN5 VDD VDD VDD VDD pfet_03v3 L=2u W=0.5u nf=1
MDPN6 VDD VDD VDD VDD pfet_03v3 L=2u W=0.5u nf=1
MDPN7 VDD VDD VDD VDD pfet_03v3 L=2u W=0.5u nf=1
MDPS0 VDD VDD VDD VDD pfet_03v3 L=2u W=0.5u nf=1
MDPS1 VDD VDD VDD VDD pfet_03v3 L=2u W=0.5u nf=1
MDPS2 VDD VDD VDD VDD pfet_03v3 L=2u W=0.5u nf=1
MDPS3 VDD VDD VDD VDD pfet_03v3 L=2u W=0.5u nf=1
MDPS4 VDD VDD VDD VDD pfet_03v3 L=2u W=0.5u nf=1
MDPS5 VDD VDD VDD VDD pfet_03v3 L=2u W=0.5u nf=1
MDPS6 VDD VDD VDD VDD pfet_03v3 L=2u W=0.5u nf=1
MDPS7 VDD VDD VDD VDD pfet_03v3 L=2u W=0.5u nf=1
MDPW0 VDD VDD VDD VDD pfet_03v3 L=2u W=4u nf=1
MDPE0 VDD VDD VDD VDD pfet_03v3 L=2u W=4u nf=1
.ends

* LVS reference for bias.gds (glayout_floorplan.two_row)
* note: MO_Vb: W 1.435 -> 1.44 (glayout 10 nm width grid, L kept)
* note: MR_Vlk: m=8 x nf=1 -> nf=8, m=1 (parallel copies as fingers)
* note: MR_VKdn: m=4 x nf=1 -> nf=4, m=1 (parallel copies as fingers)
* note: MO_VIp: W 2.335 -> 2.34 (glayout 10 nm width grid, L kept)
* note: MR_Vamp_bias: 0.22/0.28 -> 0.5/0.64 (W/L kept)
* note: MR_VK: 0.22/40 -> 0.5/90.91 (W/L kept)
* note: MR_VNA: 0.22/20 -> 0.5/45.45 (W/L kept)
* note: MO_VNA: W 5.755 -> 5.76 (glayout 10 nm width grid, L kept)
* note: MO_VKup: W 6.005 -> 6.01 (glayout 10 nm width grid, L kept)
* note: MR_Vthr: m=32 x nf=1 -> nf=32, m=1 (parallel copies as fingers)
* note: MO_Vthr: W 0.905 -> 0.91 (glayout 10 nm width grid, L kept)
* note: MR_VT_dpi: m=32 x nf=1 -> nf=32, m=1 (parallel copies as fingers)
* note: MO_VT_dpi: W 1.165 -> 1.17 (glayout 10 nm width grid, L kept)
* note: MR_VT_inh: m=16 x nf=1 -> nf=16, m=1 (parallel copies as fingers)
* note: MO_VT_inh: W 0.625 -> 0.63 (glayout 10 nm width grid, L kept)
.subckt bias VDD VSS Iref Vb Vlk VKdn VIp Vamp_bias VK VNA VKup Vthr VT_dpi VT_inh
MMNP vgp Iref VSS VSS nfet_03v3 L=8u W=10u nf=1
MMN0 Iref Iref VSS VSS nfet_03v3 L=8u W=10u nf=1
MMO_VNA VNA Iref VSS VSS nfet_03v3 L=8u W=5.76u nf=1
MMO_VKup VKup Iref VSS VSS nfet_03v3 L=8u W=6.01u nf=1
MMO_Vthr Vthr Iref VSS VSS nfet_03v3 L=32u W=0.91u nf=1
MMO_VT_dpi VT_dpi Iref VSS VSS nfet_03v3 L=32u W=1.17u nf=1
MMO_VT_inh VT_inh Iref VSS VSS nfet_03v3 L=32u W=0.63u nf=1
MMR_Vb Vb Vb VSS VSS nfet_03v3 L=8u W=1u nf=1
MMR_Vlk_f0 Vlk Vlk VSS VSS nfet_03v3 L=1u W=1u nf=1
MMR_Vlk_f1 Vlk Vlk VSS VSS nfet_03v3 L=1u W=1u nf=1
MMR_Vlk_f2 Vlk Vlk VSS VSS nfet_03v3 L=1u W=1u nf=1
MMR_Vlk_f3 Vlk Vlk VSS VSS nfet_03v3 L=1u W=1u nf=1
MMR_Vlk_f4 Vlk Vlk VSS VSS nfet_03v3 L=1u W=1u nf=1
MMR_Vlk_f5 Vlk Vlk VSS VSS nfet_03v3 L=1u W=1u nf=1
MMR_Vlk_f6 Vlk Vlk VSS VSS nfet_03v3 L=1u W=1u nf=1
MMR_Vlk_f7 Vlk Vlk VSS VSS nfet_03v3 L=1u W=1u nf=1
MMR_VKdn_f0 VKdn VKdn VSS VSS nfet_03v3 L=1u W=1u nf=1
MMR_VKdn_f1 VKdn VKdn VSS VSS nfet_03v3 L=1u W=1u nf=1
MMR_VKdn_f2 VKdn VKdn VSS VSS nfet_03v3 L=1u W=1u nf=1
MMR_VKdn_f3 VKdn VKdn VSS VSS nfet_03v3 L=1u W=1u nf=1
MMR_VIp VIp VIp VSS VSS nfet_03v3 L=1u W=1u nf=1
MMR_Vamp_bias Vamp_bias Vamp_bias VSS VSS nfet_03v3 L=0.64u W=0.5u nf=1
MMR_VK VK VK VSS VSS nfet_03v3 L=90.91u W=0.5u nf=1
MMO_Vb Vb vgp VDD VDD pfet_03v3 L=8u W=1.44u nf=1
MMO_VKdn VKdn vgp VDD VDD pfet_03v3 L=8u W=12.94u nf=1
MMP0 vgp vgp VDD VDD pfet_03v3 L=8u W=10u nf=1
MMO_VIp VIp vgp VDD VDD pfet_03v3 L=8u W=2.34u nf=1
MMO_Vamp_bias Vamp_bias vgp VDD VDD pfet_03v3 L=8u W=9.14u nf=1
MMO_VK VK vgp VDD VDD pfet_03v3 L=8u W=10.45u nf=1
MMO_Vlk Vlk vgp VDD VDD pfet_03v3 L=16u W=0.84u nf=1
MMR_VNA VNA VNA VDD VDD pfet_03v3 L=45.45u W=0.5u nf=1
MMR_VKup VKup VKup VDD VDD pfet_03v3 L=8u W=1u nf=1
MMR_Vthr_f0 Vthr Vthr VDD VDD pfet_03v3 L=5.12u W=4u nf=1
MMR_Vthr_f1 Vthr Vthr VDD VDD pfet_03v3 L=5.12u W=4u nf=1
MMR_Vthr_f2 Vthr Vthr VDD VDD pfet_03v3 L=5.12u W=4u nf=1
MMR_Vthr_f3 Vthr Vthr VDD VDD pfet_03v3 L=5.12u W=4u nf=1
MMR_Vthr_f4 Vthr Vthr VDD VDD pfet_03v3 L=5.12u W=4u nf=1
MMR_Vthr_f5 Vthr Vthr VDD VDD pfet_03v3 L=5.12u W=4u nf=1
MMR_Vthr_f6 Vthr Vthr VDD VDD pfet_03v3 L=5.12u W=4u nf=1
MMR_Vthr_f7 Vthr Vthr VDD VDD pfet_03v3 L=5.12u W=4u nf=1
MMR_Vthr_f8 Vthr Vthr VDD VDD pfet_03v3 L=5.12u W=4u nf=1
MMR_Vthr_f9 Vthr Vthr VDD VDD pfet_03v3 L=5.12u W=4u nf=1
MMR_Vthr_f10 Vthr Vthr VDD VDD pfet_03v3 L=5.12u W=4u nf=1
MMR_Vthr_f11 Vthr Vthr VDD VDD pfet_03v3 L=5.12u W=4u nf=1
MMR_Vthr_f12 Vthr Vthr VDD VDD pfet_03v3 L=5.12u W=4u nf=1
MMR_Vthr_f13 Vthr Vthr VDD VDD pfet_03v3 L=5.12u W=4u nf=1
MMR_Vthr_f14 Vthr Vthr VDD VDD pfet_03v3 L=5.12u W=4u nf=1
MMR_Vthr_f15 Vthr Vthr VDD VDD pfet_03v3 L=5.12u W=4u nf=1
MMR_Vthr_f16 Vthr Vthr VDD VDD pfet_03v3 L=5.12u W=4u nf=1
MMR_Vthr_f17 Vthr Vthr VDD VDD pfet_03v3 L=5.12u W=4u nf=1
MMR_Vthr_f18 Vthr Vthr VDD VDD pfet_03v3 L=5.12u W=4u nf=1
MMR_Vthr_f19 Vthr Vthr VDD VDD pfet_03v3 L=5.12u W=4u nf=1
MMR_Vthr_f20 Vthr Vthr VDD VDD pfet_03v3 L=5.12u W=4u nf=1
MMR_Vthr_f21 Vthr Vthr VDD VDD pfet_03v3 L=5.12u W=4u nf=1
MMR_Vthr_f22 Vthr Vthr VDD VDD pfet_03v3 L=5.12u W=4u nf=1
MMR_Vthr_f23 Vthr Vthr VDD VDD pfet_03v3 L=5.12u W=4u nf=1
MMR_Vthr_f24 Vthr Vthr VDD VDD pfet_03v3 L=5.12u W=4u nf=1
MMR_Vthr_f25 Vthr Vthr VDD VDD pfet_03v3 L=5.12u W=4u nf=1
MMR_Vthr_f26 Vthr Vthr VDD VDD pfet_03v3 L=5.12u W=4u nf=1
MMR_Vthr_f27 Vthr Vthr VDD VDD pfet_03v3 L=5.12u W=4u nf=1
MMR_Vthr_f28 Vthr Vthr VDD VDD pfet_03v3 L=5.12u W=4u nf=1
MMR_Vthr_f29 Vthr Vthr VDD VDD pfet_03v3 L=5.12u W=4u nf=1
MMR_Vthr_f30 Vthr Vthr VDD VDD pfet_03v3 L=5.12u W=4u nf=1
MMR_Vthr_f31 Vthr Vthr VDD VDD pfet_03v3 L=5.12u W=4u nf=1
MMR_VT_dpi_f0 VT_dpi VT_dpi VDD VDD pfet_03v3 L=5.12u W=4u nf=1
MMR_VT_dpi_f1 VT_dpi VT_dpi VDD VDD pfet_03v3 L=5.12u W=4u nf=1
MMR_VT_dpi_f2 VT_dpi VT_dpi VDD VDD pfet_03v3 L=5.12u W=4u nf=1
MMR_VT_dpi_f3 VT_dpi VT_dpi VDD VDD pfet_03v3 L=5.12u W=4u nf=1
MMR_VT_dpi_f4 VT_dpi VT_dpi VDD VDD pfet_03v3 L=5.12u W=4u nf=1
MMR_VT_dpi_f5 VT_dpi VT_dpi VDD VDD pfet_03v3 L=5.12u W=4u nf=1
MMR_VT_dpi_f6 VT_dpi VT_dpi VDD VDD pfet_03v3 L=5.12u W=4u nf=1
MMR_VT_dpi_f7 VT_dpi VT_dpi VDD VDD pfet_03v3 L=5.12u W=4u nf=1
MMR_VT_dpi_f8 VT_dpi VT_dpi VDD VDD pfet_03v3 L=5.12u W=4u nf=1
MMR_VT_dpi_f9 VT_dpi VT_dpi VDD VDD pfet_03v3 L=5.12u W=4u nf=1
MMR_VT_dpi_f10 VT_dpi VT_dpi VDD VDD pfet_03v3 L=5.12u W=4u nf=1
MMR_VT_dpi_f11 VT_dpi VT_dpi VDD VDD pfet_03v3 L=5.12u W=4u nf=1
MMR_VT_dpi_f12 VT_dpi VT_dpi VDD VDD pfet_03v3 L=5.12u W=4u nf=1
MMR_VT_dpi_f13 VT_dpi VT_dpi VDD VDD pfet_03v3 L=5.12u W=4u nf=1
MMR_VT_dpi_f14 VT_dpi VT_dpi VDD VDD pfet_03v3 L=5.12u W=4u nf=1
MMR_VT_dpi_f15 VT_dpi VT_dpi VDD VDD pfet_03v3 L=5.12u W=4u nf=1
MMR_VT_dpi_f16 VT_dpi VT_dpi VDD VDD pfet_03v3 L=5.12u W=4u nf=1
MMR_VT_dpi_f17 VT_dpi VT_dpi VDD VDD pfet_03v3 L=5.12u W=4u nf=1
MMR_VT_dpi_f18 VT_dpi VT_dpi VDD VDD pfet_03v3 L=5.12u W=4u nf=1
MMR_VT_dpi_f19 VT_dpi VT_dpi VDD VDD pfet_03v3 L=5.12u W=4u nf=1
MMR_VT_dpi_f20 VT_dpi VT_dpi VDD VDD pfet_03v3 L=5.12u W=4u nf=1
MMR_VT_dpi_f21 VT_dpi VT_dpi VDD VDD pfet_03v3 L=5.12u W=4u nf=1
MMR_VT_dpi_f22 VT_dpi VT_dpi VDD VDD pfet_03v3 L=5.12u W=4u nf=1
MMR_VT_dpi_f23 VT_dpi VT_dpi VDD VDD pfet_03v3 L=5.12u W=4u nf=1
MMR_VT_dpi_f24 VT_dpi VT_dpi VDD VDD pfet_03v3 L=5.12u W=4u nf=1
MMR_VT_dpi_f25 VT_dpi VT_dpi VDD VDD pfet_03v3 L=5.12u W=4u nf=1
MMR_VT_dpi_f26 VT_dpi VT_dpi VDD VDD pfet_03v3 L=5.12u W=4u nf=1
MMR_VT_dpi_f27 VT_dpi VT_dpi VDD VDD pfet_03v3 L=5.12u W=4u nf=1
MMR_VT_dpi_f28 VT_dpi VT_dpi VDD VDD pfet_03v3 L=5.12u W=4u nf=1
MMR_VT_dpi_f29 VT_dpi VT_dpi VDD VDD pfet_03v3 L=5.12u W=4u nf=1
MMR_VT_dpi_f30 VT_dpi VT_dpi VDD VDD pfet_03v3 L=5.12u W=4u nf=1
MMR_VT_dpi_f31 VT_dpi VT_dpi VDD VDD pfet_03v3 L=5.12u W=4u nf=1
MMR_VT_inh_f0 VT_inh VT_inh VDD VDD pfet_03v3 L=1.12u W=0.88u nf=1
MMR_VT_inh_f1 VT_inh VT_inh VDD VDD pfet_03v3 L=1.12u W=0.88u nf=1
MMR_VT_inh_f2 VT_inh VT_inh VDD VDD pfet_03v3 L=1.12u W=0.88u nf=1
MMR_VT_inh_f3 VT_inh VT_inh VDD VDD pfet_03v3 L=1.12u W=0.88u nf=1
MMR_VT_inh_f4 VT_inh VT_inh VDD VDD pfet_03v3 L=1.12u W=0.88u nf=1
MMR_VT_inh_f5 VT_inh VT_inh VDD VDD pfet_03v3 L=1.12u W=0.88u nf=1
MMR_VT_inh_f6 VT_inh VT_inh VDD VDD pfet_03v3 L=1.12u W=0.88u nf=1
MMR_VT_inh_f7 VT_inh VT_inh VDD VDD pfet_03v3 L=1.12u W=0.88u nf=1
MMR_VT_inh_f8 VT_inh VT_inh VDD VDD pfet_03v3 L=1.12u W=0.88u nf=1
MMR_VT_inh_f9 VT_inh VT_inh VDD VDD pfet_03v3 L=1.12u W=0.88u nf=1
MMR_VT_inh_f10 VT_inh VT_inh VDD VDD pfet_03v3 L=1.12u W=0.88u nf=1
MMR_VT_inh_f11 VT_inh VT_inh VDD VDD pfet_03v3 L=1.12u W=0.88u nf=1
MMR_VT_inh_f12 VT_inh VT_inh VDD VDD pfet_03v3 L=1.12u W=0.88u nf=1
MMR_VT_inh_f13 VT_inh VT_inh VDD VDD pfet_03v3 L=1.12u W=0.88u nf=1
MMR_VT_inh_f14 VT_inh VT_inh VDD VDD pfet_03v3 L=1.12u W=0.88u nf=1
MMR_VT_inh_f15 VT_inh VT_inh VDD VDD pfet_03v3 L=1.12u W=0.88u nf=1
MDNN0 VSS VSS VSS VSS nfet_03v3 L=2u W=0.5u nf=1
MDNN1 VSS VSS VSS VSS nfet_03v3 L=2u W=0.5u nf=1
MDNN2 VSS VSS VSS VSS nfet_03v3 L=2u W=0.5u nf=1
MDNN3 VSS VSS VSS VSS nfet_03v3 L=2u W=0.5u nf=1
MDNN4 VSS VSS VSS VSS nfet_03v3 L=2u W=0.5u nf=1
MDNN5 VSS VSS VSS VSS nfet_03v3 L=2u W=0.5u nf=1
MDNN6 VSS VSS VSS VSS nfet_03v3 L=2u W=0.5u nf=1
MDNN7 VSS VSS VSS VSS nfet_03v3 L=2u W=0.5u nf=1
MDNN8 VSS VSS VSS VSS nfet_03v3 L=2u W=0.5u nf=1
MDNN9 VSS VSS VSS VSS nfet_03v3 L=2u W=0.5u nf=1
MDNN10 VSS VSS VSS VSS nfet_03v3 L=2u W=0.5u nf=1
MDNN11 VSS VSS VSS VSS nfet_03v3 L=2u W=0.5u nf=1
MDNN12 VSS VSS VSS VSS nfet_03v3 L=2u W=0.5u nf=1
MDNN13 VSS VSS VSS VSS nfet_03v3 L=2u W=0.5u nf=1
MDNN14 VSS VSS VSS VSS nfet_03v3 L=2u W=0.5u nf=1
MDNN15 VSS VSS VSS VSS nfet_03v3 L=2u W=0.5u nf=1
MDNN16 VSS VSS VSS VSS nfet_03v3 L=2u W=0.5u nf=1
MDNN17 VSS VSS VSS VSS nfet_03v3 L=2u W=0.5u nf=1
MDNN18 VSS VSS VSS VSS nfet_03v3 L=2u W=0.5u nf=1
MDNN19 VSS VSS VSS VSS nfet_03v3 L=2u W=0.5u nf=1
MDNN20 VSS VSS VSS VSS nfet_03v3 L=2u W=0.5u nf=1
MDNN21 VSS VSS VSS VSS nfet_03v3 L=2u W=0.5u nf=1
MDNN22 VSS VSS VSS VSS nfet_03v3 L=2u W=0.5u nf=1
MDNN23 VSS VSS VSS VSS nfet_03v3 L=2u W=0.5u nf=1
MDNN24 VSS VSS VSS VSS nfet_03v3 L=2u W=0.5u nf=1
MDNN25 VSS VSS VSS VSS nfet_03v3 L=2u W=0.5u nf=1
MDNN26 VSS VSS VSS VSS nfet_03v3 L=2u W=0.5u nf=1
MDNN27 VSS VSS VSS VSS nfet_03v3 L=2u W=0.5u nf=1
MDNN28 VSS VSS VSS VSS nfet_03v3 L=2u W=0.5u nf=1
MDNN29 VSS VSS VSS VSS nfet_03v3 L=2u W=0.5u nf=1
MDNN30 VSS VSS VSS VSS nfet_03v3 L=2u W=0.5u nf=1
MDNN31 VSS VSS VSS VSS nfet_03v3 L=2u W=0.5u nf=1
MDNN32 VSS VSS VSS VSS nfet_03v3 L=2u W=0.5u nf=1
MDNN33 VSS VSS VSS VSS nfet_03v3 L=2u W=0.5u nf=1
MDNN34 VSS VSS VSS VSS nfet_03v3 L=2u W=0.5u nf=1
MDNN35 VSS VSS VSS VSS nfet_03v3 L=2u W=0.5u nf=1
MDNN36 VSS VSS VSS VSS nfet_03v3 L=2u W=0.5u nf=1
MDNN37 VSS VSS VSS VSS nfet_03v3 L=2u W=0.5u nf=1
MDNN38 VSS VSS VSS VSS nfet_03v3 L=2u W=0.5u nf=1
MDNN39 VSS VSS VSS VSS nfet_03v3 L=2u W=0.5u nf=1
MDNN40 VSS VSS VSS VSS nfet_03v3 L=2u W=0.5u nf=1
MDNN41 VSS VSS VSS VSS nfet_03v3 L=2u W=0.5u nf=1
MDNN42 VSS VSS VSS VSS nfet_03v3 L=2u W=0.5u nf=1
MDNN43 VSS VSS VSS VSS nfet_03v3 L=2u W=0.5u nf=1
MDNN44 VSS VSS VSS VSS nfet_03v3 L=2u W=0.5u nf=1
MDNN45 VSS VSS VSS VSS nfet_03v3 L=2u W=0.5u nf=1
MDNN46 VSS VSS VSS VSS nfet_03v3 L=2u W=0.5u nf=1
MDNN47 VSS VSS VSS VSS nfet_03v3 L=2u W=0.5u nf=1
MDNN48 VSS VSS VSS VSS nfet_03v3 L=2u W=0.5u nf=1
MDNN49 VSS VSS VSS VSS nfet_03v3 L=2u W=0.5u nf=1
MDNN50 VSS VSS VSS VSS nfet_03v3 L=2u W=0.5u nf=1
MDNN51 VSS VSS VSS VSS nfet_03v3 L=2u W=0.5u nf=1
MDNN52 VSS VSS VSS VSS nfet_03v3 L=2u W=0.5u nf=1
MDNN53 VSS VSS VSS VSS nfet_03v3 L=2u W=0.5u nf=1
MDNN54 VSS VSS VSS VSS nfet_03v3 L=2u W=0.5u nf=1
MDNN55 VSS VSS VSS VSS nfet_03v3 L=2u W=0.5u nf=1
MDNN56 VSS VSS VSS VSS nfet_03v3 L=2u W=0.5u nf=1
MDNN57 VSS VSS VSS VSS nfet_03v3 L=2u W=0.5u nf=1
MDNN58 VSS VSS VSS VSS nfet_03v3 L=2u W=0.5u nf=1
MDNN59 VSS VSS VSS VSS nfet_03v3 L=2u W=0.5u nf=1
MDNN60 VSS VSS VSS VSS nfet_03v3 L=2u W=0.5u nf=1
MDNN61 VSS VSS VSS VSS nfet_03v3 L=2u W=0.5u nf=1
MDNN62 VSS VSS VSS VSS nfet_03v3 L=2u W=0.5u nf=1
MDNN63 VSS VSS VSS VSS nfet_03v3 L=2u W=0.5u nf=1
MDNN64 VSS VSS VSS VSS nfet_03v3 L=2u W=0.5u nf=1
MDNN65 VSS VSS VSS VSS nfet_03v3 L=2u W=0.5u nf=1
MDNN66 VSS VSS VSS VSS nfet_03v3 L=2u W=0.5u nf=1
MDNN67 VSS VSS VSS VSS nfet_03v3 L=2u W=0.5u nf=1
MDNN68 VSS VSS VSS VSS nfet_03v3 L=2u W=0.5u nf=1
MDNN69 VSS VSS VSS VSS nfet_03v3 L=2u W=0.5u nf=1
MDNN70 VSS VSS VSS VSS nfet_03v3 L=2u W=0.5u nf=1
MDNN71 VSS VSS VSS VSS nfet_03v3 L=2u W=0.5u nf=1
MDNN72 VSS VSS VSS VSS nfet_03v3 L=2u W=0.5u nf=1
MDNN73 VSS VSS VSS VSS nfet_03v3 L=2u W=0.5u nf=1
MDNN74 VSS VSS VSS VSS nfet_03v3 L=2u W=0.5u nf=1
MDNN75 VSS VSS VSS VSS nfet_03v3 L=2u W=0.5u nf=1
MDNN76 VSS VSS VSS VSS nfet_03v3 L=2u W=0.5u nf=1
MDNN77 VSS VSS VSS VSS nfet_03v3 L=2u W=0.5u nf=1
MDNN78 VSS VSS VSS VSS nfet_03v3 L=2u W=0.5u nf=1
MDNN79 VSS VSS VSS VSS nfet_03v3 L=2u W=0.5u nf=1
MDNN80 VSS VSS VSS VSS nfet_03v3 L=2u W=0.5u nf=1
MDNN81 VSS VSS VSS VSS nfet_03v3 L=2u W=0.5u nf=1
MDNN82 VSS VSS VSS VSS nfet_03v3 L=2u W=0.5u nf=1
MDNN83 VSS VSS VSS VSS nfet_03v3 L=2u W=0.5u nf=1
MDNN84 VSS VSS VSS VSS nfet_03v3 L=2u W=0.5u nf=1
MDNN85 VSS VSS VSS VSS nfet_03v3 L=2u W=0.5u nf=1
MDNN86 VSS VSS VSS VSS nfet_03v3 L=2u W=0.5u nf=1
MDNN87 VSS VSS VSS VSS nfet_03v3 L=2u W=0.5u nf=1
MDNN88 VSS VSS VSS VSS nfet_03v3 L=2u W=0.5u nf=1
MDNN89 VSS VSS VSS VSS nfet_03v3 L=2u W=0.5u nf=1
MDNN90 VSS VSS VSS VSS nfet_03v3 L=2u W=0.5u nf=1
MDNN91 VSS VSS VSS VSS nfet_03v3 L=2u W=0.5u nf=1
MDNN92 VSS VSS VSS VSS nfet_03v3 L=2u W=0.5u nf=1
MDNN93 VSS VSS VSS VSS nfet_03v3 L=2u W=0.5u nf=1
MDNN94 VSS VSS VSS VSS nfet_03v3 L=2u W=0.5u nf=1
MDNN95 VSS VSS VSS VSS nfet_03v3 L=2u W=0.5u nf=1
MDNN96 VSS VSS VSS VSS nfet_03v3 L=2u W=0.5u nf=1
MDNN97 VSS VSS VSS VSS nfet_03v3 L=2u W=0.5u nf=1
MDNN98 VSS VSS VSS VSS nfet_03v3 L=2u W=0.5u nf=1
MDNN99 VSS VSS VSS VSS nfet_03v3 L=2u W=0.5u nf=1
MDNN100 VSS VSS VSS VSS nfet_03v3 L=2u W=0.5u nf=1
MDNN101 VSS VSS VSS VSS nfet_03v3 L=2u W=0.5u nf=1
MDNN102 VSS VSS VSS VSS nfet_03v3 L=2u W=0.5u nf=1
MDNN103 VSS VSS VSS VSS nfet_03v3 L=2u W=0.5u nf=1
MDNN104 VSS VSS VSS VSS nfet_03v3 L=2u W=0.5u nf=1
MDNN105 VSS VSS VSS VSS nfet_03v3 L=2u W=0.5u nf=1
MDNN106 VSS VSS VSS VSS nfet_03v3 L=2u W=0.5u nf=1
MDNN107 VSS VSS VSS VSS nfet_03v3 L=2u W=0.5u nf=1
MDNN108 VSS VSS VSS VSS nfet_03v3 L=2u W=0.5u nf=1
MDNN109 VSS VSS VSS VSS nfet_03v3 L=2u W=0.5u nf=1
MDNN110 VSS VSS VSS VSS nfet_03v3 L=2u W=0.5u nf=1
MDNS0 VSS VSS VSS VSS nfet_03v3 L=2u W=0.5u nf=1
MDNS1 VSS VSS VSS VSS nfet_03v3 L=2u W=0.5u nf=1
MDNS2 VSS VSS VSS VSS nfet_03v3 L=2u W=0.5u nf=1
MDNS3 VSS VSS VSS VSS nfet_03v3 L=2u W=0.5u nf=1
MDNS4 VSS VSS VSS VSS nfet_03v3 L=2u W=0.5u nf=1
MDNS5 VSS VSS VSS VSS nfet_03v3 L=2u W=0.5u nf=1
MDNS6 VSS VSS VSS VSS nfet_03v3 L=2u W=0.5u nf=1
MDNS7 VSS VSS VSS VSS nfet_03v3 L=2u W=0.5u nf=1
MDNS8 VSS VSS VSS VSS nfet_03v3 L=2u W=0.5u nf=1
MDNS9 VSS VSS VSS VSS nfet_03v3 L=2u W=0.5u nf=1
MDNS10 VSS VSS VSS VSS nfet_03v3 L=2u W=0.5u nf=1
MDNS11 VSS VSS VSS VSS nfet_03v3 L=2u W=0.5u nf=1
MDNS12 VSS VSS VSS VSS nfet_03v3 L=2u W=0.5u nf=1
MDNS13 VSS VSS VSS VSS nfet_03v3 L=2u W=0.5u nf=1
MDNS14 VSS VSS VSS VSS nfet_03v3 L=2u W=0.5u nf=1
MDNS15 VSS VSS VSS VSS nfet_03v3 L=2u W=0.5u nf=1
MDNS16 VSS VSS VSS VSS nfet_03v3 L=2u W=0.5u nf=1
MDNS17 VSS VSS VSS VSS nfet_03v3 L=2u W=0.5u nf=1
MDNS18 VSS VSS VSS VSS nfet_03v3 L=2u W=0.5u nf=1
MDNS19 VSS VSS VSS VSS nfet_03v3 L=2u W=0.5u nf=1
MDNS20 VSS VSS VSS VSS nfet_03v3 L=2u W=0.5u nf=1
MDNS21 VSS VSS VSS VSS nfet_03v3 L=2u W=0.5u nf=1
MDNS22 VSS VSS VSS VSS nfet_03v3 L=2u W=0.5u nf=1
MDNS23 VSS VSS VSS VSS nfet_03v3 L=2u W=0.5u nf=1
MDNS24 VSS VSS VSS VSS nfet_03v3 L=2u W=0.5u nf=1
MDNS25 VSS VSS VSS VSS nfet_03v3 L=2u W=0.5u nf=1
MDNS26 VSS VSS VSS VSS nfet_03v3 L=2u W=0.5u nf=1
MDNS27 VSS VSS VSS VSS nfet_03v3 L=2u W=0.5u nf=1
MDNS28 VSS VSS VSS VSS nfet_03v3 L=2u W=0.5u nf=1
MDNS29 VSS VSS VSS VSS nfet_03v3 L=2u W=0.5u nf=1
MDNS30 VSS VSS VSS VSS nfet_03v3 L=2u W=0.5u nf=1
MDNS31 VSS VSS VSS VSS nfet_03v3 L=2u W=0.5u nf=1
MDNS32 VSS VSS VSS VSS nfet_03v3 L=2u W=0.5u nf=1
MDNS33 VSS VSS VSS VSS nfet_03v3 L=2u W=0.5u nf=1
MDNS34 VSS VSS VSS VSS nfet_03v3 L=2u W=0.5u nf=1
MDNS35 VSS VSS VSS VSS nfet_03v3 L=2u W=0.5u nf=1
MDNS36 VSS VSS VSS VSS nfet_03v3 L=2u W=0.5u nf=1
MDNS37 VSS VSS VSS VSS nfet_03v3 L=2u W=0.5u nf=1
MDNS38 VSS VSS VSS VSS nfet_03v3 L=2u W=0.5u nf=1
MDNS39 VSS VSS VSS VSS nfet_03v3 L=2u W=0.5u nf=1
MDNS40 VSS VSS VSS VSS nfet_03v3 L=2u W=0.5u nf=1
MDNS41 VSS VSS VSS VSS nfet_03v3 L=2u W=0.5u nf=1
MDNS42 VSS VSS VSS VSS nfet_03v3 L=2u W=0.5u nf=1
MDNS43 VSS VSS VSS VSS nfet_03v3 L=2u W=0.5u nf=1
MDNS44 VSS VSS VSS VSS nfet_03v3 L=2u W=0.5u nf=1
MDNS45 VSS VSS VSS VSS nfet_03v3 L=2u W=0.5u nf=1
MDNS46 VSS VSS VSS VSS nfet_03v3 L=2u W=0.5u nf=1
MDNS47 VSS VSS VSS VSS nfet_03v3 L=2u W=0.5u nf=1
MDNS48 VSS VSS VSS VSS nfet_03v3 L=2u W=0.5u nf=1
MDNS49 VSS VSS VSS VSS nfet_03v3 L=2u W=0.5u nf=1
MDNS50 VSS VSS VSS VSS nfet_03v3 L=2u W=0.5u nf=1
MDNS51 VSS VSS VSS VSS nfet_03v3 L=2u W=0.5u nf=1
MDNS52 VSS VSS VSS VSS nfet_03v3 L=2u W=0.5u nf=1
MDNS53 VSS VSS VSS VSS nfet_03v3 L=2u W=0.5u nf=1
MDNS54 VSS VSS VSS VSS nfet_03v3 L=2u W=0.5u nf=1
MDNS55 VSS VSS VSS VSS nfet_03v3 L=2u W=0.5u nf=1
MDNS56 VSS VSS VSS VSS nfet_03v3 L=2u W=0.5u nf=1
MDNS57 VSS VSS VSS VSS nfet_03v3 L=2u W=0.5u nf=1
MDNS58 VSS VSS VSS VSS nfet_03v3 L=2u W=0.5u nf=1
MDNS59 VSS VSS VSS VSS nfet_03v3 L=2u W=0.5u nf=1
MDNS60 VSS VSS VSS VSS nfet_03v3 L=2u W=0.5u nf=1
MDNS61 VSS VSS VSS VSS nfet_03v3 L=2u W=0.5u nf=1
MDNS62 VSS VSS VSS VSS nfet_03v3 L=2u W=0.5u nf=1
MDNS63 VSS VSS VSS VSS nfet_03v3 L=2u W=0.5u nf=1
MDNS64 VSS VSS VSS VSS nfet_03v3 L=2u W=0.5u nf=1
MDNS65 VSS VSS VSS VSS nfet_03v3 L=2u W=0.5u nf=1
MDNS66 VSS VSS VSS VSS nfet_03v3 L=2u W=0.5u nf=1
MDNS67 VSS VSS VSS VSS nfet_03v3 L=2u W=0.5u nf=1
MDNS68 VSS VSS VSS VSS nfet_03v3 L=2u W=0.5u nf=1
MDNS69 VSS VSS VSS VSS nfet_03v3 L=2u W=0.5u nf=1
MDNS70 VSS VSS VSS VSS nfet_03v3 L=2u W=0.5u nf=1
MDNS71 VSS VSS VSS VSS nfet_03v3 L=2u W=0.5u nf=1
MDNS72 VSS VSS VSS VSS nfet_03v3 L=2u W=0.5u nf=1
MDNS73 VSS VSS VSS VSS nfet_03v3 L=2u W=0.5u nf=1
MDNS74 VSS VSS VSS VSS nfet_03v3 L=2u W=0.5u nf=1
MDNS75 VSS VSS VSS VSS nfet_03v3 L=2u W=0.5u nf=1
MDNS76 VSS VSS VSS VSS nfet_03v3 L=2u W=0.5u nf=1
MDNS77 VSS VSS VSS VSS nfet_03v3 L=2u W=0.5u nf=1
MDNS78 VSS VSS VSS VSS nfet_03v3 L=2u W=0.5u nf=1
MDNS79 VSS VSS VSS VSS nfet_03v3 L=2u W=0.5u nf=1
MDNS80 VSS VSS VSS VSS nfet_03v3 L=2u W=0.5u nf=1
MDNS81 VSS VSS VSS VSS nfet_03v3 L=2u W=0.5u nf=1
MDNS82 VSS VSS VSS VSS nfet_03v3 L=2u W=0.5u nf=1
MDNS83 VSS VSS VSS VSS nfet_03v3 L=2u W=0.5u nf=1
MDNS84 VSS VSS VSS VSS nfet_03v3 L=2u W=0.5u nf=1
MDNS85 VSS VSS VSS VSS nfet_03v3 L=2u W=0.5u nf=1
MDNS86 VSS VSS VSS VSS nfet_03v3 L=2u W=0.5u nf=1
MDNS87 VSS VSS VSS VSS nfet_03v3 L=2u W=0.5u nf=1
MDNS88 VSS VSS VSS VSS nfet_03v3 L=2u W=0.5u nf=1
MDNS89 VSS VSS VSS VSS nfet_03v3 L=2u W=0.5u nf=1
MDNS90 VSS VSS VSS VSS nfet_03v3 L=2u W=0.5u nf=1
MDNS91 VSS VSS VSS VSS nfet_03v3 L=2u W=0.5u nf=1
MDNS92 VSS VSS VSS VSS nfet_03v3 L=2u W=0.5u nf=1
MDNS93 VSS VSS VSS VSS nfet_03v3 L=2u W=0.5u nf=1
MDNS94 VSS VSS VSS VSS nfet_03v3 L=2u W=0.5u nf=1
MDNS95 VSS VSS VSS VSS nfet_03v3 L=2u W=0.5u nf=1
MDNS96 VSS VSS VSS VSS nfet_03v3 L=2u W=0.5u nf=1
MDNS97 VSS VSS VSS VSS nfet_03v3 L=2u W=0.5u nf=1
MDNS98 VSS VSS VSS VSS nfet_03v3 L=2u W=0.5u nf=1
MDNS99 VSS VSS VSS VSS nfet_03v3 L=2u W=0.5u nf=1
MDNS100 VSS VSS VSS VSS nfet_03v3 L=2u W=0.5u nf=1
MDNS101 VSS VSS VSS VSS nfet_03v3 L=2u W=0.5u nf=1
MDNS102 VSS VSS VSS VSS nfet_03v3 L=2u W=0.5u nf=1
MDNS103 VSS VSS VSS VSS nfet_03v3 L=2u W=0.5u nf=1
MDNS104 VSS VSS VSS VSS nfet_03v3 L=2u W=0.5u nf=1
MDNS105 VSS VSS VSS VSS nfet_03v3 L=2u W=0.5u nf=1
MDNS106 VSS VSS VSS VSS nfet_03v3 L=2u W=0.5u nf=1
MDNS107 VSS VSS VSS VSS nfet_03v3 L=2u W=0.5u nf=1
MDNS108 VSS VSS VSS VSS nfet_03v3 L=2u W=0.5u nf=1
MDNS109 VSS VSS VSS VSS nfet_03v3 L=2u W=0.5u nf=1
MDNS110 VSS VSS VSS VSS nfet_03v3 L=2u W=0.5u nf=1
MDNW0 VSS VSS VSS VSS nfet_03v3 L=2u W=10u nf=1
MDNE0 VSS VSS VSS VSS nfet_03v3 L=2u W=10u nf=1
MDPN0 VDD VDD VDD VDD pfet_03v3 L=2u W=0.5u nf=1
MDPN1 VDD VDD VDD VDD pfet_03v3 L=2u W=0.5u nf=1
MDPN2 VDD VDD VDD VDD pfet_03v3 L=2u W=0.5u nf=1
MDPN3 VDD VDD VDD VDD pfet_03v3 L=2u W=0.5u nf=1
MDPN4 VDD VDD VDD VDD pfet_03v3 L=2u W=0.5u nf=1
MDPN5 VDD VDD VDD VDD pfet_03v3 L=2u W=0.5u nf=1
MDPN6 VDD VDD VDD VDD pfet_03v3 L=2u W=0.5u nf=1
MDPN7 VDD VDD VDD VDD pfet_03v3 L=2u W=0.5u nf=1
MDPN8 VDD VDD VDD VDD pfet_03v3 L=2u W=0.5u nf=1
MDPN9 VDD VDD VDD VDD pfet_03v3 L=2u W=0.5u nf=1
MDPN10 VDD VDD VDD VDD pfet_03v3 L=2u W=0.5u nf=1
MDPN11 VDD VDD VDD VDD pfet_03v3 L=2u W=0.5u nf=1
MDPN12 VDD VDD VDD VDD pfet_03v3 L=2u W=0.5u nf=1
MDPN13 VDD VDD VDD VDD pfet_03v3 L=2u W=0.5u nf=1
MDPN14 VDD VDD VDD VDD pfet_03v3 L=2u W=0.5u nf=1
MDPN15 VDD VDD VDD VDD pfet_03v3 L=2u W=0.5u nf=1
MDPN16 VDD VDD VDD VDD pfet_03v3 L=2u W=0.5u nf=1
MDPN17 VDD VDD VDD VDD pfet_03v3 L=2u W=0.5u nf=1
MDPN18 VDD VDD VDD VDD pfet_03v3 L=2u W=0.5u nf=1
MDPN19 VDD VDD VDD VDD pfet_03v3 L=2u W=0.5u nf=1
MDPN20 VDD VDD VDD VDD pfet_03v3 L=2u W=0.5u nf=1
MDPN21 VDD VDD VDD VDD pfet_03v3 L=2u W=0.5u nf=1
MDPN22 VDD VDD VDD VDD pfet_03v3 L=2u W=0.5u nf=1
MDPN23 VDD VDD VDD VDD pfet_03v3 L=2u W=0.5u nf=1
MDPN24 VDD VDD VDD VDD pfet_03v3 L=2u W=0.5u nf=1
MDPN25 VDD VDD VDD VDD pfet_03v3 L=2u W=0.5u nf=1
MDPN26 VDD VDD VDD VDD pfet_03v3 L=2u W=0.5u nf=1
MDPN27 VDD VDD VDD VDD pfet_03v3 L=2u W=0.5u nf=1
MDPN28 VDD VDD VDD VDD pfet_03v3 L=2u W=0.5u nf=1
MDPN29 VDD VDD VDD VDD pfet_03v3 L=2u W=0.5u nf=1
MDPN30 VDD VDD VDD VDD pfet_03v3 L=2u W=0.5u nf=1
MDPN31 VDD VDD VDD VDD pfet_03v3 L=2u W=0.5u nf=1
MDPN32 VDD VDD VDD VDD pfet_03v3 L=2u W=0.5u nf=1
MDPN33 VDD VDD VDD VDD pfet_03v3 L=2u W=0.5u nf=1
MDPN34 VDD VDD VDD VDD pfet_03v3 L=2u W=0.5u nf=1
MDPN35 VDD VDD VDD VDD pfet_03v3 L=2u W=0.5u nf=1
MDPN36 VDD VDD VDD VDD pfet_03v3 L=2u W=0.5u nf=1
MDPN37 VDD VDD VDD VDD pfet_03v3 L=2u W=0.5u nf=1
MDPN38 VDD VDD VDD VDD pfet_03v3 L=2u W=0.5u nf=1
MDPN39 VDD VDD VDD VDD pfet_03v3 L=2u W=0.5u nf=1
MDPN40 VDD VDD VDD VDD pfet_03v3 L=2u W=0.5u nf=1
MDPN41 VDD VDD VDD VDD pfet_03v3 L=2u W=0.5u nf=1
MDPN42 VDD VDD VDD VDD pfet_03v3 L=2u W=0.5u nf=1
MDPN43 VDD VDD VDD VDD pfet_03v3 L=2u W=0.5u nf=1
MDPN44 VDD VDD VDD VDD pfet_03v3 L=2u W=0.5u nf=1
MDPN45 VDD VDD VDD VDD pfet_03v3 L=2u W=0.5u nf=1
MDPN46 VDD VDD VDD VDD pfet_03v3 L=2u W=0.5u nf=1
MDPN47 VDD VDD VDD VDD pfet_03v3 L=2u W=0.5u nf=1
MDPN48 VDD VDD VDD VDD pfet_03v3 L=2u W=0.5u nf=1
MDPN49 VDD VDD VDD VDD pfet_03v3 L=2u W=0.5u nf=1
MDPN50 VDD VDD VDD VDD pfet_03v3 L=2u W=0.5u nf=1
MDPN51 VDD VDD VDD VDD pfet_03v3 L=2u W=0.5u nf=1
MDPN52 VDD VDD VDD VDD pfet_03v3 L=2u W=0.5u nf=1
MDPN53 VDD VDD VDD VDD pfet_03v3 L=2u W=0.5u nf=1
MDPN54 VDD VDD VDD VDD pfet_03v3 L=2u W=0.5u nf=1
MDPN55 VDD VDD VDD VDD pfet_03v3 L=2u W=0.5u nf=1
MDPN56 VDD VDD VDD VDD pfet_03v3 L=2u W=0.5u nf=1
MDPN57 VDD VDD VDD VDD pfet_03v3 L=2u W=0.5u nf=1
MDPN58 VDD VDD VDD VDD pfet_03v3 L=2u W=0.5u nf=1
MDPN59 VDD VDD VDD VDD pfet_03v3 L=2u W=0.5u nf=1
MDPN60 VDD VDD VDD VDD pfet_03v3 L=2u W=0.5u nf=1
MDPN61 VDD VDD VDD VDD pfet_03v3 L=2u W=0.5u nf=1
MDPN62 VDD VDD VDD VDD pfet_03v3 L=2u W=0.5u nf=1
MDPN63 VDD VDD VDD VDD pfet_03v3 L=2u W=0.5u nf=1
MDPN64 VDD VDD VDD VDD pfet_03v3 L=2u W=0.5u nf=1
MDPN65 VDD VDD VDD VDD pfet_03v3 L=2u W=0.5u nf=1
MDPN66 VDD VDD VDD VDD pfet_03v3 L=2u W=0.5u nf=1
MDPN67 VDD VDD VDD VDD pfet_03v3 L=2u W=0.5u nf=1
MDPN68 VDD VDD VDD VDD pfet_03v3 L=2u W=0.5u nf=1
MDPN69 VDD VDD VDD VDD pfet_03v3 L=2u W=0.5u nf=1
MDPN70 VDD VDD VDD VDD pfet_03v3 L=2u W=0.5u nf=1
MDPN71 VDD VDD VDD VDD pfet_03v3 L=2u W=0.5u nf=1
MDPN72 VDD VDD VDD VDD pfet_03v3 L=2u W=0.5u nf=1
MDPN73 VDD VDD VDD VDD pfet_03v3 L=2u W=0.5u nf=1
MDPN74 VDD VDD VDD VDD pfet_03v3 L=2u W=0.5u nf=1
MDPN75 VDD VDD VDD VDD pfet_03v3 L=2u W=0.5u nf=1
MDPN76 VDD VDD VDD VDD pfet_03v3 L=2u W=0.5u nf=1
MDPN77 VDD VDD VDD VDD pfet_03v3 L=2u W=0.5u nf=1
MDPN78 VDD VDD VDD VDD pfet_03v3 L=2u W=0.5u nf=1
MDPN79 VDD VDD VDD VDD pfet_03v3 L=2u W=0.5u nf=1
MDPN80 VDD VDD VDD VDD pfet_03v3 L=2u W=0.5u nf=1
MDPN81 VDD VDD VDD VDD pfet_03v3 L=2u W=0.5u nf=1
MDPN82 VDD VDD VDD VDD pfet_03v3 L=2u W=0.5u nf=1
MDPN83 VDD VDD VDD VDD pfet_03v3 L=2u W=0.5u nf=1
MDPN84 VDD VDD VDD VDD pfet_03v3 L=2u W=0.5u nf=1
MDPN85 VDD VDD VDD VDD pfet_03v3 L=2u W=0.5u nf=1
MDPN86 VDD VDD VDD VDD pfet_03v3 L=2u W=0.5u nf=1
MDPN87 VDD VDD VDD VDD pfet_03v3 L=2u W=0.5u nf=1
MDPN88 VDD VDD VDD VDD pfet_03v3 L=2u W=0.5u nf=1
MDPN89 VDD VDD VDD VDD pfet_03v3 L=2u W=0.5u nf=1
MDPN90 VDD VDD VDD VDD pfet_03v3 L=2u W=0.5u nf=1
MDPN91 VDD VDD VDD VDD pfet_03v3 L=2u W=0.5u nf=1
MDPN92 VDD VDD VDD VDD pfet_03v3 L=2u W=0.5u nf=1
MDPN93 VDD VDD VDD VDD pfet_03v3 L=2u W=0.5u nf=1
MDPN94 VDD VDD VDD VDD pfet_03v3 L=2u W=0.5u nf=1
MDPN95 VDD VDD VDD VDD pfet_03v3 L=2u W=0.5u nf=1
MDPN96 VDD VDD VDD VDD pfet_03v3 L=2u W=0.5u nf=1
MDPN97 VDD VDD VDD VDD pfet_03v3 L=2u W=0.5u nf=1
MDPN98 VDD VDD VDD VDD pfet_03v3 L=2u W=0.5u nf=1
MDPN99 VDD VDD VDD VDD pfet_03v3 L=2u W=0.5u nf=1
MDPN100 VDD VDD VDD VDD pfet_03v3 L=2u W=0.5u nf=1
MDPN101 VDD VDD VDD VDD pfet_03v3 L=2u W=0.5u nf=1
MDPN102 VDD VDD VDD VDD pfet_03v3 L=2u W=0.5u nf=1
MDPN103 VDD VDD VDD VDD pfet_03v3 L=2u W=0.5u nf=1
MDPN104 VDD VDD VDD VDD pfet_03v3 L=2u W=0.5u nf=1
MDPN105 VDD VDD VDD VDD pfet_03v3 L=2u W=0.5u nf=1
MDPN106 VDD VDD VDD VDD pfet_03v3 L=2u W=0.5u nf=1
MDPN107 VDD VDD VDD VDD pfet_03v3 L=2u W=0.5u nf=1
MDPN108 VDD VDD VDD VDD pfet_03v3 L=2u W=0.5u nf=1
MDPN109 VDD VDD VDD VDD pfet_03v3 L=2u W=0.5u nf=1
MDPN110 VDD VDD VDD VDD pfet_03v3 L=2u W=0.5u nf=1
MDPN111 VDD VDD VDD VDD pfet_03v3 L=2u W=0.5u nf=1
MDPN112 VDD VDD VDD VDD pfet_03v3 L=2u W=0.5u nf=1
MDPN113 VDD VDD VDD VDD pfet_03v3 L=2u W=0.5u nf=1
MDPN114 VDD VDD VDD VDD pfet_03v3 L=2u W=0.5u nf=1
MDPN115 VDD VDD VDD VDD pfet_03v3 L=2u W=0.5u nf=1
MDPN116 VDD VDD VDD VDD pfet_03v3 L=2u W=0.5u nf=1
MDPN117 VDD VDD VDD VDD pfet_03v3 L=2u W=0.5u nf=1
MDPN118 VDD VDD VDD VDD pfet_03v3 L=2u W=0.5u nf=1
MDPN119 VDD VDD VDD VDD pfet_03v3 L=2u W=0.5u nf=1
MDPN120 VDD VDD VDD VDD pfet_03v3 L=2u W=0.5u nf=1
MDPN121 VDD VDD VDD VDD pfet_03v3 L=2u W=0.5u nf=1
MDPN122 VDD VDD VDD VDD pfet_03v3 L=2u W=0.5u nf=1
MDPN123 VDD VDD VDD VDD pfet_03v3 L=2u W=0.5u nf=1
MDPN124 VDD VDD VDD VDD pfet_03v3 L=2u W=0.5u nf=1
MDPN125 VDD VDD VDD VDD pfet_03v3 L=2u W=0.5u nf=1
MDPN126 VDD VDD VDD VDD pfet_03v3 L=2u W=0.5u nf=1
MDPN127 VDD VDD VDD VDD pfet_03v3 L=2u W=0.5u nf=1
MDPN128 VDD VDD VDD VDD pfet_03v3 L=2u W=0.5u nf=1
MDPN129 VDD VDD VDD VDD pfet_03v3 L=2u W=0.5u nf=1
MDPN130 VDD VDD VDD VDD pfet_03v3 L=2u W=0.5u nf=1
MDPN131 VDD VDD VDD VDD pfet_03v3 L=2u W=0.5u nf=1
MDPN132 VDD VDD VDD VDD pfet_03v3 L=2u W=0.5u nf=1
MDPN133 VDD VDD VDD VDD pfet_03v3 L=2u W=0.5u nf=1
MDPN134 VDD VDD VDD VDD pfet_03v3 L=2u W=0.5u nf=1
MDPN135 VDD VDD VDD VDD pfet_03v3 L=2u W=0.5u nf=1
MDPN136 VDD VDD VDD VDD pfet_03v3 L=2u W=0.5u nf=1
MDPN137 VDD VDD VDD VDD pfet_03v3 L=2u W=0.5u nf=1
MDPN138 VDD VDD VDD VDD pfet_03v3 L=2u W=0.5u nf=1
MDPN139 VDD VDD VDD VDD pfet_03v3 L=2u W=0.5u nf=1
MDPN140 VDD VDD VDD VDD pfet_03v3 L=2u W=0.5u nf=1
MDPN141 VDD VDD VDD VDD pfet_03v3 L=2u W=0.5u nf=1
MDPN142 VDD VDD VDD VDD pfet_03v3 L=2u W=0.5u nf=1
MDPN143 VDD VDD VDD VDD pfet_03v3 L=2u W=0.5u nf=1
MDPN144 VDD VDD VDD VDD pfet_03v3 L=2u W=0.5u nf=1
MDPN145 VDD VDD VDD VDD pfet_03v3 L=2u W=0.5u nf=1
MDPN146 VDD VDD VDD VDD pfet_03v3 L=2u W=0.5u nf=1
MDPN147 VDD VDD VDD VDD pfet_03v3 L=2u W=0.5u nf=1
MDPN148 VDD VDD VDD VDD pfet_03v3 L=2u W=0.5u nf=1
MDPN149 VDD VDD VDD VDD pfet_03v3 L=2u W=0.5u nf=1
MDPN150 VDD VDD VDD VDD pfet_03v3 L=2u W=0.5u nf=1
MDPN151 VDD VDD VDD VDD pfet_03v3 L=2u W=0.5u nf=1
MDPN152 VDD VDD VDD VDD pfet_03v3 L=2u W=0.5u nf=1
MDPN153 VDD VDD VDD VDD pfet_03v3 L=2u W=0.5u nf=1
MDPN154 VDD VDD VDD VDD pfet_03v3 L=2u W=0.5u nf=1
MDPN155 VDD VDD VDD VDD pfet_03v3 L=2u W=0.5u nf=1
MDPN156 VDD VDD VDD VDD pfet_03v3 L=2u W=0.5u nf=1
MDPN157 VDD VDD VDD VDD pfet_03v3 L=2u W=0.5u nf=1
MDPN158 VDD VDD VDD VDD pfet_03v3 L=2u W=0.5u nf=1
MDPN159 VDD VDD VDD VDD pfet_03v3 L=2u W=0.5u nf=1
MDPN160 VDD VDD VDD VDD pfet_03v3 L=2u W=0.5u nf=1
MDPN161 VDD VDD VDD VDD pfet_03v3 L=2u W=0.5u nf=1
MDPN162 VDD VDD VDD VDD pfet_03v3 L=2u W=0.5u nf=1
MDPN163 VDD VDD VDD VDD pfet_03v3 L=2u W=0.5u nf=1
MDPN164 VDD VDD VDD VDD pfet_03v3 L=2u W=0.5u nf=1
MDPN165 VDD VDD VDD VDD pfet_03v3 L=2u W=0.5u nf=1
MDPN166 VDD VDD VDD VDD pfet_03v3 L=2u W=0.5u nf=1
MDPN167 VDD VDD VDD VDD pfet_03v3 L=2u W=0.5u nf=1
MDPN168 VDD VDD VDD VDD pfet_03v3 L=2u W=0.5u nf=1
MDPN169 VDD VDD VDD VDD pfet_03v3 L=2u W=0.5u nf=1
MDPN170 VDD VDD VDD VDD pfet_03v3 L=2u W=0.5u nf=1
MDPN171 VDD VDD VDD VDD pfet_03v3 L=2u W=0.5u nf=1
MDPN172 VDD VDD VDD VDD pfet_03v3 L=2u W=0.5u nf=1
MDPN173 VDD VDD VDD VDD pfet_03v3 L=2u W=0.5u nf=1
MDPN174 VDD VDD VDD VDD pfet_03v3 L=2u W=0.5u nf=1
MDPN175 VDD VDD VDD VDD pfet_03v3 L=2u W=0.5u nf=1
MDPN176 VDD VDD VDD VDD pfet_03v3 L=2u W=0.5u nf=1
MDPN177 VDD VDD VDD VDD pfet_03v3 L=2u W=0.5u nf=1
MDPN178 VDD VDD VDD VDD pfet_03v3 L=2u W=0.5u nf=1
MDPN179 VDD VDD VDD VDD pfet_03v3 L=2u W=0.5u nf=1
MDPN180 VDD VDD VDD VDD pfet_03v3 L=2u W=0.5u nf=1
MDPN181 VDD VDD VDD VDD pfet_03v3 L=2u W=0.5u nf=1
MDPN182 VDD VDD VDD VDD pfet_03v3 L=2u W=0.5u nf=1
MDPN183 VDD VDD VDD VDD pfet_03v3 L=2u W=0.5u nf=1
MDPN184 VDD VDD VDD VDD pfet_03v3 L=2u W=0.5u nf=1
MDPN185 VDD VDD VDD VDD pfet_03v3 L=2u W=0.5u nf=1
MDPN186 VDD VDD VDD VDD pfet_03v3 L=2u W=0.5u nf=1
MDPN187 VDD VDD VDD VDD pfet_03v3 L=2u W=0.5u nf=1
MDPN188 VDD VDD VDD VDD pfet_03v3 L=2u W=0.5u nf=1
MDPN189 VDD VDD VDD VDD pfet_03v3 L=2u W=0.5u nf=1
MDPN190 VDD VDD VDD VDD pfet_03v3 L=2u W=0.5u nf=1
MDPN191 VDD VDD VDD VDD pfet_03v3 L=2u W=0.5u nf=1
MDPN192 VDD VDD VDD VDD pfet_03v3 L=2u W=0.5u nf=1
MDPN193 VDD VDD VDD VDD pfet_03v3 L=2u W=0.5u nf=1
MDPN194 VDD VDD VDD VDD pfet_03v3 L=2u W=0.5u nf=1
MDPN195 VDD VDD VDD VDD pfet_03v3 L=2u W=0.5u nf=1
MDPN196 VDD VDD VDD VDD pfet_03v3 L=2u W=0.5u nf=1
MDPN197 VDD VDD VDD VDD pfet_03v3 L=2u W=0.5u nf=1
MDPN198 VDD VDD VDD VDD pfet_03v3 L=2u W=0.5u nf=1
MDPN199 VDD VDD VDD VDD pfet_03v3 L=2u W=0.5u nf=1
MDPN200 VDD VDD VDD VDD pfet_03v3 L=2u W=0.5u nf=1
MDPN201 VDD VDD VDD VDD pfet_03v3 L=2u W=0.5u nf=1
MDPN202 VDD VDD VDD VDD pfet_03v3 L=2u W=0.5u nf=1
MDPN203 VDD VDD VDD VDD pfet_03v3 L=2u W=0.5u nf=1
MDPN204 VDD VDD VDD VDD pfet_03v3 L=2u W=0.5u nf=1
MDPN205 VDD VDD VDD VDD pfet_03v3 L=2u W=0.5u nf=1
MDPN206 VDD VDD VDD VDD pfet_03v3 L=2u W=0.5u nf=1
MDPN207 VDD VDD VDD VDD pfet_03v3 L=2u W=0.5u nf=1
MDPN208 VDD VDD VDD VDD pfet_03v3 L=2u W=0.5u nf=1
MDPN209 VDD VDD VDD VDD pfet_03v3 L=2u W=0.5u nf=1
MDPN210 VDD VDD VDD VDD pfet_03v3 L=2u W=0.5u nf=1
MDPN211 VDD VDD VDD VDD pfet_03v3 L=2u W=0.5u nf=1
MDPS0 VDD VDD VDD VDD pfet_03v3 L=2u W=0.5u nf=1
MDPS1 VDD VDD VDD VDD pfet_03v3 L=2u W=0.5u nf=1
MDPS2 VDD VDD VDD VDD pfet_03v3 L=2u W=0.5u nf=1
MDPS3 VDD VDD VDD VDD pfet_03v3 L=2u W=0.5u nf=1
MDPS4 VDD VDD VDD VDD pfet_03v3 L=2u W=0.5u nf=1
MDPS5 VDD VDD VDD VDD pfet_03v3 L=2u W=0.5u nf=1
MDPS6 VDD VDD VDD VDD pfet_03v3 L=2u W=0.5u nf=1
MDPS7 VDD VDD VDD VDD pfet_03v3 L=2u W=0.5u nf=1
MDPS8 VDD VDD VDD VDD pfet_03v3 L=2u W=0.5u nf=1
MDPS9 VDD VDD VDD VDD pfet_03v3 L=2u W=0.5u nf=1
MDPS10 VDD VDD VDD VDD pfet_03v3 L=2u W=0.5u nf=1
MDPS11 VDD VDD VDD VDD pfet_03v3 L=2u W=0.5u nf=1
MDPS12 VDD VDD VDD VDD pfet_03v3 L=2u W=0.5u nf=1
MDPS13 VDD VDD VDD VDD pfet_03v3 L=2u W=0.5u nf=1
MDPS14 VDD VDD VDD VDD pfet_03v3 L=2u W=0.5u nf=1
MDPS15 VDD VDD VDD VDD pfet_03v3 L=2u W=0.5u nf=1
MDPS16 VDD VDD VDD VDD pfet_03v3 L=2u W=0.5u nf=1
MDPS17 VDD VDD VDD VDD pfet_03v3 L=2u W=0.5u nf=1
MDPS18 VDD VDD VDD VDD pfet_03v3 L=2u W=0.5u nf=1
MDPS19 VDD VDD VDD VDD pfet_03v3 L=2u W=0.5u nf=1
MDPS20 VDD VDD VDD VDD pfet_03v3 L=2u W=0.5u nf=1
MDPS21 VDD VDD VDD VDD pfet_03v3 L=2u W=0.5u nf=1
MDPS22 VDD VDD VDD VDD pfet_03v3 L=2u W=0.5u nf=1
MDPS23 VDD VDD VDD VDD pfet_03v3 L=2u W=0.5u nf=1
MDPS24 VDD VDD VDD VDD pfet_03v3 L=2u W=0.5u nf=1
MDPS25 VDD VDD VDD VDD pfet_03v3 L=2u W=0.5u nf=1
MDPS26 VDD VDD VDD VDD pfet_03v3 L=2u W=0.5u nf=1
MDPS27 VDD VDD VDD VDD pfet_03v3 L=2u W=0.5u nf=1
MDPS28 VDD VDD VDD VDD pfet_03v3 L=2u W=0.5u nf=1
MDPS29 VDD VDD VDD VDD pfet_03v3 L=2u W=0.5u nf=1
MDPS30 VDD VDD VDD VDD pfet_03v3 L=2u W=0.5u nf=1
MDPS31 VDD VDD VDD VDD pfet_03v3 L=2u W=0.5u nf=1
MDPS32 VDD VDD VDD VDD pfet_03v3 L=2u W=0.5u nf=1
MDPS33 VDD VDD VDD VDD pfet_03v3 L=2u W=0.5u nf=1
MDPS34 VDD VDD VDD VDD pfet_03v3 L=2u W=0.5u nf=1
MDPS35 VDD VDD VDD VDD pfet_03v3 L=2u W=0.5u nf=1
MDPS36 VDD VDD VDD VDD pfet_03v3 L=2u W=0.5u nf=1
MDPS37 VDD VDD VDD VDD pfet_03v3 L=2u W=0.5u nf=1
MDPS38 VDD VDD VDD VDD pfet_03v3 L=2u W=0.5u nf=1
MDPS39 VDD VDD VDD VDD pfet_03v3 L=2u W=0.5u nf=1
MDPS40 VDD VDD VDD VDD pfet_03v3 L=2u W=0.5u nf=1
MDPS41 VDD VDD VDD VDD pfet_03v3 L=2u W=0.5u nf=1
MDPS42 VDD VDD VDD VDD pfet_03v3 L=2u W=0.5u nf=1
MDPS43 VDD VDD VDD VDD pfet_03v3 L=2u W=0.5u nf=1
MDPS44 VDD VDD VDD VDD pfet_03v3 L=2u W=0.5u nf=1
MDPS45 VDD VDD VDD VDD pfet_03v3 L=2u W=0.5u nf=1
MDPS46 VDD VDD VDD VDD pfet_03v3 L=2u W=0.5u nf=1
MDPS47 VDD VDD VDD VDD pfet_03v3 L=2u W=0.5u nf=1
MDPS48 VDD VDD VDD VDD pfet_03v3 L=2u W=0.5u nf=1
MDPS49 VDD VDD VDD VDD pfet_03v3 L=2u W=0.5u nf=1
MDPS50 VDD VDD VDD VDD pfet_03v3 L=2u W=0.5u nf=1
MDPS51 VDD VDD VDD VDD pfet_03v3 L=2u W=0.5u nf=1
MDPS52 VDD VDD VDD VDD pfet_03v3 L=2u W=0.5u nf=1
MDPS53 VDD VDD VDD VDD pfet_03v3 L=2u W=0.5u nf=1
MDPS54 VDD VDD VDD VDD pfet_03v3 L=2u W=0.5u nf=1
MDPS55 VDD VDD VDD VDD pfet_03v3 L=2u W=0.5u nf=1
MDPS56 VDD VDD VDD VDD pfet_03v3 L=2u W=0.5u nf=1
MDPS57 VDD VDD VDD VDD pfet_03v3 L=2u W=0.5u nf=1
MDPS58 VDD VDD VDD VDD pfet_03v3 L=2u W=0.5u nf=1
MDPS59 VDD VDD VDD VDD pfet_03v3 L=2u W=0.5u nf=1
MDPS60 VDD VDD VDD VDD pfet_03v3 L=2u W=0.5u nf=1
MDPS61 VDD VDD VDD VDD pfet_03v3 L=2u W=0.5u nf=1
MDPS62 VDD VDD VDD VDD pfet_03v3 L=2u W=0.5u nf=1
MDPS63 VDD VDD VDD VDD pfet_03v3 L=2u W=0.5u nf=1
MDPS64 VDD VDD VDD VDD pfet_03v3 L=2u W=0.5u nf=1
MDPS65 VDD VDD VDD VDD pfet_03v3 L=2u W=0.5u nf=1
MDPS66 VDD VDD VDD VDD pfet_03v3 L=2u W=0.5u nf=1
MDPS67 VDD VDD VDD VDD pfet_03v3 L=2u W=0.5u nf=1
MDPS68 VDD VDD VDD VDD pfet_03v3 L=2u W=0.5u nf=1
MDPS69 VDD VDD VDD VDD pfet_03v3 L=2u W=0.5u nf=1
MDPS70 VDD VDD VDD VDD pfet_03v3 L=2u W=0.5u nf=1
MDPS71 VDD VDD VDD VDD pfet_03v3 L=2u W=0.5u nf=1
MDPS72 VDD VDD VDD VDD pfet_03v3 L=2u W=0.5u nf=1
MDPS73 VDD VDD VDD VDD pfet_03v3 L=2u W=0.5u nf=1
MDPS74 VDD VDD VDD VDD pfet_03v3 L=2u W=0.5u nf=1
MDPS75 VDD VDD VDD VDD pfet_03v3 L=2u W=0.5u nf=1
MDPS76 VDD VDD VDD VDD pfet_03v3 L=2u W=0.5u nf=1
MDPS77 VDD VDD VDD VDD pfet_03v3 L=2u W=0.5u nf=1
MDPS78 VDD VDD VDD VDD pfet_03v3 L=2u W=0.5u nf=1
MDPS79 VDD VDD VDD VDD pfet_03v3 L=2u W=0.5u nf=1
MDPS80 VDD VDD VDD VDD pfet_03v3 L=2u W=0.5u nf=1
MDPS81 VDD VDD VDD VDD pfet_03v3 L=2u W=0.5u nf=1
MDPS82 VDD VDD VDD VDD pfet_03v3 L=2u W=0.5u nf=1
MDPS83 VDD VDD VDD VDD pfet_03v3 L=2u W=0.5u nf=1
MDPS84 VDD VDD VDD VDD pfet_03v3 L=2u W=0.5u nf=1
MDPS85 VDD VDD VDD VDD pfet_03v3 L=2u W=0.5u nf=1
MDPS86 VDD VDD VDD VDD pfet_03v3 L=2u W=0.5u nf=1
MDPS87 VDD VDD VDD VDD pfet_03v3 L=2u W=0.5u nf=1
MDPS88 VDD VDD VDD VDD pfet_03v3 L=2u W=0.5u nf=1
MDPS89 VDD VDD VDD VDD pfet_03v3 L=2u W=0.5u nf=1
MDPS90 VDD VDD VDD VDD pfet_03v3 L=2u W=0.5u nf=1
MDPS91 VDD VDD VDD VDD pfet_03v3 L=2u W=0.5u nf=1
MDPS92 VDD VDD VDD VDD pfet_03v3 L=2u W=0.5u nf=1
MDPS93 VDD VDD VDD VDD pfet_03v3 L=2u W=0.5u nf=1
MDPS94 VDD VDD VDD VDD pfet_03v3 L=2u W=0.5u nf=1
MDPS95 VDD VDD VDD VDD pfet_03v3 L=2u W=0.5u nf=1
MDPS96 VDD VDD VDD VDD pfet_03v3 L=2u W=0.5u nf=1
MDPS97 VDD VDD VDD VDD pfet_03v3 L=2u W=0.5u nf=1
MDPS98 VDD VDD VDD VDD pfet_03v3 L=2u W=0.5u nf=1
MDPS99 VDD VDD VDD VDD pfet_03v3 L=2u W=0.5u nf=1
MDPS100 VDD VDD VDD VDD pfet_03v3 L=2u W=0.5u nf=1
MDPS101 VDD VDD VDD VDD pfet_03v3 L=2u W=0.5u nf=1
MDPS102 VDD VDD VDD VDD pfet_03v3 L=2u W=0.5u nf=1
MDPS103 VDD VDD VDD VDD pfet_03v3 L=2u W=0.5u nf=1
MDPS104 VDD VDD VDD VDD pfet_03v3 L=2u W=0.5u nf=1
MDPS105 VDD VDD VDD VDD pfet_03v3 L=2u W=0.5u nf=1
MDPS106 VDD VDD VDD VDD pfet_03v3 L=2u W=0.5u nf=1
MDPS107 VDD VDD VDD VDD pfet_03v3 L=2u W=0.5u nf=1
MDPS108 VDD VDD VDD VDD pfet_03v3 L=2u W=0.5u nf=1
MDPS109 VDD VDD VDD VDD pfet_03v3 L=2u W=0.5u nf=1
MDPS110 VDD VDD VDD VDD pfet_03v3 L=2u W=0.5u nf=1
MDPS111 VDD VDD VDD VDD pfet_03v3 L=2u W=0.5u nf=1
MDPS112 VDD VDD VDD VDD pfet_03v3 L=2u W=0.5u nf=1
MDPS113 VDD VDD VDD VDD pfet_03v3 L=2u W=0.5u nf=1
MDPS114 VDD VDD VDD VDD pfet_03v3 L=2u W=0.5u nf=1
MDPS115 VDD VDD VDD VDD pfet_03v3 L=2u W=0.5u nf=1
MDPS116 VDD VDD VDD VDD pfet_03v3 L=2u W=0.5u nf=1
MDPS117 VDD VDD VDD VDD pfet_03v3 L=2u W=0.5u nf=1
MDPS118 VDD VDD VDD VDD pfet_03v3 L=2u W=0.5u nf=1
MDPS119 VDD VDD VDD VDD pfet_03v3 L=2u W=0.5u nf=1
MDPS120 VDD VDD VDD VDD pfet_03v3 L=2u W=0.5u nf=1
MDPS121 VDD VDD VDD VDD pfet_03v3 L=2u W=0.5u nf=1
MDPS122 VDD VDD VDD VDD pfet_03v3 L=2u W=0.5u nf=1
MDPS123 VDD VDD VDD VDD pfet_03v3 L=2u W=0.5u nf=1
MDPS124 VDD VDD VDD VDD pfet_03v3 L=2u W=0.5u nf=1
MDPS125 VDD VDD VDD VDD pfet_03v3 L=2u W=0.5u nf=1
MDPS126 VDD VDD VDD VDD pfet_03v3 L=2u W=0.5u nf=1
MDPS127 VDD VDD VDD VDD pfet_03v3 L=2u W=0.5u nf=1
MDPS128 VDD VDD VDD VDD pfet_03v3 L=2u W=0.5u nf=1
MDPS129 VDD VDD VDD VDD pfet_03v3 L=2u W=0.5u nf=1
MDPS130 VDD VDD VDD VDD pfet_03v3 L=2u W=0.5u nf=1
MDPS131 VDD VDD VDD VDD pfet_03v3 L=2u W=0.5u nf=1
MDPS132 VDD VDD VDD VDD pfet_03v3 L=2u W=0.5u nf=1
MDPS133 VDD VDD VDD VDD pfet_03v3 L=2u W=0.5u nf=1
MDPS134 VDD VDD VDD VDD pfet_03v3 L=2u W=0.5u nf=1
MDPS135 VDD VDD VDD VDD pfet_03v3 L=2u W=0.5u nf=1
MDPS136 VDD VDD VDD VDD pfet_03v3 L=2u W=0.5u nf=1
MDPS137 VDD VDD VDD VDD pfet_03v3 L=2u W=0.5u nf=1
MDPS138 VDD VDD VDD VDD pfet_03v3 L=2u W=0.5u nf=1
MDPS139 VDD VDD VDD VDD pfet_03v3 L=2u W=0.5u nf=1
MDPS140 VDD VDD VDD VDD pfet_03v3 L=2u W=0.5u nf=1
MDPS141 VDD VDD VDD VDD pfet_03v3 L=2u W=0.5u nf=1
MDPS142 VDD VDD VDD VDD pfet_03v3 L=2u W=0.5u nf=1
MDPS143 VDD VDD VDD VDD pfet_03v3 L=2u W=0.5u nf=1
MDPS144 VDD VDD VDD VDD pfet_03v3 L=2u W=0.5u nf=1
MDPS145 VDD VDD VDD VDD pfet_03v3 L=2u W=0.5u nf=1
MDPS146 VDD VDD VDD VDD pfet_03v3 L=2u W=0.5u nf=1
MDPS147 VDD VDD VDD VDD pfet_03v3 L=2u W=0.5u nf=1
MDPS148 VDD VDD VDD VDD pfet_03v3 L=2u W=0.5u nf=1
MDPS149 VDD VDD VDD VDD pfet_03v3 L=2u W=0.5u nf=1
MDPS150 VDD VDD VDD VDD pfet_03v3 L=2u W=0.5u nf=1
MDPS151 VDD VDD VDD VDD pfet_03v3 L=2u W=0.5u nf=1
MDPS152 VDD VDD VDD VDD pfet_03v3 L=2u W=0.5u nf=1
MDPS153 VDD VDD VDD VDD pfet_03v3 L=2u W=0.5u nf=1
MDPS154 VDD VDD VDD VDD pfet_03v3 L=2u W=0.5u nf=1
MDPS155 VDD VDD VDD VDD pfet_03v3 L=2u W=0.5u nf=1
MDPS156 VDD VDD VDD VDD pfet_03v3 L=2u W=0.5u nf=1
MDPS157 VDD VDD VDD VDD pfet_03v3 L=2u W=0.5u nf=1
MDPS158 VDD VDD VDD VDD pfet_03v3 L=2u W=0.5u nf=1
MDPS159 VDD VDD VDD VDD pfet_03v3 L=2u W=0.5u nf=1
MDPS160 VDD VDD VDD VDD pfet_03v3 L=2u W=0.5u nf=1
MDPS161 VDD VDD VDD VDD pfet_03v3 L=2u W=0.5u nf=1
MDPS162 VDD VDD VDD VDD pfet_03v3 L=2u W=0.5u nf=1
MDPS163 VDD VDD VDD VDD pfet_03v3 L=2u W=0.5u nf=1
MDPS164 VDD VDD VDD VDD pfet_03v3 L=2u W=0.5u nf=1
MDPS165 VDD VDD VDD VDD pfet_03v3 L=2u W=0.5u nf=1
MDPS166 VDD VDD VDD VDD pfet_03v3 L=2u W=0.5u nf=1
MDPS167 VDD VDD VDD VDD pfet_03v3 L=2u W=0.5u nf=1
MDPS168 VDD VDD VDD VDD pfet_03v3 L=2u W=0.5u nf=1
MDPS169 VDD VDD VDD VDD pfet_03v3 L=2u W=0.5u nf=1
MDPS170 VDD VDD VDD VDD pfet_03v3 L=2u W=0.5u nf=1
MDPS171 VDD VDD VDD VDD pfet_03v3 L=2u W=0.5u nf=1
MDPS172 VDD VDD VDD VDD pfet_03v3 L=2u W=0.5u nf=1
MDPS173 VDD VDD VDD VDD pfet_03v3 L=2u W=0.5u nf=1
MDPS174 VDD VDD VDD VDD pfet_03v3 L=2u W=0.5u nf=1
MDPS175 VDD VDD VDD VDD pfet_03v3 L=2u W=0.5u nf=1
MDPS176 VDD VDD VDD VDD pfet_03v3 L=2u W=0.5u nf=1
MDPS177 VDD VDD VDD VDD pfet_03v3 L=2u W=0.5u nf=1
MDPS178 VDD VDD VDD VDD pfet_03v3 L=2u W=0.5u nf=1
MDPS179 VDD VDD VDD VDD pfet_03v3 L=2u W=0.5u nf=1
MDPS180 VDD VDD VDD VDD pfet_03v3 L=2u W=0.5u nf=1
MDPS181 VDD VDD VDD VDD pfet_03v3 L=2u W=0.5u nf=1
MDPS182 VDD VDD VDD VDD pfet_03v3 L=2u W=0.5u nf=1
MDPS183 VDD VDD VDD VDD pfet_03v3 L=2u W=0.5u nf=1
MDPS184 VDD VDD VDD VDD pfet_03v3 L=2u W=0.5u nf=1
MDPS185 VDD VDD VDD VDD pfet_03v3 L=2u W=0.5u nf=1
MDPS186 VDD VDD VDD VDD pfet_03v3 L=2u W=0.5u nf=1
MDPS187 VDD VDD VDD VDD pfet_03v3 L=2u W=0.5u nf=1
MDPS188 VDD VDD VDD VDD pfet_03v3 L=2u W=0.5u nf=1
MDPS189 VDD VDD VDD VDD pfet_03v3 L=2u W=0.5u nf=1
MDPS190 VDD VDD VDD VDD pfet_03v3 L=2u W=0.5u nf=1
MDPS191 VDD VDD VDD VDD pfet_03v3 L=2u W=0.5u nf=1
MDPS192 VDD VDD VDD VDD pfet_03v3 L=2u W=0.5u nf=1
MDPS193 VDD VDD VDD VDD pfet_03v3 L=2u W=0.5u nf=1
MDPS194 VDD VDD VDD VDD pfet_03v3 L=2u W=0.5u nf=1
MDPS195 VDD VDD VDD VDD pfet_03v3 L=2u W=0.5u nf=1
MDPS196 VDD VDD VDD VDD pfet_03v3 L=2u W=0.5u nf=1
MDPS197 VDD VDD VDD VDD pfet_03v3 L=2u W=0.5u nf=1
MDPS198 VDD VDD VDD VDD pfet_03v3 L=2u W=0.5u nf=1
MDPS199 VDD VDD VDD VDD pfet_03v3 L=2u W=0.5u nf=1
MDPS200 VDD VDD VDD VDD pfet_03v3 L=2u W=0.5u nf=1
MDPS201 VDD VDD VDD VDD pfet_03v3 L=2u W=0.5u nf=1
MDPS202 VDD VDD VDD VDD pfet_03v3 L=2u W=0.5u nf=1
MDPS203 VDD VDD VDD VDD pfet_03v3 L=2u W=0.5u nf=1
MDPS204 VDD VDD VDD VDD pfet_03v3 L=2u W=0.5u nf=1
MDPS205 VDD VDD VDD VDD pfet_03v3 L=2u W=0.5u nf=1
MDPS206 VDD VDD VDD VDD pfet_03v3 L=2u W=0.5u nf=1
MDPS207 VDD VDD VDD VDD pfet_03v3 L=2u W=0.5u nf=1
MDPS208 VDD VDD VDD VDD pfet_03v3 L=2u W=0.5u nf=1
MDPS209 VDD VDD VDD VDD pfet_03v3 L=2u W=0.5u nf=1
MDPS210 VDD VDD VDD VDD pfet_03v3 L=2u W=0.5u nf=1
MDPS211 VDD VDD VDD VDD pfet_03v3 L=2u W=0.5u nf=1
MDPW0 VDD VDD VDD VDD pfet_03v3 L=2u W=12.94u nf=1
MDPE0 VDD VDD VDD VDD pfet_03v3 L=2u W=12.94u nf=1
.ends

.subckt SNN_signed VDD VSS Iref VT w[31] w[30] w[29] w[28] w[27] w[26] w[25] w[24] w[23] w[22] w[21] w[20] w[19] w[18] w[17] w[16] w[15] w[14] w[13] w[12] w[11] w[10] w[9] w[8] w[7] w[6] w[5] w[4] w[3] w[2] w[1] w[0] s[7] s[6] s[5] s[4] s[3] s[2] s[1] s[0] pulse[1] pulse[0] spike[4] spike[3] spike[2] spike[1] spike[0]
Xxdac0_0 Isum_0 w[3] w[2] w[1] w[0] pulse[0] s[0] Vb VDD VDD VSS DAC
Xxdpi0 VDD Vthr VMEM_0 Isum_0 VT_dpi VSS DPI
Xxneu0 VSS VDD VMEM_0 VNA Vlk VK VIp VKup VKdn Vamp_bias VT spike[0] neuron
Xxdac1_0 Isum_1 w[7] w[6] w[5] w[4] pulse[1] s[1] Vb VDD VDD VSS DAC
Xxdpi1 VDD Vthr VMEM_1 Isum_1 VT_dpi VSS DPI
Xxneu1 VSS VDD VMEM_1 VNA Vlk VK VIp VKup VKdn Vamp_bias VT spike[1] neuron
Xxdac2_0 Isum_2 w[11] w[10] w[9] w[8] spike[0] s[2] Vb Isum_inh2 VDD VSS DAC
Xxdac2_1 Isum_2 w[15] w[14] w[13] w[12] spike[1] s[3] Vb Isum_inh2 VDD VSS DAC
Xxdpi2 VDD Vthr VMEM_2 Isum_2 VT_dpi VSS DPI
Xxneu2 VSS VDD VMEM_2 VNA Vlk VK VIp VKup VKdn Vamp_bias VT spike[2] neuron
Xxdac3_0 Isum_3 w[19] w[18] w[17] w[16] spike[0] s[4] Vb Isum_inh3 VDD VSS DAC
Xxdac3_1 Isum_3 w[23] w[22] w[21] w[20] spike[1] s[5] Vb Isum_inh3 VDD VSS DAC
Xxdpi3 VDD Vthr VMEM_3 Isum_3 VT_dpi VSS DPI
Xxneu3 VSS VDD VMEM_3 VNA Vlk VK VIp VKup VKdn Vamp_bias VT spike[3] neuron
Xxdac4_0 Isum_4 w[27] w[26] w[25] w[24] spike[2] s[6] Vb Isum_inh4 VDD VSS DAC
Xxdac4_1 Isum_4 w[31] w[30] w[29] w[28] spike[3] s[7] Vb Isum_inh4 VDD VSS DAC
Xxdpi4 VDD Vthr VMEM_4 Isum_4 VT_dpi VSS DPI
Xxdpi5 Vthr VT_dpi Isum_inh4 VDD VMEM_4 VSS DPI_inh
Xxneu4 VSS VDD VMEM_4 VNA Vlk VK VIp VKup VKdn Vamp_bias VT spike[4] neuron
Xxdpi6 Vthr VT_dpi Isum_inh2 VDD VMEM_2 VSS DPI_inh
Xxdpi7 Vthr VT_dpi Isum_inh3 VDD VMEM_3 VSS DPI_inh
Xxbias VDD VSS Iref Vb Vlk VKdn VIp Vamp_bias VK VNA VKup Vthr VT_dpi xbias_VT_inh_nc bias
.ends
