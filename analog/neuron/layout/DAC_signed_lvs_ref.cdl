* LVS reference for the DAC_signed layout (gen_dac_signed.py, default dac=DAC_binary).
* Devices and nets as in analog/neuron/DAC_signed.sch, with these layout-only changes:
*   - x1 is the binary DAC layout cell (DAC_binary.gds, weights 1:2:4:8) instead of DAC.sym
*     (1:2:3:4); its reference is DAC_binary_lvs_ref.spice, copied below
*   - GND (a global in the schematic) is a port; VDD is shared with the DAC's DNWELL tie
.subckt DAC_binary Isum Vb w[3] w[2] w[1] w[0] en VDD GND
MMen Isum en X GND nfet_03v3 L=0.28u W=0.22u nf=1
MM1 X w[0] net4 net4 nfet_03v3 L=0.28u W=0.22u nf=1
MM2 net4 Vb GND GND nfet_03v3 L=8u W=1u nf=1
MM3 X w[1] net2 net2 nfet_03v3 L=0.28u W=0.44u nf=2
MM4 net2 Vb GND GND nfet_03v3 L=8u W=2u nf=2
MM5 X w[2] net3 net3 nfet_03v3 L=0.28u W=0.88u nf=4
MM6 net3 Vb GND GND nfet_03v3 L=8u W=4u nf=4
MM7 X w[3] net1 net1 nfet_03v3 L=0.28u W=1.76u nf=8
MM8 net1 Vb GND GND nfet_03v3 L=8u W=8u nf=8
* dummies at the ends of the switch rows
MMEN_DL GND GND GND GND nfet_03v3 L=0.28u W=0.22u nf=1
MMEN_DR GND GND GND GND nfet_03v3 L=0.28u W=0.22u nf=1
MA_DL net4 net4 net4 net4 nfet_03v3 L=0.28u W=0.22u nf=1
MA_DR net4 net4 net4 net4 nfet_03v3 L=0.28u W=0.22u nf=1
MB_DL net2 net2 net2 net2 nfet_03v3 L=0.28u W=0.22u nf=1
MB_DR net2 net2 net2 net2 nfet_03v3 L=0.28u W=0.22u nf=1
MC_DL net3 net3 net3 net3 nfet_03v3 L=0.28u W=0.22u nf=1
MC_DR net3 net3 net3 net3 nfet_03v3 L=0.28u W=0.22u nf=1
MD_DL net1 net1 net1 net1 nfet_03v3 L=0.28u W=0.22u nf=1
MD_DR net1 net1 net1 net1 nfet_03v3 L=0.28u W=0.22u nf=1
* dummy rows above (_T) and below (_B) each switch row (all terminals on that well's body net)
MMEN_T0 GND GND GND GND nfet_03v3 L=0.28u W=0.22u nf=1
MMEN_T1 GND GND GND GND nfet_03v3 L=0.28u W=0.22u nf=1
MMEN_T2 GND GND GND GND nfet_03v3 L=0.28u W=0.22u nf=1
MMEN_B0 GND GND GND GND nfet_03v3 L=0.28u W=0.22u nf=1
MMEN_B1 GND GND GND GND nfet_03v3 L=0.28u W=0.22u nf=1
MMEN_B2 GND GND GND GND nfet_03v3 L=0.28u W=0.22u nf=1
MA_T0 net4 net4 net4 net4 nfet_03v3 L=0.28u W=0.22u nf=1
MA_T1 net4 net4 net4 net4 nfet_03v3 L=0.28u W=0.22u nf=1
MA_T2 net4 net4 net4 net4 nfet_03v3 L=0.28u W=0.22u nf=1
MA_B0 net4 net4 net4 net4 nfet_03v3 L=0.28u W=0.22u nf=1
MA_B1 net4 net4 net4 net4 nfet_03v3 L=0.28u W=0.22u nf=1
MA_B2 net4 net4 net4 net4 nfet_03v3 L=0.28u W=0.22u nf=1
MB_T0 net2 net2 net2 net2 nfet_03v3 L=0.28u W=0.22u nf=1
MB_T1 net2 net2 net2 net2 nfet_03v3 L=0.28u W=0.22u nf=1
MB_T2 net2 net2 net2 net2 nfet_03v3 L=0.28u W=0.22u nf=1
MB_T3 net2 net2 net2 net2 nfet_03v3 L=0.28u W=0.22u nf=1
MB_B0 net2 net2 net2 net2 nfet_03v3 L=0.28u W=0.22u nf=1
MB_B1 net2 net2 net2 net2 nfet_03v3 L=0.28u W=0.22u nf=1
MB_B2 net2 net2 net2 net2 nfet_03v3 L=0.28u W=0.22u nf=1
MB_B3 net2 net2 net2 net2 nfet_03v3 L=0.28u W=0.22u nf=1
MC_T0 net3 net3 net3 net3 nfet_03v3 L=0.28u W=0.22u nf=1
MC_T1 net3 net3 net3 net3 nfet_03v3 L=0.28u W=0.22u nf=1
MC_T2 net3 net3 net3 net3 nfet_03v3 L=0.28u W=0.22u nf=1
MC_T3 net3 net3 net3 net3 nfet_03v3 L=0.28u W=0.22u nf=1
MC_T4 net3 net3 net3 net3 nfet_03v3 L=0.28u W=0.22u nf=1
MC_T5 net3 net3 net3 net3 nfet_03v3 L=0.28u W=0.22u nf=1
MC_B0 net3 net3 net3 net3 nfet_03v3 L=0.28u W=0.22u nf=1
MC_B1 net3 net3 net3 net3 nfet_03v3 L=0.28u W=0.22u nf=1
MC_B2 net3 net3 net3 net3 nfet_03v3 L=0.28u W=0.22u nf=1
MC_B3 net3 net3 net3 net3 nfet_03v3 L=0.28u W=0.22u nf=1
MC_B4 net3 net3 net3 net3 nfet_03v3 L=0.28u W=0.22u nf=1
MC_B5 net3 net3 net3 net3 nfet_03v3 L=0.28u W=0.22u nf=1
MD_T0 net1 net1 net1 net1 nfet_03v3 L=0.28u W=0.22u nf=1
MD_T1 net1 net1 net1 net1 nfet_03v3 L=0.28u W=0.22u nf=1
MD_T2 net1 net1 net1 net1 nfet_03v3 L=0.28u W=0.22u nf=1
MD_T3 net1 net1 net1 net1 nfet_03v3 L=0.28u W=0.22u nf=1
MD_T4 net1 net1 net1 net1 nfet_03v3 L=0.28u W=0.22u nf=1
MD_T5 net1 net1 net1 net1 nfet_03v3 L=0.28u W=0.22u nf=1
MD_T6 net1 net1 net1 net1 nfet_03v3 L=0.28u W=0.22u nf=1
MD_T7 net1 net1 net1 net1 nfet_03v3 L=0.28u W=0.22u nf=1
MD_T8 net1 net1 net1 net1 nfet_03v3 L=0.28u W=0.22u nf=1
MD_T9 net1 net1 net1 net1 nfet_03v3 L=0.28u W=0.22u nf=1
MD_B0 net1 net1 net1 net1 nfet_03v3 L=0.28u W=0.22u nf=1
MD_B1 net1 net1 net1 net1 nfet_03v3 L=0.28u W=0.22u nf=1
MD_B2 net1 net1 net1 net1 nfet_03v3 L=0.28u W=0.22u nf=1
MD_B3 net1 net1 net1 net1 nfet_03v3 L=0.28u W=0.22u nf=1
MD_B4 net1 net1 net1 net1 nfet_03v3 L=0.28u W=0.22u nf=1
MD_B5 net1 net1 net1 net1 nfet_03v3 L=0.28u W=0.22u nf=1
MD_B6 net1 net1 net1 net1 nfet_03v3 L=0.28u W=0.22u nf=1
MD_B7 net1 net1 net1 net1 nfet_03v3 L=0.28u W=0.22u nf=1
MD_B8 net1 net1 net1 net1 nfet_03v3 L=0.28u W=0.22u nf=1
MD_B9 net1 net1 net1 net1 nfet_03v3 L=0.28u W=0.22u nf=1
* dummy ring around the current-source array (20 devices, all GND)
MDA_b0 GND GND GND GND nfet_03v3 L=8u W=1u nf=1
MDA_b1 GND GND GND GND nfet_03v3 L=8u W=1u nf=1
MDA_b2 GND GND GND GND nfet_03v3 L=8u W=1u nf=1
MDA_b3 GND GND GND GND nfet_03v3 L=8u W=1u nf=1
MDA_b4 GND GND GND GND nfet_03v3 L=8u W=1u nf=1
MDA_b5 GND GND GND GND nfet_03v3 L=8u W=1u nf=1
MDA_b6 GND GND GND GND nfet_03v3 L=8u W=1u nf=1
MDA_t0 GND GND GND GND nfet_03v3 L=8u W=1u nf=1
MDA_t1 GND GND GND GND nfet_03v3 L=8u W=1u nf=1
MDA_t2 GND GND GND GND nfet_03v3 L=8u W=1u nf=1
MDA_t3 GND GND GND GND nfet_03v3 L=8u W=1u nf=1
MDA_t4 GND GND GND GND nfet_03v3 L=8u W=1u nf=1
MDA_t5 GND GND GND GND nfet_03v3 L=8u W=1u nf=1
MDA_t6 GND GND GND GND nfet_03v3 L=8u W=1u nf=1
MDA_10 GND GND GND GND nfet_03v3 L=8u W=1u nf=1
MDA_16 GND GND GND GND nfet_03v3 L=8u W=1u nf=1
MDA_20 GND GND GND GND nfet_03v3 L=8u W=1u nf=1
MDA_26 GND GND GND GND nfet_03v3 L=8u W=1u nf=1
MDA_30 GND GND GND GND nfet_03v3 L=8u W=1u nf=1
MDA_36 GND GND GND GND nfet_03v3 L=8u W=1u nf=1
.ends

.subckt DAC_signed Isum_e Isum_i s Vb w[3] w[2] w[1] w[0] en VDD GND
x1 Y Vb w[3] w[2] w[1] w[0] en VDD GND DAC_binary
MMse Isum_e sb Y GND nfet_03v3 L=0.28u W=0.22u nf=1
MMsi Isum_i s Y GND nfet_03v3 L=0.28u W=0.22u nf=1
MMpi sb s VDD VDD pfet_03v3 L=0.28u W=0.44u nf=1
MMni sb s GND GND nfet_03v3 L=0.28u W=0.22u nf=1
.ends
