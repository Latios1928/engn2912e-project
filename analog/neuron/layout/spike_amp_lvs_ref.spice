* LVS reference for spike_amp.gds (generated by gen_spike_amp.py)
* = spike_amplifier_sized.sch with M3 0.5/0.64 (glayout min W) + dummy rings
.subckt spike_amp VDD VSS VP VN VB spike_out
XM1 net2 VP net1 VSS nfet_03v3 L=2u W=4u nf=1
XM2 spike_out VN net1 VSS nfet_03v3 L=2u W=4u nf=1
XM3 net1 VB VSS VSS nfet_03v3 L=0.64u W=0.5u nf=1
XM4 net2 net2 VDD VDD pfet_03v3 L=8u W=0.5u nf=1
XM5 spike_out net2 VDD VDD pfet_03v3 L=8u W=0.5u nf=1
XDNN0 VSS VSS VSS VSS nfet_03v3 L=2u W=0.5u nf=1
XDNN1 VSS VSS VSS VSS nfet_03v3 L=2u W=0.5u nf=1
XDNN2 VSS VSS VSS VSS nfet_03v3 L=2u W=0.5u nf=1
XDNN3 VSS VSS VSS VSS nfet_03v3 L=2u W=0.5u nf=1
XDNN4 VSS VSS VSS VSS nfet_03v3 L=2u W=0.5u nf=1
XDNN5 VSS VSS VSS VSS nfet_03v3 L=2u W=0.5u nf=1
XDNS0 VSS VSS VSS VSS nfet_03v3 L=2u W=0.5u nf=1
XDNS1 VSS VSS VSS VSS nfet_03v3 L=2u W=0.5u nf=1
XDNS2 VSS VSS VSS VSS nfet_03v3 L=2u W=0.5u nf=1
XDNS3 VSS VSS VSS VSS nfet_03v3 L=2u W=0.5u nf=1
XDNS4 VSS VSS VSS VSS nfet_03v3 L=2u W=0.5u nf=1
XDNS5 VSS VSS VSS VSS nfet_03v3 L=2u W=0.5u nf=1
XDNW0 VSS VSS VSS VSS nfet_03v3 L=2u W=8.24u nf=1
XDNE0 VSS VSS VSS VSS nfet_03v3 L=2u W=8.24u nf=1
XDPN0 VDD VDD VDD VDD pfet_03v3 L=8u W=0.5u nf=1
XDPN1 VDD VDD VDD VDD pfet_03v3 L=8u W=0.5u nf=1
XDPN2 VDD VDD VDD VDD pfet_03v3 L=8u W=0.5u nf=1
XDPN3 VDD VDD VDD VDD pfet_03v3 L=8u W=0.5u nf=1
XDPS0 VDD VDD VDD VDD pfet_03v3 L=8u W=0.5u nf=1
XDPS1 VDD VDD VDD VDD pfet_03v3 L=8u W=0.5u nf=1
XDPS2 VDD VDD VDD VDD pfet_03v3 L=8u W=0.5u nf=1
XDPS3 VDD VDD VDD VDD pfet_03v3 L=8u W=0.5u nf=1
XDPW0 VDD VDD VDD VDD pfet_03v3 L=8u W=0.5u nf=1
XDPE0 VDD VDD VDD VDD pfet_03v3 L=8u W=0.5u nf=1
.ends
