* NGSPICE file created from SNN_flat.ext - technology: gf180mcuD

.subckt SNN_flat spike[0] spike[3] VDD VSS Iref w[0] w[1] w[2] w[3] w[4] w[5] w[6]
+ w[7] w[8] w[9] w[10] w[11] w[12] w[13] w[14] w[15] w[16] w[17] w[18] w[19] w[20]
+ w[21] w[22] w[23] w[24] w[25] w[26] w[27] w[28] w[29] w[30] w[31] pulse[0] pulse[1]
+ s[0] s[1] VT spike[2] spike[1] spike[4]
X0 bias_cell_0.VT_dpi bias_cell_0.VT_dpi VDD VDD pfet_03v3 ad=0.1074p pd=1.08u as=0.1074p ps=1.08u w=0.22u l=0.28u
X1 VSS VSS VSS VSS nfet_03v3 ad=0.2014p pd=1.98u as=0.72393n ps=4.91971m w=0.22u l=0.28u
X2 VSS VSS VSS VSS nfet_03v3 ad=0.2014p pd=1.98u as=0 ps=0 w=0.22u l=0.28u
X3 VSS VSS VSS VSS nfet_03v3 ad=0.61p pd=3.22u as=0 ps=0 w=1u l=8u
X4 VSS w[5] a_5364_23116# VSS nfet_03v3 ad=0.2014p pd=1.98u as=0.2014p ps=1.98u w=0.22u l=0.28u
X5 VSS VSS VSS VSS nfet_03v3 ad=0.2014p pd=1.98u as=0 ps=0 w=0.22u l=0.28u
X6 VSS w[25] a_3364_81516# VSS nfet_03v3 ad=0.2014p pd=1.98u as=0.2014p ps=1.98u w=0.22u l=0.28u
X7 VSS VSS VSS VSS nfet_03v3 ad=0.61p pd=3.22u as=0 ps=0 w=1u l=8u
X8 VSS w[23] a_5364_69692# VSS nfet_03v3 ad=0.2014p pd=1.98u as=0.2014p ps=1.98u w=0.22u l=0.28u
X9 VSS w[13] a_5364_46404# VSS nfet_03v3 ad=0.2014p pd=1.98u as=0.2014p ps=1.98u w=0.22u l=0.28u
X10 VSS VSS VSS VSS nfet_03v3 ad=0.61p pd=3.22u as=0 ps=0 w=1u l=8u
X11 VSS VSS VSS VSS nfet_03v3 ad=0.61p pd=3.22u as=0 ps=0 w=1u l=8u
X12 VSS VSS VSS VSS nfet_03v3 ad=0.61p pd=3.22u as=0 ps=0 w=1u l=8u
X13 VSS VSS VSS VSS nfet_03v3 ad=0.61p pd=3.22u as=0 ps=0 w=1u l=1u
X14 VSS bias_cell_0.Vb VSS VSS nfet_03v3 ad=0.61p pd=3.22u as=0 ps=0 w=1u l=8u
X15 VSS VSS VSS VSS nfet_03v3 ad=0.2014p pd=1.98u as=0 ps=0 w=0.22u l=0.28u
X16 bias_cell_0.Vthr bias_cell_0.Vthr VDD VDD pfet_03v3 ad=0.1074p pd=1.08u as=0.1074p ps=1.08u w=0.22u l=0.28u
X17 VSS w[31] a_3364_92980# VSS nfet_03v3 ad=0.2014p pd=1.98u as=0.2014p ps=1.98u w=0.22u l=0.28u
X18 VSS VSS VSS VSS nfet_03v3 ad=0.2014p pd=1.98u as=0 ps=0 w=0.22u l=0.28u
X19 VSS VSS VSS VSS nfet_03v3 ad=0.61p pd=3.22u as=0 ps=0 w=1u l=8u
X20 VSS bias_cell_0.Vb VSS VSS nfet_03v3 ad=0.61p pd=3.22u as=0 ps=0 w=1u l=8u
X21 VDD VDD VDD VDD pfet_03v3 ad=0.2166p pd=2.06u as=0.14012n ps=0.83427m w=0.22u l=0.28u
X22 VSS VSS VSS VSS nfet_03v3 ad=0.2014p pd=1.98u as=0 ps=0 w=0.22u l=0.28u
X23 VDD VDD VDD VDD pfet_03v3 ad=0.65p pd=3.3u as=0 ps=0 w=1u l=1u
X24 VSS VSS VSS VSS nfet_03v3 ad=0.2014p pd=1.98u as=0 ps=0 w=0.22u l=0.28u
X25 VSS VSS VSS VSS nfet_03v3 ad=0.2014p pd=1.98u as=0 ps=0 w=0.22u l=0.28u
X26 neuron_sized_1.VMEM spike[3] a_43986_51190# VSS nfet_03v3 ad=0.2014p pd=1.98u as=0.2014p ps=1.98u w=0.22u l=5u
X27 VSS VSS VSS VSS nfet_03v3 ad=0.2014p pd=1.98u as=0 ps=0 w=0.22u l=0.28u
X28 DAC_signed_1.DAC_binary_0.Isum a_23094_79840# DPI_0.Isum VSS nfet_03v3 ad=0.2014p pd=1.98u as=0.2014p ps=1.98u w=0.22u l=0.28u
X29 VDD VDD VDD VDD pfet_03v3 ad=0.65p pd=3.3u as=0 ps=0 w=1u l=1u
X30 VSS VSS VSS VSS nfet_03v3 ad=0.61p pd=3.22u as=0 ps=0 w=1u l=1u
X31 VSS VSS VSS VSS nfet_03v3 ad=0.2014p pd=1.98u as=0 ps=0 w=0.22u l=0.28u
X32 VSS VSS VSS VSS nfet_03v3 ad=0.2014p pd=1.98u as=0 ps=0 w=0.22u l=0.28u
X33 VSS VSS VSS VSS nfet_03v3 ad=0.61p pd=3.22u as=0 ps=0 w=1u l=8u
X34 VSS VSS VSS VSS nfet_03v3 ad=0.61p pd=3.22u as=0 ps=0 w=1u l=8u
X35 VDD bias_cell_0.VT_dpi bias_cell_0.VT_dpi VDD pfet_03v3 ad=0.1074p pd=1.08u as=0.1074p ps=1.08u w=0.22u l=0.28u
X36 VSS VSS VSS VSS nfet_03v3 ad=0.2014p pd=1.98u as=0 ps=0 w=0.22u l=0.28u
X37 VSS bias_cell_0.Vb VSS VSS nfet_03v3 ad=0.61p pd=3.22u as=0 ps=0 w=1u l=8u
X38 a_48826_16078# bias_cell_0.VKdn VSS VSS nfet_03v3 ad=0.61p pd=3.22u as=0.61p ps=3.22u w=1u l=1u
X39 bias_cell_0.Vlk a_2244_98592# VDD VDD pfet_03v3 ad=0.546p pd=2.98u as=0.546p ps=2.98u w=0.84u l=16u
X40 VDD bias_cell_0.Vthr bias_cell_0.Vthr VDD pfet_03v3 ad=0.1074p pd=1.08u as=0.1074p ps=1.08u w=0.22u l=0.28u
X41 VSS VSS VSS VSS nfet_03v3 ad=0.61p pd=3.22u as=0 ps=0 w=1u l=8u
X42 VSS VSS VSS VSS nfet_03v3 ad=0.2014p pd=1.98u as=0 ps=0 w=0.22u l=0.28u
X43 VSS bias_cell_0.Vb VSS VSS nfet_03v3 ad=0.61p pd=3.22u as=0 ps=0 w=1u l=8u
X44 spike[2] VSS cap_mim_2f0_m4m5_noshield c_width=10u c_length=10u
X45 a_46472_20418# a_50306_20496# spike[1] VDD pfet_03v3 ad=0.2166p pd=2.06u as=0.2166p ps=2.06u w=0.22u l=0.28u
X46 VSS VSS VSS VSS nfet_03v3 ad=0.2014p pd=1.98u as=0 ps=0 w=0.22u l=0.28u
X47 VDD a_2244_98592# bias_cell_0.VKdn VDD pfet_03v3 ad=2.10275p pd=7.77u as=1.13225p ps=3.935u w=3.235u l=8u
X48 VSS VSS VSS VSS nfet_03v3 ad=0.2014p pd=1.98u as=0 ps=0 w=0.22u l=0.28u
X49 VSS VSS VSS VSS nfet_03v3 ad=0.2014p pd=1.98u as=0 ps=0 w=0.22u l=0.28u
X50 VSS VSS VSS VSS nfet_03v3 ad=0.2014p pd=1.98u as=0 ps=0 w=0.22u l=0.28u
X51 a_45268_4332# neuron_sized_4.VMEM a_44260_8656# VSS nfet_03v3 ad=0.2014p pd=1.98u as=0.2014p ps=1.98u w=0.22u l=0.28u
X52 VDD VDD VDD VDD pfet_03v3 ad=0.2166p pd=2.06u as=0 ps=0 w=0.22u l=0.28u
X53 VSS w[23] a_5364_69692# VSS nfet_03v3 ad=0.2014p pd=1.98u as=0.2014p ps=1.98u w=0.22u l=0.28u
X54 VSS w[30] a_3364_92980# VSS nfet_03v3 ad=0.2014p pd=1.98u as=0.2014p ps=1.98u w=0.22u l=0.28u
X55 VSS VSS VSS VSS nfet_03v3 ad=0.2014p pd=1.98u as=0 ps=0 w=0.22u l=0.28u
X56 VSS bias_cell_0.Vb VSS VSS nfet_03v3 ad=0.61p pd=3.22u as=0 ps=0 w=1u l=8u
X57 VSS VSS VSS VSS nfet_03v3 ad=0.2014p pd=1.98u as=0 ps=0 w=0.22u l=0.28u
X58 VSS VSS VSS VSS nfet_03v3 ad=0.61p pd=3.22u as=0 ps=0 w=1u l=8u
X59 VSS VSS VSS VSS nfet_03v3 ad=0.2014p pd=1.98u as=0 ps=0 w=0.22u l=0.28u
X60 a_34406_27492# bias_cell_0.VT_dpi VDD VDD pfet_03v3 ad=0.2166p pd=2.06u as=0.2166p ps=2.06u w=0.22u l=0.28u
X61 VSS VSS VSS VSS nfet_03v3 ad=0.2014p pd=1.98u as=0 ps=0 w=0.22u l=0.28u
X62 VSS VSS VSS VSS nfet_03v3 ad=0.61p pd=3.22u as=0 ps=0 w=1u l=1u
X63 VSS VSS VSS VSS nfet_03v3 ad=0.2014p pd=1.98u as=0 ps=0 w=0.22u l=0.28u
X64 VSS VSS VSS VSS nfet_03v3 ad=0.2014p pd=1.98u as=0 ps=0 w=0.22u l=0.28u
X65 bias_cell_0.VT_dpi bias_cell_0.VT_dpi VDD VDD pfet_03v3 ad=0.1074p pd=1.08u as=0.1074p ps=1.08u w=0.22u l=0.28u
X66 VDD bias_cell_0.VT_inh bias_cell_0.VT_inh VDD pfet_03v3 ad=0.308p pd=1.58u as=0.308p ps=1.58u w=0.88u l=1.12u
X67 VSS VSS VSS VSS nfet_03v3 ad=0.2014p pd=1.98u as=0 ps=0 w=0.22u l=0.28u
X68 VSS VSS VSS VSS nfet_03v3 ad=0.2014p pd=1.98u as=0 ps=0 w=0.22u l=0.28u
X69 VSS bias_cell_0.Vb VSS VSS nfet_03v3 ad=0.61p pd=3.22u as=0 ps=0 w=1u l=8u
X70 VSS VSS VSS VSS nfet_03v3 ad=0.2014p pd=1.98u as=0 ps=0 w=0.22u l=0.28u
X71 VSS VSS VSS VSS nfet_03v3 ad=0.61p pd=3.22u as=0 ps=0 w=1u l=1u
X72 VSS VSS VSS VSS nfet_03v3 ad=0.2014p pd=1.98u as=0 ps=0 w=0.22u l=0.28u
X73 VSS bias_cell_0.Vb VSS VSS nfet_03v3 ad=0.61p pd=3.22u as=0 ps=0 w=1u l=8u
X74 VSS VSS VSS VSS nfet_03v3 ad=0.2014p pd=1.98u as=0 ps=0 w=0.22u l=0.28u
X75 bias_cell_0.VK a_2244_98592# VDD VDD pfet_03v3 ad=0.7315p pd=2.79u as=1.3585p ps=5.48u w=2.09u l=8u
X76 bias_cell_0.VT_dpi bias_cell_0.VT_dpi VDD VDD pfet_03v3 ad=0.1074p pd=1.08u as=0.1074p ps=1.08u w=0.22u l=0.28u
X77 VSS VSS VSS VSS nfet_03v3 ad=0.2014p pd=1.98u as=0 ps=0 w=0.22u l=0.28u
X78 VSS VSS VSS VSS nfet_03v3 ad=0.2014p pd=1.98u as=0 ps=0 w=0.22u l=0.28u
X79 VSS w[3] a_5364_11292# VSS nfet_03v3 ad=0.2014p pd=1.98u as=0.2014p ps=1.98u w=0.22u l=0.28u
X80 VSS VSS VSS VSS nfet_03v3 ad=0.2014p pd=1.98u as=0 ps=0 w=0.22u l=0.28u
X81 VSS VSS VSS VSS nfet_03v3 ad=0.2014p pd=1.98u as=0 ps=0 w=0.22u l=0.28u
X82 a_50306_55608# a_45030_55608# a_48106_51190# VSS nfet_03v3 ad=0.2014p pd=1.98u as=0.2014p ps=1.98u w=0.22u l=0.28u
X83 VSS VSS VSS VSS nfet_03v3 ad=0.2014p pd=1.98u as=0 ps=0 w=0.22u l=0.28u
X84 VDD VDD VDD VDD pfet_03v3 ad=0.2166p pd=2.06u as=0 ps=0 w=0.22u l=0.28u
X85 VDD VDD VDD VDD pfet_03v3 ad=0.65p pd=3.3u as=0 ps=0 w=1u l=1u
X86 VSS w[7] a_5364_23116# VSS nfet_03v3 ad=0.2014p pd=1.98u as=0.2014p ps=1.98u w=0.22u l=0.28u
X87 Iref Iref VSS VSS nfet_03v3 ad=1.75p pd=5.7u as=3.05p ps=11.22u w=5u l=8u
X88 VSS VSS VSS VSS nfet_03v3 ad=0.61p pd=3.22u as=0 ps=0 w=1u l=8u
X89 VSS VSS VSS VSS nfet_03v3 ad=0.61p pd=3.22u as=0 ps=0 w=1u l=8u
X90 VSS VSS VSS VSS nfet_03v3 ad=0.61p pd=3.22u as=0 ps=0 w=1u l=8u
X91 VSS VSS VSS VSS nfet_03v3 ad=0.61p pd=3.22u as=0 ps=0 w=1u l=8u
X92 VSS VSS VSS VSS nfet_03v3 ad=0.61p pd=3.22u as=0 ps=0 w=1u l=1u
X93 VDD bias_cell_0.VT_dpi bias_cell_0.VT_dpi VDD pfet_03v3 ad=0.1074p pd=1.08u as=0.1074p ps=1.08u w=0.22u l=0.28u
X94 VSS VSS VSS VSS nfet_03v3 ad=0.2014p pd=1.98u as=0 ps=0 w=0.22u l=0.28u
X95 VSS w[11] a_5364_34940# VSS nfet_03v3 ad=0.2014p pd=1.98u as=0.2014p ps=1.98u w=0.22u l=0.28u
X96 VSS VSS VSS VSS nfet_03v3 ad=0.61p pd=3.22u as=0 ps=0 w=1u l=8u
X97 VDD VDD VDD VDD pfet_03v3 ad=0.2166p pd=2.06u as=0 ps=0 w=0.22u l=0.28u
X98 VDD VDD VDD VDD pfet_03v3 ad=0.65p pd=3.3u as=0 ps=0 w=1u l=1u
X99 VSS w[5] a_5364_23116# VSS nfet_03v3 ad=0.2014p pd=1.98u as=0.2014p ps=1.98u w=0.22u l=0.28u
X100 bias_cell_0.VKdn bias_cell_0.VKdn VSS VSS nfet_03v3 ad=0.35p pd=1.7u as=0.61p ps=3.22u w=1u l=1u
X101 VSS VSS VSS VSS nfet_03v3 ad=0.61p pd=3.22u as=0 ps=0 w=1u l=8u
X102 VSS w[19] a_5364_58228# VSS nfet_03v3 ad=0.2014p pd=1.98u as=0.2014p ps=1.98u w=0.22u l=0.28u
X103 VSS bias_cell_0.Vb VSS VSS nfet_03v3 ad=0.61p pd=3.22u as=0 ps=0 w=1u l=8u
X104 a_34406_50780# VDD cap_mim_2f0_m4m5_noshield c_width=22.36u c_length=22.36u
X105 VSS VSS VSS VSS nfet_03v3 ad=0.61p pd=3.22u as=0 ps=0 w=1u l=8u
X106 VSS VSS VSS VSS nfet_03v3 ad=0.61p pd=3.22u as=0 ps=0 w=1u l=8u
X107 VSS VSS VSS VSS nfet_03v3 ad=0.2014p pd=1.98u as=0 ps=0 w=0.22u l=0.28u
X108 VDD VDD VDD VDD pfet_03v3 ad=0.65p pd=3.3u as=0 ps=0 w=1u l=1u
X109 VDD bias_cell_0.VT_dpi bias_cell_0.VT_dpi VDD pfet_03v3 ad=0.1074p pd=1.08u as=0.1074p ps=1.08u w=0.22u l=0.28u
X110 VSS VSS VSS VSS nfet_03v3 ad=0.61p pd=3.22u as=0 ps=0 w=1u l=8u
X111 VSS VSS VSS VSS nfet_03v3 ad=0.61p pd=3.22u as=0 ps=0 w=1u l=8u
X112 VDD VDD VDD VDD pfet_03v3 ad=0.65p pd=3.3u as=0 ps=0 w=1u l=1u
X113 VSS VSS VSS VSS nfet_03v3 ad=0.61p pd=3.22u as=0 ps=0 w=1u l=1u
X114 neuron_sized_3.VMEM spike[1] a_43986_16078# VSS nfet_03v3 ad=0.2014p pd=1.98u as=0.2014p ps=1.98u w=0.22u l=5u
X115 VSS VSS VSS VSS nfet_03v3 ad=0.2014p pd=1.98u as=0 ps=0 w=0.22u l=0.28u
X116 VSS w[22] a_5364_69692# VSS nfet_03v3 ad=0.2014p pd=1.98u as=0.2014p ps=1.98u w=0.22u l=0.28u
X117 VDD VDD VDD VDD pfet_03v3 ad=0.65p pd=3.3u as=0 ps=0 w=1u l=1u
X118 VSS VSS VSS VSS nfet_03v3 ad=0.2014p pd=1.98u as=0 ps=0 w=0.22u l=0.28u
X119 VSS VSS VSS VSS nfet_03v3 ad=0.2014p pd=1.98u as=0 ps=0 w=0.22u l=0.28u
X120 VDD VDD VDD VDD pfet_03v3 ad=0.2166p pd=2.06u as=0 ps=0 w=0.22u l=0.28u
X121 VSS VSS VSS VSS nfet_03v3 ad=0.2014p pd=1.98u as=0 ps=0 w=0.22u l=0.28u
X122 VSS VSS VSS VSS nfet_03v3 ad=0.2014p pd=1.98u as=0 ps=0 w=0.22u l=0.28u
X123 a_45030_78896# VT a_45268_74556# VSS nfet_03v3 ad=0.2014p pd=1.98u as=0.2014p ps=1.98u w=0.22u l=0.28u
X124 VSS VSS VSS VSS nfet_03v3 ad=0.2014p pd=1.98u as=0 ps=0 w=0.22u l=0.28u
X125 a_43986_27902# bias_cell_0.VK VSS VSS nfet_03v3 ad=0.61p pd=3.22u as=0.61p ps=3.22u w=1u l=1u
X126 VSS VSS VSS VSS nfet_03v3 ad=0.61p pd=3.22u as=0 ps=0 w=1u l=8u
X127 VSS VSS VSS VSS nfet_03v3 ad=0.61p pd=3.22u as=0 ps=0 w=1u l=8u
X128 VSS VSS VSS VSS nfet_03v3 ad=0.2014p pd=1.98u as=0 ps=0 w=0.22u l=0.28u
X129 VSS VSS VSS VSS nfet_03v3 ad=0.2014p pd=1.98u as=0 ps=0 w=0.22u l=0.28u
X130 VSS w[3] a_5364_11292# VSS nfet_03v3 ad=0.2014p pd=1.98u as=0.2014p ps=1.98u w=0.22u l=0.28u
X131 VSS VSS VSS VSS nfet_03v3 ad=0.2014p pd=1.98u as=0 ps=0 w=0.22u l=0.28u
X132 VSS VSS VSS VSS nfet_03v3 ad=0.2014p pd=1.98u as=0 ps=0 w=0.22u l=0.28u
X133 VSS VSS VSS VSS nfet_03v3 ad=0.2014p pd=1.98u as=0 ps=0 w=0.22u l=0.28u
X134 VSS VSS VSS VSS nfet_03v3 ad=0.2014p pd=1.98u as=0 ps=0 w=0.22u l=0.28u
X135 VSS VSS VSS VSS nfet_03v3 ad=0.61p pd=3.22u as=0 ps=0 w=1u l=8u
X136 bias_cell_0.VT_dpi bias_cell_0.VT_dpi VDD VDD pfet_03v3 ad=0.1074p pd=1.08u as=0.1074p ps=1.08u w=0.22u l=0.28u
X137 VSS VSS VSS VSS nfet_03v3 ad=0.61p pd=3.22u as=0 ps=0 w=1u l=1u
X138 VSS w[10] a_5364_34940# VSS nfet_03v3 ad=0.2014p pd=1.98u as=0.2014p ps=1.98u w=0.22u l=0.28u
X139 DPI_inh_0.Isum s[0] DAC_signed_1.DAC_binary_0.Isum VSS nfet_03v3 ad=0.2014p pd=1.98u as=0.2014p ps=1.98u w=0.22u l=0.28u
X140 VSS w[18] a_5364_58228# VSS nfet_03v3 ad=0.2014p pd=1.98u as=0.2014p ps=1.98u w=0.22u l=0.28u
X141 VDD VDD VDD VDD pfet_03v3 ad=0.2166p pd=2.06u as=0 ps=0 w=0.22u l=0.28u
X142 bias_cell_0.Vamp_bias bias_cell_0.Vamp_bias VSS VSS nfet_03v3 ad=0.2014p pd=1.98u as=0.2014p ps=1.98u w=0.22u l=0.28u
X143 VSS VSS VSS VSS nfet_03v3 ad=0.2014p pd=1.98u as=0 ps=0 w=0.22u l=0.28u
X144 VSS VSS VSS VSS nfet_03v3 ad=0.2014p pd=1.98u as=0 ps=0 w=0.22u l=0.28u
X145 VSS VSS VSS VSS nfet_03v3 ad=0.2014p pd=1.98u as=0 ps=0 w=0.22u l=0.28u
X146 VSS VSS VSS VSS nfet_03v3 ad=0.61p pd=3.22u as=0 ps=0 w=1u l=8u
X147 VSS bias_cell_0.Vb VSS VSS nfet_03v3 ad=0.61p pd=3.22u as=0 ps=0 w=1u l=8u
X148 bias_cell_0.Vthr bias_cell_0.Vthr VDD VDD pfet_03v3 ad=0.1074p pd=1.08u as=0.1074p ps=1.08u w=0.22u l=0.28u
X149 VSS VSS VSS VSS nfet_03v3 ad=0.2014p pd=1.98u as=0 ps=0 w=0.22u l=0.28u
X150 neuron_sized_4.VMEM a_50306_8672# a_43278_8594# VDD pfet_03v3 ad=0.2166p pd=2.06u as=0.2166p ps=2.06u w=0.22u l=0.28u
X151 VSS VSS VSS VSS nfet_03v3 ad=0.61p pd=3.22u as=0 ps=0 w=1u l=1u
X152 VSS VSS VSS VSS nfet_03v3 ad=0.2014p pd=1.98u as=0 ps=0 w=0.22u l=0.28u
X153 VSS VSS VSS VSS nfet_03v3 ad=0.61p pd=3.22u as=0 ps=0 w=1u l=8u
X154 VSS VSS VSS VSS nfet_03v3 ad=0.2014p pd=1.98u as=0 ps=0 w=0.22u l=0.28u
X155 VSS VSS VSS VSS nfet_03v3 ad=0.2014p pd=1.98u as=0 ps=0 w=0.22u l=0.28u
X156 VSS VSS VSS VSS nfet_03v3 ad=0.61p pd=3.22u as=0 ps=0 w=1u l=8u
X157 VSS VSS VSS VSS nfet_03v3 ad=0.2014p pd=1.98u as=0 ps=0 w=0.22u l=0.28u
X158 VSS VSS VSS VSS nfet_03v3 ad=0.2014p pd=1.98u as=0 ps=0 w=0.22u l=0.28u
X159 VSS VSS VSS VSS nfet_03v3 ad=0.61p pd=3.22u as=0 ps=0 w=1u l=8u
X160 VSS VSS VSS VSS nfet_03v3 ad=0.2014p pd=1.98u as=0 ps=0 w=0.22u l=0.28u
X161 a_50306_20496# a_45030_20496# a_48106_16078# VSS nfet_03v3 ad=0.2014p pd=1.98u as=0.2014p ps=1.98u w=0.22u l=0.28u
X162 VSS VSS VSS VSS nfet_03v3 ad=0.2014p pd=1.98u as=0 ps=0 w=0.22u l=0.28u
X163 VSS VSS VSS VSS nfet_03v3 ad=0.2014p pd=1.98u as=0 ps=0 w=0.22u l=0.28u
X164 VDD bias_cell_0.VT_dpi bias_cell_0.VT_dpi VDD pfet_03v3 ad=0.1074p pd=1.08u as=0.1074p ps=1.08u w=0.22u l=0.28u
X165 VDD VDD VDD VDD pfet_03v3 ad=0.65p pd=3.3u as=0 ps=0 w=1u l=1u
X166 VSS VSS VSS VSS nfet_03v3 ad=0.61p pd=3.22u as=0 ps=0 w=1u l=8u
X167 VSS VSS VSS VSS nfet_03v3 ad=0.61p pd=3.22u as=0 ps=0 w=1u l=8u
X168 VDD bias_cell_0.Vthr bias_cell_0.Vthr VDD pfet_03v3 ad=0.1074p pd=1.08u as=0.1074p ps=1.08u w=0.22u l=0.28u
X169 VSS VSS VSS VSS nfet_03v3 ad=0.2014p pd=1.98u as=0 ps=0 w=0.22u l=0.28u
X170 VSS bias_cell_0.Vb VSS VSS nfet_03v3 ad=0.61p pd=3.22u as=0 ps=0 w=1u l=8u
X171 VDD VDD VDD VDD pfet_03v3 ad=0.65p pd=3.3u as=0 ps=0 w=1u l=1u
X172 VSS VSS VSS VSS nfet_03v3 ad=0.61p pd=3.22u as=0 ps=0 w=1u l=8u
X173 VSS VSS VSS VSS nfet_03v3 ad=0.2014p pd=1.98u as=0 ps=0 w=0.22u l=0.28u
X174 VSS w[2] a_5364_11292# VSS nfet_03v3 ad=0.2014p pd=1.98u as=0.2014p ps=1.98u w=0.22u l=0.28u
X175 VSS bias_cell_0.Vb VSS VSS nfet_03v3 ad=0.61p pd=3.22u as=0 ps=0 w=1u l=8u
X176 VSS VSS VSS VSS nfet_03v3 ad=0.61p pd=3.22u as=0 ps=0 w=1u l=8u
X177 VSS bias_cell_0.Vb VSS VSS nfet_03v3 ad=0.61p pd=3.22u as=0 ps=0 w=1u l=8u
X178 a_50306_78896# a_45030_78896# VDD VDD pfet_03v3 ad=0.2166p pd=2.06u as=0.2166p ps=2.06u w=0.22u l=0.28u
X179 VSS w[30] a_3364_92980# VSS nfet_03v3 ad=0.2014p pd=1.98u as=0.2014p ps=1.98u w=0.22u l=0.28u
X180 neuron_sized_2.VMEM VSS cap_mim_2f0_m4m5_noshield c_width=22.18u c_length=22.18u
X181 VDD VDD VDD VDD pfet_03v3 ad=0.2166p pd=2.06u as=0 ps=0 w=0.22u l=0.28u
X182 bias_cell_0.VT_dpi bias_cell_0.VT_dpi VDD VDD pfet_03v3 ad=0.1074p pd=1.08u as=0.1074p ps=1.08u w=0.22u l=0.28u
X183 VSS VSS VSS VSS nfet_03v3 ad=0.2014p pd=1.98u as=0 ps=0 w=0.22u l=0.28u
X184 a_45030_55608# VT a_45268_51268# VSS nfet_03v3 ad=0.2014p pd=1.98u as=0.2014p ps=1.98u w=0.22u l=0.28u
X185 VSS VSS VSS VSS nfet_03v3 ad=0.2014p pd=1.98u as=0 ps=0 w=0.22u l=0.28u
X186 VSS VSS VSS VSS nfet_03v3 ad=0.2014p pd=1.98u as=0 ps=0 w=0.22u l=0.28u
X187 VSS VSS VSS VSS nfet_03v3 ad=0.61p pd=3.22u as=0 ps=0 w=1u l=1u
X188 VSS VSS VSS VSS nfet_03v3 ad=0.2014p pd=1.98u as=0 ps=0 w=0.22u l=0.28u
X189 VSS VSS VSS VSS nfet_03v3 ad=0.2014p pd=1.98u as=0 ps=0 w=0.22u l=0.28u
X190 VSS VSS VSS VSS nfet_03v3 ad=0.2014p pd=1.98u as=0 ps=0 w=0.22u l=0.28u
X191 a_45030_20496# a_44260_20480# VDD VDD pfet_03v3 ad=0.2166p pd=2.06u as=0.2166p ps=2.06u w=0.22u l=0.28u
X192 VSS bias_cell_0.Vb VSS VSS nfet_03v3 ad=0.61p pd=3.22u as=0 ps=0 w=1u l=8u
X193 VSS VSS VSS VSS nfet_03v3 ad=0.2014p pd=1.98u as=0 ps=0 w=0.22u l=0.28u
X194 VDD bias_cell_0.VT_dpi bias_cell_0.VT_dpi VDD pfet_03v3 ad=0.1074p pd=1.08u as=0.1074p ps=1.08u w=0.22u l=0.28u
X195 VSS VSS VSS VSS nfet_03v3 ad=0.2014p pd=1.98u as=0 ps=0 w=0.22u l=0.28u
X196 VSS VSS VSS VSS nfet_03v3 ad=0.2014p pd=1.98u as=0 ps=0 w=0.22u l=0.28u
X197 VSS VSS VSS VSS nfet_03v3 ad=0.2014p pd=1.98u as=0 ps=0 w=0.22u l=0.28u
X198 VSS VSS VSS VSS nfet_03v3 ad=0.61p pd=3.22u as=0 ps=0 w=1u l=8u
X199 bias_cell_0.VT_inh bias_cell_0.VT_inh VDD VDD pfet_03v3 ad=0.308p pd=1.58u as=0.308p ps=1.58u w=0.88u l=1.12u
X200 VSS VSS VSS VSS nfet_03v3 ad=0.2014p pd=1.98u as=0 ps=0 w=0.22u l=0.28u
X201 VSS VSS VSS VSS nfet_03v3 ad=0.61p pd=3.22u as=0 ps=0 w=1u l=1u
X202 VSS VSS VSS VSS nfet_03v3 ad=0.2014p pd=1.98u as=0 ps=0 w=0.22u l=0.28u
X203 a_3364_92980# spike[3] DAC_signed_0.DAC_binary_0.Isum VSS nfet_03v3 ad=0.2014p pd=1.98u as=0.2014p ps=1.98u w=0.22u l=0.28u
X204 VSS VSS VSS VSS nfet_03v3 ad=0.2014p pd=1.98u as=0 ps=0 w=0.22u l=0.28u
X205 VDD bias_cell_0.Vthr DPI_2.Isum DPI_2.Isum nfet_03v3 ad=0.2014p pd=1.98u as=0.2014p ps=1.98u w=0.22u l=0.28u
X206 VSS VSS VSS VSS nfet_03v3 ad=0.2014p pd=1.98u as=0 ps=0 w=0.22u l=0.28u
X207 VSS VSS VSS VSS nfet_03v3 ad=0.2014p pd=1.98u as=0 ps=0 w=0.22u l=0.28u
X208 VSS VSS VSS VSS nfet_03v3 ad=0.2014p pd=1.98u as=0 ps=0 w=0.22u l=0.28u
X209 VSS VSS VSS VSS nfet_03v3 ad=0.2014p pd=1.98u as=0 ps=0 w=0.22u l=0.28u
X210 VSS VSS VSS VSS nfet_03v3 ad=0.2014p pd=1.98u as=0 ps=0 w=0.22u l=0.28u
X211 VSS VSS VSS VSS nfet_03v3 ad=0.2014p pd=1.98u as=0 ps=0 w=0.22u l=0.28u
X212 VSS VSS VSS VSS nfet_03v3 ad=0.2014p pd=1.98u as=0 ps=0 w=0.22u l=0.28u
X213 VSS VSS VSS VSS nfet_03v3 ad=0.2014p pd=1.98u as=0 ps=0 w=0.22u l=0.28u
X214 VDD VDD VDD VDD pfet_03v3 ad=0.65p pd=3.3u as=0 ps=0 w=1u l=1u
X215 VSS w[24] a_3364_81516# VSS nfet_03v3 ad=0.2014p pd=1.98u as=0.2014p ps=1.98u w=0.22u l=0.28u
X216 VSS w[12] a_5364_46404# VSS nfet_03v3 ad=0.2014p pd=1.98u as=0.2014p ps=1.98u w=0.22u l=0.28u
X217 VDD VDD VDD VDD pfet_03v3 ad=0.65p pd=3.3u as=0 ps=0 w=1u l=1u
X218 VSS w[3] a_5364_11292# VSS nfet_03v3 ad=0.2014p pd=1.98u as=0.2014p ps=1.98u w=0.22u l=0.28u
X219 VSS VSS VSS VSS nfet_03v3 ad=0.2014p pd=1.98u as=0 ps=0 w=0.22u l=0.28u
X220 VDD VDD VDD VDD pfet_03v3 ad=0.65p pd=3.3u as=0 ps=0 w=1u l=1u
X221 VSS VSS VSS VSS nfet_03v3 ad=0.2014p pd=1.98u as=0 ps=0 w=0.22u l=0.28u
X222 VSS VSS VSS VSS nfet_03v3 ad=0.61p pd=3.22u as=0 ps=0 w=1u l=8u
X223 VSS VSS VSS VSS nfet_03v3 ad=0.61p pd=3.22u as=0 ps=0 w=1u l=8u
X224 VSS bias_cell_0.Vb VSS VSS nfet_03v3 ad=0.61p pd=3.22u as=0 ps=0 w=1u l=8u
X225 VSS VSS VSS VSS nfet_03v3 ad=0.61p pd=3.22u as=0 ps=0 w=1u l=8u
X226 VSS w[10] a_5364_34940# VSS nfet_03v3 ad=0.2014p pd=1.98u as=0.2014p ps=1.98u w=0.22u l=0.28u
X227 VSS VSS VSS VSS nfet_03v3 ad=0.61p pd=3.22u as=0 ps=0 w=1u l=1u
X228 VSS VSS VSS VSS nfet_03v3 ad=0.2014p pd=1.98u as=0 ps=0 w=0.22u l=0.28u
X229 VSS VSS VSS VSS nfet_03v3 ad=0.2014p pd=1.98u as=0 ps=0 w=0.22u l=0.28u
X230 VSS w[18] a_5364_58228# VSS nfet_03v3 ad=0.2014p pd=1.98u as=0.2014p ps=1.98u w=0.22u l=0.28u
X231 VDD VDD VDD VDD pfet_03v3 ad=0.65p pd=3.3u as=0 ps=0 w=1u l=1u
X232 VSS VSS VSS VSS nfet_03v3 ad=0.2014p pd=1.98u as=0 ps=0 w=0.22u l=0.28u
X233 VSS VSS VSS VSS nfet_03v3 ad=0.61p pd=3.22u as=0 ps=0 w=1u l=1u
X234 VDD VDD VDD VDD pfet_03v3 ad=0.65p pd=3.3u as=0 ps=0 w=1u l=1u
X235 VSS VSS VSS VSS nfet_03v3 ad=0.2014p pd=1.98u as=0 ps=0 w=0.22u l=0.28u
X236 bias_cell_0.VK a_2244_98592# VDD VDD pfet_03v3 ad=0.7315p pd=2.79u as=0.7315p ps=2.79u w=2.09u l=8u
X237 VSS VSS VSS VSS nfet_03v3 ad=0.61p pd=3.22u as=0 ps=0 w=1u l=8u
X238 VSS VSS VSS VSS nfet_03v3 ad=0.2014p pd=1.98u as=0 ps=0 w=0.22u l=0.28u
X239 VSS VSS VSS VSS nfet_03v3 ad=0.2014p pd=1.98u as=0 ps=0 w=0.22u l=0.28u
X240 VDD a_2244_98592# bias_cell_0.VK VDD pfet_03v3 ad=0.7315p pd=2.79u as=0.7315p ps=2.79u w=2.09u l=8u
X241 VSS bias_cell_0.Vb VSS VSS nfet_03v3 ad=0.61p pd=3.22u as=0 ps=0 w=1u l=8u
X242 a_45030_20496# VT a_45268_16156# VSS nfet_03v3 ad=0.2014p pd=1.98u as=0.2014p ps=1.98u w=0.22u l=0.28u
X243 VSS VSS VSS VSS nfet_03v3 ad=0.61p pd=3.22u as=0 ps=0 w=1u l=8u
X244 VSS VSS VSS VSS nfet_03v3 ad=0.2014p pd=1.98u as=0 ps=0 w=0.22u l=0.28u
X245 VSS VSS VSS VSS nfet_03v3 ad=0.2014p pd=1.98u as=0 ps=0 w=0.22u l=0.28u
X246 a_46472_55530# bias_cell_0.VKup VDD VDD pfet_03v3 ad=0.65p pd=3.3u as=0.65p ps=3.3u w=1u l=1u
X247 VDD VDD VDD VDD pfet_03v3 ad=0.2166p pd=2.06u as=0 ps=0 w=0.22u l=0.28u
X248 bias_cell_0.Vamp_bias a_2244_98592# VDD VDD pfet_03v3 ad=1.5995p pd=5.27u as=2.9705p ps=10.44u w=4.57u l=8u
X249 VSS VSS VSS VSS nfet_03v3 ad=0.2014p pd=1.98u as=0 ps=0 w=0.22u l=0.28u
X250 VSS VSS VSS VSS nfet_03v3 ad=0.61p pd=3.22u as=0 ps=0 w=1u l=1u
X251 VSS VSS VSS VSS nfet_03v3 ad=0.2014p pd=1.98u as=0 ps=0 w=0.22u l=0.28u
X252 VSS VSS VSS VSS nfet_03v3 ad=0.2014p pd=1.98u as=0 ps=0 w=0.22u l=0.28u
X253 VSS VSS VSS VSS nfet_03v3 ad=0.2014p pd=1.98u as=0 ps=0 w=0.22u l=0.28u
X254 a_48106_74478# bias_cell_0.VIp VSS VSS nfet_03v3 ad=0.61p pd=3.22u as=0.61p ps=3.22u w=1u l=1u
X255 bias_cell_0.VT_dpi bias_cell_0.VT_dpi VDD VDD pfet_03v3 ad=0.1074p pd=1.08u as=0.1074p ps=1.08u w=0.22u l=0.28u
X256 VSS bias_cell_0.Vb VSS VSS nfet_03v3 ad=0.61p pd=3.22u as=0 ps=0 w=1u l=8u
X257 VSS VSS VSS VSS nfet_03v3 ad=0.2014p pd=1.98u as=0 ps=0 w=0.22u l=0.28u
X258 VSS bias_cell_0.Vb VSS VSS nfet_03v3 ad=0.61p pd=3.22u as=0 ps=0 w=1u l=8u
X259 VSS VSS VSS VSS nfet_03v3 ad=0.2014p pd=1.98u as=0 ps=0 w=0.22u l=0.28u
X260 VSS VSS VSS VSS nfet_03v3 ad=0.2014p pd=1.98u as=0 ps=0 w=0.22u l=0.28u
X261 VSS VSS VSS VSS nfet_03v3 ad=0.2014p pd=1.98u as=0 ps=0 w=0.22u l=0.28u
X262 a_5364_34940# spike[0] DPI_2.Isum VSS nfet_03v3 ad=0.2014p pd=1.98u as=0.2014p ps=1.98u w=0.22u l=0.28u
X263 a_5364_58228# spike[0] DPI_1.Isum VSS nfet_03v3 ad=0.2014p pd=1.98u as=0.2014p ps=1.98u w=0.22u l=0.28u
X264 VSS VSS VSS VSS nfet_03v3 ad=0.2014p pd=1.98u as=0 ps=0 w=0.22u l=0.28u
X265 VSS bias_cell_0.Vb VSS VSS nfet_03v3 ad=0.61p pd=3.22u as=0 ps=0 w=1u l=8u
X266 VSS VSS VSS VSS nfet_03v3 ad=0.2014p pd=1.98u as=0 ps=0 w=0.22u l=0.28u
X267 VSS bias_cell_0.Vb VSS VSS nfet_03v3 ad=0.61p pd=3.22u as=0 ps=0 w=1u l=8u
X268 VSS VSS VSS VSS nfet_03v3 ad=0.2014p pd=1.98u as=0 ps=0 w=0.22u l=0.28u
X269 VSS VSS VSS VSS nfet_03v3 ad=0.2014p pd=1.98u as=0 ps=0 w=0.22u l=0.28u
X270 VSS bias_cell_0.Vb VSS VSS nfet_03v3 ad=0.61p pd=3.22u as=0 ps=0 w=1u l=8u
X271 VSS VSS VSS VSS nfet_03v3 ad=0.2014p pd=1.98u as=0 ps=0 w=0.22u l=0.28u
X272 VSS bias_cell_0.Vb VSS VSS nfet_03v3 ad=0.61p pd=3.22u as=0 ps=0 w=1u l=8u
X273 neuron_sized_2.VMEM bias_cell_0.Vlk VSS VSS nfet_03v3 ad=0.61p pd=3.22u as=0.61p ps=3.22u w=1u l=1u
X274 VSS w[31] a_3364_92980# VSS nfet_03v3 ad=0.2014p pd=1.98u as=0.2014p ps=1.98u w=0.22u l=0.28u
X275 VSS VSS VSS VSS nfet_03v3 ad=0.2014p pd=1.98u as=0 ps=0 w=0.22u l=0.28u
X276 VSS VSS VSS VSS nfet_03v3 ad=0.2014p pd=1.98u as=0 ps=0 w=0.22u l=0.28u
X277 VSS bias_cell_0.Vb VSS VSS nfet_03v3 ad=0.61p pd=3.22u as=0 ps=0 w=1u l=8u
X278 VSS w[4] a_5364_23116# VSS nfet_03v3 ad=0.2014p pd=1.98u as=0.2014p ps=1.98u w=0.22u l=0.28u
X279 VSS VSS VSS VSS nfet_03v3 ad=0.61p pd=3.22u as=0 ps=0 w=1u l=8u
X280 VSS bias_cell_0.Vb VSS VSS nfet_03v3 ad=0.61p pd=3.22u as=0 ps=0 w=1u l=8u
X281 VSS VSS VSS VSS nfet_03v3 ad=0.2014p pd=1.98u as=0 ps=0 w=0.22u l=0.28u
X282 VSS VSS VSS VSS nfet_03v3 ad=0.61p pd=3.22u as=0 ps=0 w=1u l=8u
X283 VSS VSS VSS VSS nfet_03v3 ad=0.61p pd=3.22u as=0 ps=0 w=1u l=8u
X284 VSS VSS VSS VSS nfet_03v3 ad=0.2014p pd=1.98u as=0 ps=0 w=0.22u l=0.28u
X285 VSS VSS VSS VSS nfet_03v3 ad=0.2014p pd=1.98u as=0 ps=0 w=0.22u l=0.28u
X286 VSS VSS VSS VSS nfet_03v3 ad=0.61p pd=3.22u as=0 ps=0 w=1u l=8u
X287 VSS VSS VSS VSS nfet_03v3 ad=0.2014p pd=1.98u as=0 ps=0 w=0.22u l=0.28u
X288 bias_cell_0.VT_inh bias_cell_0.VT_inh VDD VDD pfet_03v3 ad=0.308p pd=1.58u as=0.308p ps=1.58u w=0.88u l=1.12u
X289 VSS VSS VSS VSS nfet_03v3 ad=0.61p pd=3.22u as=0 ps=0 w=1u l=1u
X290 VSS bias_cell_0.Vb VSS VSS nfet_03v3 ad=0.61p pd=3.22u as=0 ps=0 w=1u l=8u
X291 VSS VSS VSS VSS nfet_03v3 ad=0.2014p pd=1.98u as=0 ps=0 w=0.22u l=0.28u
X292 VSS VSS VSS VSS nfet_03v3 ad=0.61p pd=3.22u as=0 ps=0 w=1u l=8u
X293 VSS VSS VSS VSS nfet_03v3 ad=0.2014p pd=1.98u as=0 ps=0 w=0.22u l=0.28u
X294 VSS bias_cell_0.Vb VSS VSS nfet_03v3 ad=0.61p pd=3.22u as=0 ps=0 w=1u l=8u
X295 a_46472_55530# a_50306_55608# spike[3] VDD pfet_03v3 ad=0.2166p pd=2.06u as=0.2166p ps=2.06u w=0.22u l=0.28u
X296 VSS VSS VSS VSS nfet_03v3 ad=0.2014p pd=1.98u as=0 ps=0 w=0.22u l=0.28u
X297 VSS VSS VSS VSS nfet_03v3 ad=0.2014p pd=1.98u as=0 ps=0 w=0.22u l=0.28u
X298 a_46472_32242# bias_cell_0.VKup VDD VDD pfet_03v3 ad=0.65p pd=3.3u as=0.65p ps=3.3u w=1u l=1u
X299 bias_cell_0.Vthr bias_cell_0.Vthr VDD VDD pfet_03v3 ad=0.1074p pd=1.08u as=0.1074p ps=1.08u w=0.22u l=0.28u
X300 VSS VSS VSS VSS nfet_03v3 ad=0.2014p pd=1.98u as=0 ps=0 w=0.22u l=0.28u
X301 VSS VSS VSS VSS nfet_03v3 ad=0.2014p pd=1.98u as=0 ps=0 w=0.22u l=0.28u
X302 VSS VSS VSS VSS nfet_03v3 ad=0.61p pd=3.22u as=0 ps=0 w=1u l=1u
X303 VSS VSS VSS VSS nfet_03v3 ad=0.2014p pd=1.98u as=0 ps=0 w=0.22u l=0.28u
X304 VDD VDD VDD VDD pfet_03v3 ad=0.65p pd=3.3u as=0 ps=0 w=1u l=1u
X305 VDD VDD VDD VDD pfet_03v3 ad=0.65p pd=3.3u as=0 ps=0 w=1u l=1u
X306 VSS VSS VSS VSS nfet_03v3 ad=0.2014p pd=1.98u as=0 ps=0 w=0.22u l=0.28u
X307 VSS VSS VSS VSS nfet_03v3 ad=0.2014p pd=1.98u as=0 ps=0 w=0.22u l=0.28u
X308 bias_cell_0.Vthr bias_cell_0.Vthr VDD VDD pfet_03v3 ad=0.1074p pd=1.08u as=0.2166p ps=2.06u w=0.22u l=0.28u
X309 VSS w[31] a_3364_92980# VSS nfet_03v3 ad=0.2014p pd=1.98u as=0.2014p ps=1.98u w=0.22u l=0.28u
X310 a_45268_27980# bias_cell_0.Vamp_bias VSS VSS nfet_03v3 ad=0.2014p pd=1.98u as=0.2014p ps=1.98u w=0.22u l=0.28u
X311 VSS VSS VSS VSS nfet_03v3 ad=0.2014p pd=1.98u as=0 ps=0 w=0.22u l=0.28u
X312 VSS VSS VSS VSS nfet_03v3 ad=0.2014p pd=1.98u as=0 ps=0 w=0.22u l=0.28u
X313 VDD bias_cell_0.VT_dpi bias_cell_0.VT_dpi VDD pfet_03v3 ad=0.2166p pd=2.06u as=0.1074p ps=1.08u w=0.22u l=0.28u
X314 VSS VSS VSS VSS nfet_03v3 ad=0.2014p pd=1.98u as=0 ps=0 w=0.22u l=0.28u
X315 VSS VSS VSS VSS nfet_03v3 ad=0.2014p pd=1.98u as=0 ps=0 w=0.22u l=0.28u
X316 VSS VSS VSS VSS nfet_03v3 ad=0.2014p pd=1.98u as=0 ps=0 w=0.22u l=0.28u
X317 VSS VSS VSS VSS nfet_03v3 ad=0.2014p pd=1.98u as=0 ps=0 w=0.22u l=0.28u
X318 VSS VSS VSS VSS nfet_03v3 ad=0.2014p pd=1.98u as=0 ps=0 w=0.22u l=0.28u
X319 VSS VSS VSS VSS nfet_03v3 ad=0.2014p pd=1.98u as=0 ps=0 w=0.22u l=0.28u
X320 VSS VSS VSS VSS nfet_03v3 ad=0.2014p pd=1.98u as=0 ps=0 w=0.22u l=0.28u
X321 VSS VSS VSS VSS nfet_03v3 ad=0.2014p pd=1.98u as=0 ps=0 w=0.22u l=0.28u
X322 VSS VSS VSS VSS nfet_03v3 ad=0.2014p pd=1.98u as=0 ps=0 w=0.22u l=0.28u
X323 VSS VSS VSS VSS nfet_03v3 ad=0.2014p pd=1.98u as=0 ps=0 w=0.22u l=0.28u
X324 VDD bias_cell_0.Vthr bias_cell_0.Vthr VDD pfet_03v3 ad=0.1074p pd=1.08u as=0.1074p ps=1.08u w=0.22u l=0.28u
X325 VSS w[11] a_5364_34940# VSS nfet_03v3 ad=0.2014p pd=1.98u as=0.2014p ps=1.98u w=0.22u l=0.28u
X326 VSS bias_cell_0.Vb VSS VSS nfet_03v3 ad=0.61p pd=3.22u as=0 ps=0 w=1u l=8u
X327 VSS w[19] a_5364_58228# VSS nfet_03v3 ad=0.2014p pd=1.98u as=0.2014p ps=1.98u w=0.22u l=0.28u
X328 VSS VSS VSS VSS nfet_03v3 ad=0.2014p pd=1.98u as=0 ps=0 w=0.22u l=0.28u
X329 VSS VSS VSS VSS nfet_03v3 ad=0.2014p pd=1.98u as=0 ps=0 w=0.22u l=0.28u
X330 VSS bias_cell_0.Vb VSS VSS nfet_03v3 ad=0.61p pd=3.22u as=0 ps=0 w=1u l=8u
X331 VSS bias_cell_0.Vb VSS VSS nfet_03v3 ad=0.61p pd=3.22u as=0 ps=0 w=1u l=8u
X332 a_45268_27980# neuron_sized_2.VMEM a_44260_32304# VSS nfet_03v3 ad=0.2014p pd=1.98u as=0.2014p ps=1.98u w=0.22u l=0.28u
X333 VSS w[1] a_5364_11292# VSS nfet_03v3 ad=0.2014p pd=1.98u as=0.2014p ps=1.98u w=0.22u l=0.28u
X334 VSS VSS VSS VSS nfet_03v3 ad=0.2014p pd=1.98u as=0 ps=0 w=0.22u l=0.28u
X335 VSS w[23] a_5364_69692# VSS nfet_03v3 ad=0.2014p pd=1.98u as=0.2014p ps=1.98u w=0.22u l=0.28u
X336 bias_cell_0.VT_dpi bias_cell_0.VT_dpi VDD VDD pfet_03v3 ad=0.1074p pd=1.08u as=0.1074p ps=1.08u w=0.22u l=0.28u
X337 VDD VDD VDD VDD pfet_03v3 ad=0.65p pd=3.3u as=0 ps=0 w=1u l=1u
X338 VSS w[30] a_3364_92980# VSS nfet_03v3 ad=0.2014p pd=1.98u as=0.2014p ps=1.98u w=0.22u l=0.28u
X339 VSS VSS VSS VSS nfet_03v3 ad=0.2014p pd=1.98u as=0 ps=0 w=0.22u l=0.28u
X340 VSS bias_cell_0.Vb VSS VSS nfet_03v3 ad=0.61p pd=3.22u as=0 ps=0 w=1u l=8u
X341 VDD VDD VDD VDD pfet_03v3 ad=0.2166p pd=2.06u as=0 ps=0 w=0.22u l=0.28u
X342 bias_cell_0.VKup Iref VSS VSS nfet_03v3 ad=3.66305p pd=13.23u as=3.66305p ps=13.23u w=6.005u l=8u
X343 VSS VSS VSS VSS nfet_03v3 ad=0.2014p pd=1.98u as=0 ps=0 w=0.22u l=0.28u
X344 VSS VSS VSS VSS nfet_03v3 ad=0.2014p pd=1.98u as=0 ps=0 w=0.22u l=0.28u
X345 VSS VSS VSS VSS nfet_03v3 ad=0.2014p pd=1.98u as=0 ps=0 w=0.22u l=0.28u
X346 VSS VSS VSS VSS nfet_03v3 ad=0.61p pd=3.22u as=0 ps=0 w=1u l=8u
X347 VSS VSS VSS VSS nfet_03v3 ad=0.2014p pd=1.98u as=0 ps=0 w=0.22u l=0.28u
X348 VSS VSS VSS VSS nfet_03v3 ad=0.61p pd=3.22u as=0 ps=0 w=1u l=8u
X349 VSS VSS VSS VSS nfet_03v3 ad=0.2014p pd=1.98u as=0 ps=0 w=0.22u l=0.28u
X350 VSS bias_cell_0.Vb VSS VSS nfet_03v3 ad=0.61p pd=3.22u as=0 ps=0 w=1u l=8u
X351 VSS VSS VSS VSS nfet_03v3 ad=0.2014p pd=1.98u as=0 ps=0 w=0.22u l=0.28u
X352 a_46472_8594# bias_cell_0.VKup VDD VDD pfet_03v3 ad=0.65p pd=3.3u as=0.65p ps=3.3u w=1u l=1u
X353 VSS bias_cell_0.Vb VSS VSS nfet_03v3 ad=0.61p pd=3.22u as=0 ps=0 w=1u l=8u
X354 VSS VSS VSS VSS nfet_03v3 ad=0.2014p pd=1.98u as=0 ps=0 w=0.22u l=0.28u
X355 VSS VSS VSS VSS nfet_03v3 ad=0.61p pd=3.22u as=0 ps=0 w=1u l=8u
X356 VSS VSS VSS VSS nfet_03v3 ad=0.2014p pd=1.98u as=0 ps=0 w=0.22u l=0.28u
X357 VDD VDD VDD VDD pfet_03v3 ad=0.65p pd=3.3u as=0 ps=0 w=1u l=1u
X358 VSS VSS VSS VSS nfet_03v3 ad=0.2014p pd=1.98u as=0 ps=0 w=0.22u l=0.28u
X359 VSS bias_cell_0.Vb VSS VSS nfet_03v3 ad=0.61p pd=3.22u as=0 ps=0 w=1u l=8u
X360 a_43986_4254# bias_cell_0.VK VSS VSS nfet_03v3 ad=0.61p pd=3.22u as=0.61p ps=3.22u w=1u l=1u
X361 VSS w[11] a_5364_34940# VSS nfet_03v3 ad=0.2014p pd=1.98u as=0.2014p ps=1.98u w=0.22u l=0.28u
X362 a_50306_32320# a_45030_32320# VDD VDD pfet_03v3 ad=0.2166p pd=2.06u as=0.2166p ps=2.06u w=0.22u l=0.28u
X363 VSS VSS VSS VSS nfet_03v3 ad=0.2014p pd=1.98u as=0 ps=0 w=0.22u l=0.28u
X364 VSS w[19] a_5364_58228# VSS nfet_03v3 ad=0.2014p pd=1.98u as=0.2014p ps=1.98u w=0.22u l=0.28u
X365 VDD VDD VDD VDD pfet_03v3 ad=0.2166p pd=2.06u as=0 ps=0 w=0.22u l=0.28u
X366 VSS bias_cell_0.Vb VSS VSS nfet_03v3 ad=0.61p pd=3.22u as=0 ps=0 w=1u l=8u
X367 a_48106_16078# bias_cell_0.VIp VSS VSS nfet_03v3 ad=0.61p pd=3.22u as=0.61p ps=3.22u w=1u l=1u
X368 VSS VSS VSS VSS nfet_03v3 ad=0.2014p pd=1.98u as=0 ps=0 w=0.22u l=0.28u
X369 VSS w[22] a_5364_69692# VSS nfet_03v3 ad=0.2014p pd=1.98u as=0.2014p ps=1.98u w=0.22u l=0.28u
X370 VDD VDD VDD VDD pfet_03v3 ad=0.2166p pd=2.06u as=0 ps=0 w=0.22u l=0.28u
X371 bias_cell_0.VIp bias_cell_0.VIp VSS VSS nfet_03v3 ad=0.61p pd=3.22u as=0.61p ps=3.22u w=1u l=1u
X372 VSS VSS VSS VSS nfet_03v3 ad=0.2014p pd=1.98u as=0 ps=0 w=0.22u l=0.28u
X373 VDD s[1] a_23094_91304# VDD pfet_03v3 ad=0.286p pd=2.18u as=0.286p ps=2.18u w=0.44u l=0.28u
X374 VSS VSS VSS VSS nfet_03v3 ad=0.61p pd=3.22u as=0 ps=0 w=1u l=1u
X375 VDD bias_cell_0.VT_dpi bias_cell_0.VT_dpi VDD pfet_03v3 ad=0.1074p pd=1.08u as=0.1074p ps=1.08u w=0.22u l=0.28u
X376 VSS VSS VSS VSS nfet_03v3 ad=0.2014p pd=1.98u as=0 ps=0 w=0.22u l=0.28u
X377 a_43278_78818# bias_cell_0.VNA VDD VDD pfet_03v3 ad=0.65p pd=3.3u as=0.65p ps=3.3u w=1u l=1u
X378 VSS VSS VSS VSS nfet_03v3 ad=0.2014p pd=1.98u as=0 ps=0 w=0.22u l=0.28u
X379 VSS VSS VSS VSS nfet_03v3 ad=0.2014p pd=1.98u as=0 ps=0 w=0.22u l=0.28u
X380 VSS VSS VSS VSS nfet_03v3 ad=0.2014p pd=1.98u as=0 ps=0 w=0.22u l=0.28u
X381 VDD bias_cell_0.VT_inh bias_cell_0.VT_inh VDD pfet_03v3 ad=0.308p pd=1.58u as=0.308p ps=1.58u w=0.88u l=1.12u
X382 VSS VSS VSS VSS nfet_03v3 ad=0.2014p pd=1.98u as=0 ps=0 w=0.22u l=0.28u
X383 VSS VSS VSS VSS nfet_03v3 ad=0.2014p pd=1.98u as=0 ps=0 w=0.22u l=0.28u
X384 VSS VSS VSS VSS nfet_03v3 ad=0.2014p pd=1.98u as=0 ps=0 w=0.22u l=0.28u
X385 VSS VSS VSS VSS nfet_03v3 ad=0.2014p pd=1.98u as=0 ps=0 w=0.22u l=0.28u
X386 VSS w[27] a_3364_81516# VSS nfet_03v3 ad=0.2014p pd=1.98u as=0.2014p ps=1.98u w=0.22u l=0.28u
X387 VDD VDD VDD VDD pfet_03v3 ad=0.65p pd=3.3u as=0 ps=0 w=1u l=1u
X388 VSS VSS VSS VSS nfet_03v3 ad=0.61p pd=3.22u as=0 ps=0 w=1u l=1u
X389 VSS VSS VSS VSS nfet_03v3 ad=0.2014p pd=1.98u as=0 ps=0 w=0.22u l=0.28u
X390 VSS w[15] a_5364_46404# VSS nfet_03v3 ad=0.2014p pd=1.98u as=0.2014p ps=1.98u w=0.22u l=0.28u
X391 VSS VSS VSS VSS nfet_03v3 ad=0.2014p pd=1.98u as=0 ps=0 w=0.22u l=0.28u
X392 VSS VSS VSS VSS nfet_03v3 ad=0.61p pd=3.22u as=0 ps=0 w=1u l=1u
X393 VSS VSS VSS VSS nfet_03v3 ad=0.2014p pd=1.98u as=0 ps=0 w=0.22u l=0.28u
X394 a_48826_51190# bias_cell_0.VKdn VSS VSS nfet_03v3 ad=0.61p pd=3.22u as=0.61p ps=3.22u w=1u l=1u
X395 VSS VSS VSS VSS nfet_03v3 ad=0.2014p pd=1.98u as=0 ps=0 w=0.22u l=0.28u
X396 VSS w[3] a_5364_11292# VSS nfet_03v3 ad=0.2014p pd=1.98u as=0.2014p ps=1.98u w=0.22u l=0.28u
X397 bias_cell_0.Vthr bias_cell_0.Vthr VDD VDD pfet_03v3 ad=0.1074p pd=1.08u as=0.1074p ps=1.08u w=0.22u l=0.28u
X398 a_34406_74068# a_34406_74068# DPI_0.Isum DPI_0.Isum nfet_03v3 ad=0.2014p pd=1.98u as=0.2014p ps=1.98u w=0.22u l=0.28u
X399 VSS VSS VSS VSS nfet_03v3 ad=0.2014p pd=1.98u as=0 ps=0 w=0.22u l=0.28u
X400 VSS w[10] a_5364_34940# VSS nfet_03v3 ad=0.2014p pd=1.98u as=0.2014p ps=1.98u w=0.22u l=0.28u
X401 VDD VDD VDD VDD pfet_03v3 ad=0.2166p pd=2.06u as=0 ps=0 w=0.22u l=0.28u
X402 VSS w[31] a_3364_92980# VSS nfet_03v3 ad=0.2014p pd=1.98u as=0.2014p ps=1.98u w=0.22u l=0.28u
X403 VSS w[18] a_5364_58228# VSS nfet_03v3 ad=0.2014p pd=1.98u as=0.2014p ps=1.98u w=0.22u l=0.28u
X404 VSS w[1] a_5364_11292# VSS nfet_03v3 ad=0.2014p pd=1.98u as=0.2014p ps=1.98u w=0.22u l=0.28u
X405 VSS VSS VSS VSS nfet_03v3 ad=0.61p pd=3.22u as=0 ps=0 w=1u l=8u
X406 VSS VSS VSS VSS nfet_03v3 ad=0.61p pd=3.22u as=0 ps=0 w=1u l=8u
X407 VSS VSS VSS VSS nfet_03v3 ad=0.61p pd=3.22u as=0 ps=0 w=1u l=8u
X408 VSS VSS VSS VSS nfet_03v3 ad=0.2014p pd=1.98u as=0 ps=0 w=0.22u l=0.28u
X409 VSS bias_cell_0.Vb VSS VSS nfet_03v3 ad=0.61p pd=3.22u as=0 ps=0 w=1u l=8u
X410 VDD VDD VDD VDD pfet_03v3 ad=0.65p pd=3.3u as=0 ps=0 w=1u l=1u
X411 a_34406_3844# bias_cell_0.VT_dpi VDD VDD pfet_03v3 ad=0.2166p pd=2.06u as=0.2166p ps=2.06u w=0.22u l=0.28u
X412 VSS VSS VSS VSS nfet_03v3 ad=0.2014p pd=1.98u as=0 ps=0 w=0.22u l=0.28u
X413 VDD VDD VDD VDD pfet_03v3 ad=0.2166p pd=2.06u as=0 ps=0 w=0.22u l=0.28u
X414 bias_cell_0.Vthr bias_cell_0.Vthr VDD VDD pfet_03v3 ad=0.1074p pd=1.08u as=0.1074p ps=1.08u w=0.22u l=0.28u
X415 VDD bias_cell_0.VT_dpi bias_cell_0.VT_dpi VDD pfet_03v3 ad=0.1074p pd=1.08u as=0.1074p ps=1.08u w=0.22u l=0.28u
X416 VSS VSS VSS VSS nfet_03v3 ad=0.2014p pd=1.98u as=0 ps=0 w=0.22u l=0.28u
X417 VSS VSS VSS VSS nfet_03v3 ad=0.61p pd=3.22u as=0 ps=0 w=1u l=8u
X418 VSS VSS VSS VSS nfet_03v3 ad=0.61p pd=3.22u as=0 ps=0 w=1u l=8u
X419 VSS bias_cell_0.Vb VSS VSS nfet_03v3 ad=0.61p pd=3.22u as=0 ps=0 w=1u l=8u
X420 VSS VSS VSS VSS nfet_03v3 ad=0.61p pd=3.22u as=0 ps=0 w=1u l=8u
X421 VSS VSS VSS VSS nfet_03v3 ad=0.61p pd=3.22u as=0 ps=0 w=1u l=8u
X422 VSS VSS VSS VSS nfet_03v3 ad=0.2014p pd=1.98u as=0 ps=0 w=0.22u l=0.28u
X423 VSS VSS VSS VSS nfet_03v3 ad=0.2014p pd=1.98u as=0 ps=0 w=0.22u l=0.28u
X424 VSS VSS VSS VSS nfet_03v3 ad=0.61p pd=3.22u as=0 ps=0 w=1u l=8u
X425 VSS VSS VSS VSS nfet_03v3 ad=0.2014p pd=1.98u as=0 ps=0 w=0.22u l=0.28u
X426 VSS VSS VSS VSS nfet_03v3 ad=0.61p pd=3.22u as=0 ps=0 w=1u l=8u
X427 a_45030_55608# a_44260_55592# VDD VDD pfet_03v3 ad=0.2166p pd=2.06u as=0.2166p ps=2.06u w=0.22u l=0.28u
X428 VSS bias_cell_0.Vb VSS VSS nfet_03v3 ad=0.61p pd=3.22u as=0 ps=0 w=1u l=8u
X429 VDD VDD VDD VDD pfet_03v3 ad=0.2166p pd=2.06u as=0 ps=0 w=0.22u l=0.28u
X430 VSS VSS VSS VSS nfet_03v3 ad=0.61p pd=3.22u as=0 ps=0 w=1u l=8u
X431 VSS VSS VSS VSS nfet_03v3 ad=0.2014p pd=1.98u as=0 ps=0 w=0.22u l=0.28u
X432 VSS bias_cell_0.Vb VSS VSS nfet_03v3 ad=0.61p pd=3.22u as=0 ps=0 w=1u l=8u
X433 VSS VSS VSS VSS nfet_03v3 ad=0.2014p pd=1.98u as=0 ps=0 w=0.22u l=0.28u
X434 VDD VDD VDD VDD pfet_03v3 ad=0.2166p pd=2.06u as=0 ps=0 w=0.22u l=0.28u
X435 VDD bias_cell_0.Vthr bias_cell_0.Vthr VDD pfet_03v3 ad=0.1074p pd=1.08u as=0.1074p ps=1.08u w=0.22u l=0.28u
X436 VSS bias_cell_0.Vb VSS VSS nfet_03v3 ad=0.61p pd=3.22u as=0 ps=0 w=1u l=8u
X437 VDD VDD VDD VDD pfet_03v3 ad=0.2166p pd=2.06u as=0 ps=0 w=0.22u l=0.28u
X438 VSS VSS VSS VSS nfet_03v3 ad=0.2014p pd=1.98u as=0 ps=0 w=0.22u l=0.28u
X439 VDD bias_cell_0.VT_inh bias_cell_0.VT_inh VDD pfet_03v3 ad=0.308p pd=1.58u as=0.308p ps=1.58u w=0.88u l=1.12u
X440 VSS VSS VSS VSS nfet_03v3 ad=0.2014p pd=1.98u as=0 ps=0 w=0.22u l=0.28u
X441 VSS VSS VSS VSS nfet_03v3 ad=0.2014p pd=1.98u as=0 ps=0 w=0.22u l=0.28u
X442 VSS VSS VSS VSS nfet_03v3 ad=0.2014p pd=1.98u as=0 ps=0 w=0.22u l=0.28u
X443 VDD VDD VDD VDD pfet_03v3 ad=0.2166p pd=2.06u as=0 ps=0 w=0.22u l=0.28u
X444 VSS VSS VSS VSS nfet_03v3 ad=0.61p pd=3.22u as=0 ps=0 w=1u l=1u
X445 VSS VSS VSS VSS nfet_03v3 ad=0.61p pd=3.22u as=0 ps=0 w=1u l=1u
X446 VSS VSS VSS VSS nfet_03v3 ad=0.2014p pd=1.98u as=0 ps=0 w=0.22u l=0.28u
X447 VSS VSS VSS VSS nfet_03v3 ad=0.2014p pd=1.98u as=0 ps=0 w=0.22u l=0.28u
X448 VSS VSS VSS VSS nfet_03v3 ad=0.2014p pd=1.98u as=0 ps=0 w=0.22u l=0.28u
X449 VDD VDD VDD VDD pfet_03v3 ad=0.65p pd=3.3u as=0 ps=0 w=1u l=1u
X450 VSS VSS VSS VSS nfet_03v3 ad=0.2014p pd=1.98u as=0 ps=0 w=0.22u l=0.28u
X451 VSS VSS VSS VSS nfet_03v3 ad=0.2014p pd=1.98u as=0 ps=0 w=0.22u l=0.28u
X452 VSS VSS VSS VSS nfet_03v3 ad=0.2014p pd=1.98u as=0 ps=0 w=0.22u l=0.28u
X453 VSS VSS VSS VSS nfet_03v3 ad=0.61p pd=3.22u as=0 ps=0 w=1u l=8u
X454 VSS VSS VSS VSS nfet_03v3 ad=0.2014p pd=1.98u as=0 ps=0 w=0.22u l=0.28u
X455 VSS VSS VSS VSS nfet_03v3 ad=0.2014p pd=1.98u as=0 ps=0 w=0.22u l=0.28u
X456 VSS VSS VSS VSS nfet_03v3 ad=0.2014p pd=1.98u as=0 ps=0 w=0.22u l=0.28u
X457 VSS VSS VSS VSS nfet_03v3 ad=0.2014p pd=1.98u as=0 ps=0 w=0.22u l=0.28u
X458 VSS VSS VSS VSS nfet_03v3 ad=0.2014p pd=1.98u as=0 ps=0 w=0.22u l=0.28u
X459 bias_cell_0.VT_dpi bias_cell_0.VT_dpi VDD VDD pfet_03v3 ad=0.1074p pd=1.08u as=0.1074p ps=1.08u w=0.22u l=0.28u
X460 VSS VSS VSS VSS nfet_03v3 ad=0.2014p pd=1.98u as=0 ps=0 w=0.22u l=0.28u
X461 VSS VSS VSS VSS nfet_03v3 ad=0.2014p pd=1.98u as=0 ps=0 w=0.22u l=0.28u
X462 VSS VSS VSS VSS nfet_03v3 ad=0.61p pd=3.22u as=0 ps=0 w=1u l=1u
X463 neuron_sized_3.VMEM a_50306_20496# a_43278_20418# VDD pfet_03v3 ad=0.2166p pd=2.06u as=0.2166p ps=2.06u w=0.22u l=0.28u
X464 VSS VSS VSS VSS nfet_03v3 ad=0.2014p pd=1.98u as=0 ps=0 w=0.22u l=0.28u
X465 VSS w[7] a_5364_23116# VSS nfet_03v3 ad=0.2014p pd=1.98u as=0.2014p ps=1.98u w=0.22u l=0.28u
X466 VDD a_2244_98592# bias_cell_0.VKdn VDD pfet_03v3 ad=1.13225p pd=3.935u as=1.13225p ps=3.935u w=3.235u l=8u
X467 bias_cell_0.VKdn a_2244_98592# VDD VDD pfet_03v3 ad=1.13225p pd=3.935u as=2.10275p ps=7.77u w=3.235u l=8u
X468 VSS VSS VSS VSS nfet_03v3 ad=0.2014p pd=1.98u as=0 ps=0 w=0.22u l=0.28u
X469 VSS w[11] a_5364_34940# VSS nfet_03v3 ad=0.2014p pd=1.98u as=0.2014p ps=1.98u w=0.22u l=0.28u
X470 VSS w[19] a_5364_58228# VSS nfet_03v3 ad=0.2014p pd=1.98u as=0.2014p ps=1.98u w=0.22u l=0.28u
X471 a_34406_50780# a_34406_50780# DPI_1.Isum DPI_1.Isum nfet_03v3 ad=0.2014p pd=1.98u as=0.2014p ps=1.98u w=0.22u l=0.28u
X472 VSS VSS VSS VSS nfet_03v3 ad=0.2014p pd=1.98u as=0 ps=0 w=0.22u l=0.28u
X473 VSS VSS VSS VSS nfet_03v3 ad=0.2014p pd=1.98u as=0 ps=0 w=0.22u l=0.28u
X474 VDD VDD VDD VDD pfet_03v3 ad=0.2166p pd=2.06u as=0 ps=0 w=0.22u l=0.28u
X475 VDD bias_cell_0.Vthr bias_cell_0.Vthr VDD pfet_03v3 ad=0.2166p pd=2.06u as=0.1074p ps=1.08u w=0.22u l=0.28u
X476 VDD VDD VDD VDD pfet_03v3 ad=0.2166p pd=2.06u as=0 ps=0 w=0.22u l=0.28u
X477 VSS VSS VSS VSS nfet_03v3 ad=0.2014p pd=1.98u as=0 ps=0 w=0.22u l=0.28u
X478 VSS VSS VSS VSS nfet_03v3 ad=0.2014p pd=1.98u as=0 ps=0 w=0.22u l=0.28u
X479 VSS w[22] a_5364_69692# VSS nfet_03v3 ad=0.2014p pd=1.98u as=0.2014p ps=1.98u w=0.22u l=0.28u
X480 VSS VSS VSS VSS nfet_03v3 ad=0.61p pd=3.22u as=0 ps=0 w=1u l=8u
X481 VSS VSS VSS VSS nfet_03v3 ad=0.61p pd=3.22u as=0 ps=0 w=1u l=8u
X482 VSS VSS VSS VSS nfet_03v3 ad=0.2014p pd=1.98u as=0 ps=0 w=0.22u l=0.28u
X483 VSS VSS VSS VSS nfet_03v3 ad=0.61p pd=3.22u as=0 ps=0 w=1u l=8u
X484 VDD bias_cell_0.VT_dpi bias_cell_0.VT_dpi VDD pfet_03v3 ad=0.1074p pd=1.08u as=0.1074p ps=1.08u w=0.22u l=0.28u
X485 VSS VSS VSS VSS nfet_03v3 ad=0.2014p pd=1.98u as=0 ps=0 w=0.22u l=0.28u
X486 VSS VSS VSS VSS nfet_03v3 ad=0.61p pd=3.22u as=0 ps=0 w=1u l=8u
X487 VSS VSS VSS VSS nfet_03v3 ad=0.61p pd=3.22u as=0 ps=0 w=1u l=8u
X488 VSS bias_cell_0.Vb VSS VSS nfet_03v3 ad=0.61p pd=3.22u as=0 ps=0 w=1u l=8u
X489 VSS VSS VSS VSS nfet_03v3 ad=0.61p pd=3.22u as=0 ps=0 w=1u l=8u
X490 VSS VSS VSS VSS nfet_03v3 ad=0.61p pd=3.22u as=0 ps=0 w=1u l=1u
X491 neuron_sized_1.VMEM a_34406_50780# VDD VDD pfet_03v3 ad=0.2166p pd=2.06u as=0.2166p ps=2.06u w=0.22u l=0.28u
X492 VSS bias_cell_0.Vb VSS VSS nfet_03v3 ad=0.61p pd=3.22u as=0 ps=0 w=1u l=8u
X493 VSS VSS VSS VSS nfet_03v3 ad=0.2014p pd=1.98u as=0 ps=0 w=0.22u l=0.28u
X494 DPI_inh_0.Iout a_34406_74068# VDD VDD pfet_03v3 ad=0.2166p pd=2.06u as=0.2166p ps=2.06u w=0.22u l=0.28u
X495 VSS VSS VSS VSS nfet_03v3 ad=0.61p pd=3.22u as=0 ps=0 w=1u l=8u
X496 VSS VSS VSS VSS nfet_03v3 ad=0.2014p pd=1.98u as=0 ps=0 w=0.22u l=0.28u
X497 VSS VSS VSS VSS nfet_03v3 ad=0.2014p pd=1.98u as=0 ps=0 w=0.22u l=0.28u
X498 VSS VSS VSS VSS nfet_03v3 ad=0.2014p pd=1.98u as=0 ps=0 w=0.22u l=0.28u
X499 VSS VSS VSS VSS nfet_03v3 ad=0.61p pd=3.22u as=0 ps=0 w=1u l=8u
X500 bias_cell_0.VKup bias_cell_0.VKup VDD VDD pfet_03v3 ad=0.65p pd=3.3u as=0.65p ps=3.3u w=1u l=8u
X501 VSS VSS VSS VSS nfet_03v3 ad=0.61p pd=3.22u as=0 ps=0 w=1u l=8u
X502 VSS VSS VSS VSS nfet_03v3 ad=0.61p pd=3.22u as=0 ps=0 w=1u l=1u
X503 VSS bias_cell_0.Vb VSS VSS nfet_03v3 ad=0.61p pd=3.22u as=0 ps=0 w=1u l=8u
X504 VSS w[27] a_3364_81516# VSS nfet_03v3 ad=0.2014p pd=1.98u as=0.2014p ps=1.98u w=0.22u l=0.28u
X505 VSS VSS VSS VSS nfet_03v3 ad=0.61p pd=3.22u as=0 ps=0 w=1u l=1u
X506 VSS w[15] a_5364_46404# VSS nfet_03v3 ad=0.2014p pd=1.98u as=0.2014p ps=1.98u w=0.22u l=0.28u
X507 VSS VSS VSS VSS nfet_03v3 ad=0.2014p pd=1.98u as=0 ps=0 w=0.22u l=0.28u
X508 VSS VSS VSS VSS nfet_03v3 ad=0.61p pd=3.22u as=0 ps=0 w=1u l=1u
X509 bias_cell_0.Vthr bias_cell_0.Vthr VDD VDD pfet_03v3 ad=0.1074p pd=1.08u as=0.1074p ps=1.08u w=0.22u l=0.28u
X510 VSS bias_cell_0.Vb VSS VSS nfet_03v3 ad=0.61p pd=3.22u as=0 ps=0 w=1u l=8u
X511 VSS VSS VSS VSS nfet_03v3 ad=0.2014p pd=1.98u as=0 ps=0 w=0.22u l=0.28u
X512 VSS VSS VSS VSS nfet_03v3 ad=0.2014p pd=1.98u as=0 ps=0 w=0.22u l=0.28u
X513 VDD VDD VDD VDD pfet_03v3 ad=0.65p pd=3.3u as=0 ps=0 w=1u l=1u
X514 VSS VSS VSS VSS nfet_03v3 ad=0.2014p pd=1.98u as=0 ps=0 w=0.22u l=0.28u
X515 VSS VSS VSS VSS nfet_03v3 ad=0.61p pd=3.22u as=0 ps=0 w=1u l=8u
X516 VSS VSS VSS VSS nfet_03v3 ad=0.2014p pd=1.98u as=0 ps=0 w=0.22u l=0.28u
X517 VSS VSS VSS VSS nfet_03v3 ad=0.2014p pd=1.98u as=0 ps=0 w=0.22u l=0.28u
X518 a_5364_69692# spike[1] DPI_1.Isum VSS nfet_03v3 ad=0.2014p pd=1.98u as=0.2014p ps=1.98u w=0.22u l=0.28u
X519 VSS VSS VSS VSS nfet_03v3 ad=0.2014p pd=1.98u as=0 ps=0 w=0.22u l=0.28u
X520 VDD VDD VDD VDD pfet_03v3 ad=0.2166p pd=2.06u as=0 ps=0 w=0.22u l=0.28u
X521 bias_cell_0.Vthr bias_cell_0.Vthr VDD VDD pfet_03v3 ad=0.1074p pd=1.08u as=0.1074p ps=1.08u w=0.22u l=0.28u
X522 VSS VSS VSS VSS nfet_03v3 ad=0.2014p pd=1.98u as=0 ps=0 w=0.22u l=0.28u
X523 VSS VSS VSS VSS nfet_03v3 ad=0.61p pd=3.22u as=0 ps=0 w=1u l=1u
X524 VSS VSS VSS VSS nfet_03v3 ad=0.2014p pd=1.98u as=0 ps=0 w=0.22u l=0.28u
X525 VSS VSS VSS VSS nfet_03v3 ad=0.2014p pd=1.98u as=0 ps=0 w=0.22u l=0.28u
X526 VSS VSS VSS VSS nfet_03v3 ad=0.2014p pd=1.98u as=0 ps=0 w=0.22u l=0.28u
X527 VSS VSS VSS VSS nfet_03v3 ad=0.2014p pd=1.98u as=0 ps=0 w=0.22u l=0.28u
X528 VSS bias_cell_0.Vb VSS VSS nfet_03v3 ad=0.61p pd=3.22u as=0 ps=0 w=1u l=8u
X529 VSS VSS VSS VSS nfet_03v3 ad=0.2014p pd=1.98u as=0 ps=0 w=0.22u l=0.28u
X530 VSS VSS VSS VSS nfet_03v3 ad=0.2014p pd=1.98u as=0 ps=0 w=0.22u l=0.28u
X531 VSS bias_cell_0.Vb VSS VSS nfet_03v3 ad=0.61p pd=3.22u as=0 ps=0 w=1u l=8u
X532 VDD a_44260_20480# a_44260_20480# VDD pfet_03v3 ad=0.2166p pd=2.06u as=0.2166p ps=2.06u w=0.22u l=0.28u
X533 VSS VSS VSS VSS nfet_03v3 ad=0.2014p pd=1.98u as=0 ps=0 w=0.22u l=0.28u
X534 VSS VSS VSS VSS nfet_03v3 ad=0.2014p pd=1.98u as=0 ps=0 w=0.22u l=0.28u
X535 VDD VDD VDD VDD pfet_03v3 ad=0.65p pd=3.3u as=0 ps=0 w=1u l=1u
X536 VSS VSS VSS VSS nfet_03v3 ad=0.61p pd=3.22u as=0 ps=0 w=1u l=1u
X537 VSS VSS VSS VSS nfet_03v3 ad=0.2014p pd=1.98u as=0 ps=0 w=0.22u l=0.28u
X538 a_34406_15668# a_34406_15668# DPI_3.Isum DPI_3.Isum nfet_03v3 ad=0.2014p pd=1.98u as=0.2014p ps=1.98u w=0.22u l=0.28u
X539 VSS w[27] a_3364_81516# VSS nfet_03v3 ad=0.2014p pd=1.98u as=0.2014p ps=1.98u w=0.22u l=0.28u
X540 VSS w[15] a_5364_46404# VSS nfet_03v3 ad=0.2014p pd=1.98u as=0.2014p ps=1.98u w=0.22u l=0.28u
X541 VDD bias_cell_0.Vthr bias_cell_0.Vthr VDD pfet_03v3 ad=0.1074p pd=1.08u as=0.1074p ps=1.08u w=0.22u l=0.28u
X542 VSS VSS VSS VSS nfet_03v3 ad=0.61p pd=3.22u as=0 ps=0 w=1u l=8u
X543 VSS VSS VSS VSS nfet_03v3 ad=0.2014p pd=1.98u as=0 ps=0 w=0.22u l=0.28u
X544 VSS VSS VSS VSS nfet_03v3 ad=0.2014p pd=1.98u as=0 ps=0 w=0.22u l=0.28u
X545 VSS VSS VSS VSS nfet_03v3 ad=0.2014p pd=1.98u as=0 ps=0 w=0.22u l=0.28u
X546 VSS w[29] a_3364_92980# VSS nfet_03v3 ad=0.2014p pd=1.98u as=0.2014p ps=1.98u w=0.22u l=0.28u
X547 VDD VDD VDD VDD pfet_03v3 ad=0.65p pd=3.3u as=0 ps=0 w=1u l=1u
X548 VSS VSS VSS VSS nfet_03v3 ad=0.2014p pd=1.98u as=0 ps=0 w=0.22u l=0.28u
X549 VSS VSS VSS VSS nfet_03v3 ad=0.61p pd=3.22u as=0 ps=0 w=1u l=8u
X550 VSS VSS VSS VSS nfet_03v3 ad=0.61p pd=3.22u as=0 ps=0 w=1u l=8u
X551 VSS VSS VSS VSS nfet_03v3 ad=0.61p pd=3.22u as=0 ps=0 w=1u l=8u
X552 neuron_sized_4.VMEM a_34406_3844# VDD VDD pfet_03v3 ad=0.2166p pd=2.06u as=0.2166p ps=2.06u w=0.22u l=0.28u
X553 VSS VSS VSS VSS nfet_03v3 ad=0.61p pd=3.22u as=0 ps=0 w=1u l=1u
X554 VSS VSS VSS VSS nfet_03v3 ad=0.61p pd=3.22u as=0 ps=0 w=1u l=8u
X555 VSS VSS VSS VSS nfet_03v3 ad=0.2014p pd=1.98u as=0 ps=0 w=0.22u l=0.28u
X556 VSS VSS VSS VSS nfet_03v3 ad=0.2014p pd=1.98u as=0 ps=0 w=0.22u l=0.28u
X557 VSS VSS VSS VSS nfet_03v3 ad=0.2014p pd=1.98u as=0 ps=0 w=0.22u l=0.28u
X558 neuron_sized_3.VMEM a_34406_15668# VDD VDD pfet_03v3 ad=0.2166p pd=2.06u as=0.2166p ps=2.06u w=0.22u l=0.28u
X559 VSS bias_cell_0.Vb VSS VSS nfet_03v3 ad=0.61p pd=3.22u as=0 ps=0 w=1u l=8u
X560 neuron_sized_4.VMEM VSS cap_mim_2f0_m4m5_noshield c_width=22.18u c_length=22.18u
X561 bias_cell_0.Vlk bias_cell_0.Vlk VSS VSS nfet_03v3 ad=0.35p pd=1.7u as=0.35p ps=1.7u w=1u l=1u
X562 bias_cell_0.VT_dpi bias_cell_0.VT_dpi VDD VDD pfet_03v3 ad=0.1074p pd=1.08u as=0.1074p ps=1.08u w=0.22u l=0.28u
X563 VSS VSS VSS VSS nfet_03v3 ad=1.22p pd=5.22u as=0 ps=0 w=2u l=8u
X564 VSS VSS VSS VSS nfet_03v3 ad=0.2014p pd=1.98u as=0 ps=0 w=0.22u l=0.28u
X565 VSS VSS VSS VSS nfet_03v3 ad=0.2014p pd=1.98u as=0 ps=0 w=0.22u l=0.28u
X566 VSS VSS VSS VSS nfet_03v3 ad=0.2014p pd=1.98u as=0 ps=0 w=0.22u l=0.28u
X567 VSS VSS VSS VSS nfet_03v3 ad=0.2014p pd=1.98u as=0 ps=0 w=0.22u l=0.28u
X568 VDD VDD VDD VDD pfet_03v3 ad=0.65p pd=3.3u as=0 ps=0 w=1u l=1u
X569 VSS VSS VSS VSS nfet_03v3 ad=0.2014p pd=1.98u as=0 ps=0 w=0.22u l=0.28u
X570 a_46472_78818# a_50306_78896# spike[4] VDD pfet_03v3 ad=0.2166p pd=2.06u as=0.2166p ps=2.06u w=0.22u l=0.28u
X571 VSS VSS VSS VSS nfet_03v3 ad=0.61p pd=3.22u as=0 ps=0 w=1u l=8u
X572 VSS VSS VSS VSS nfet_03v3 ad=0.2014p pd=1.98u as=0 ps=0 w=0.22u l=0.28u
X573 VSS VSS VSS VSS nfet_03v3 ad=0.2014p pd=1.98u as=0 ps=0 w=0.22u l=0.28u
X574 VSS VSS VSS VSS nfet_03v3 ad=0.2014p pd=1.98u as=0 ps=0 w=0.22u l=0.28u
X575 VSS VSS VSS VSS nfet_03v3 ad=0.2014p pd=1.98u as=0 ps=0 w=0.22u l=0.28u
X576 VSS VSS VSS VSS nfet_03v3 ad=0.61p pd=3.22u as=0 ps=0 w=1u l=1u
X577 a_50306_8672# a_45030_8672# a_48106_4254# VSS nfet_03v3 ad=0.2014p pd=1.98u as=0.2014p ps=1.98u w=0.22u l=0.28u
X578 VSS w[7] a_5364_23116# VSS nfet_03v3 ad=0.2014p pd=1.98u as=0.2014p ps=1.98u w=0.22u l=0.28u
X579 VSS VSS VSS VSS nfet_03v3 ad=0.2014p pd=1.98u as=0 ps=0 w=0.22u l=0.28u
X580 VSS VSS VSS VSS nfet_03v3 ad=0.2014p pd=1.98u as=0 ps=0 w=0.22u l=0.28u
X581 a_45268_74556# bias_cell_0.Vamp_bias VSS VSS nfet_03v3 ad=0.2014p pd=1.98u as=0.2014p ps=1.98u w=0.22u l=0.28u
X582 VSS w[26] a_3364_81516# VSS nfet_03v3 ad=0.2014p pd=1.98u as=0.2014p ps=1.98u w=0.22u l=0.28u
X583 VSS VSS VSS VSS nfet_03v3 ad=0.2014p pd=1.98u as=0 ps=0 w=0.22u l=0.28u
X584 VSS w[14] a_5364_46404# VSS nfet_03v3 ad=0.2014p pd=1.98u as=0.2014p ps=1.98u w=0.22u l=0.28u
X585 VSS VSS VSS VSS nfet_03v3 ad=0.2014p pd=1.98u as=0 ps=0 w=0.22u l=0.28u
X586 VSS VSS VSS VSS nfet_03v3 ad=0.2014p pd=1.98u as=0 ps=0 w=0.22u l=0.28u
X587 VSS VSS VSS VSS nfet_03v3 ad=0.2014p pd=1.98u as=0 ps=0 w=0.22u l=0.28u
X588 VSS VSS VSS VSS nfet_03v3 ad=0.2014p pd=1.98u as=0 ps=0 w=0.22u l=0.28u
X589 VSS VSS VSS VSS nfet_03v3 ad=0.2014p pd=1.98u as=0 ps=0 w=0.22u l=0.28u
X590 VSS bias_cell_0.Vlk bias_cell_0.Vlk VSS nfet_03v3 ad=0.35p pd=1.7u as=0.35p ps=1.7u w=1u l=1u
X591 VSS VSS VSS VSS nfet_03v3 ad=0.2014p pd=1.98u as=0 ps=0 w=0.22u l=0.28u
X592 VSS bias_cell_0.Vb VSS VSS nfet_03v3 ad=0.61p pd=3.22u as=0 ps=0 w=1u l=8u
X593 VSS VSS VSS VSS nfet_03v3 ad=0.2014p pd=1.98u as=0 ps=0 w=0.22u l=0.28u
X594 VDD bias_cell_0.Vthr bias_cell_0.Vthr VDD pfet_03v3 ad=0.1074p pd=1.08u as=0.1074p ps=1.08u w=0.22u l=0.28u
X595 VSS VSS VSS VSS nfet_03v3 ad=0.2014p pd=1.98u as=0 ps=0 w=0.22u l=0.28u
X596 VSS VSS VSS VSS nfet_03v3 ad=0.2014p pd=1.98u as=0 ps=0 w=0.22u l=0.28u
X597 VSS VSS VSS VSS nfet_03v3 ad=0.2014p pd=1.98u as=0 ps=0 w=0.22u l=0.28u
X598 VSS bias_cell_0.Vb VSS VSS nfet_03v3 ad=0.61p pd=3.22u as=0 ps=0 w=1u l=8u
X599 VSS VSS VSS VSS nfet_03v3 ad=0.2014p pd=1.98u as=0 ps=0 w=0.22u l=0.28u
X600 VSS w[23] a_5364_69692# VSS nfet_03v3 ad=0.2014p pd=1.98u as=0.2014p ps=1.98u w=0.22u l=0.28u
X601 VSS VSS VSS VSS nfet_03v3 ad=0.2014p pd=1.98u as=0 ps=0 w=0.22u l=0.28u
X602 VSS VSS VSS VSS nfet_03v3 ad=0.61p pd=3.22u as=0 ps=0 w=1u l=1u
X603 VSS w[31] a_3364_92980# VSS nfet_03v3 ad=0.2014p pd=1.98u as=0.2014p ps=1.98u w=0.22u l=0.28u
X604 VSS w[9] a_5364_34940# VSS nfet_03v3 ad=0.2014p pd=1.98u as=0.2014p ps=1.98u w=0.22u l=0.28u
X605 VSS w[0] a_5364_11292# VSS nfet_03v3 ad=0.2014p pd=1.98u as=0.2014p ps=1.98u w=0.22u l=0.28u
X606 VSS w[7] a_5364_23116# VSS nfet_03v3 ad=0.2014p pd=1.98u as=0.2014p ps=1.98u w=0.22u l=0.28u
X607 VSS VSS VSS VSS nfet_03v3 ad=0.2014p pd=1.98u as=0 ps=0 w=0.22u l=0.28u
X608 VSS VSS VSS VSS nfet_03v3 ad=0.2014p pd=1.98u as=0 ps=0 w=0.22u l=0.28u
X609 VSS w[17] a_5364_58228# VSS nfet_03v3 ad=0.2014p pd=1.98u as=0.2014p ps=1.98u w=0.22u l=0.28u
X610 VSS bias_cell_0.Vb VSS VSS nfet_03v3 ad=0.61p pd=3.22u as=0 ps=0 w=1u l=8u
X611 a_45268_74556# DPI_inh_0.Iout a_44260_78880# VSS nfet_03v3 ad=0.2014p pd=1.98u as=0.2014p ps=1.98u w=0.22u l=0.28u
X612 VSS bias_cell_0.Vb VSS VSS nfet_03v3 ad=0.61p pd=3.22u as=0 ps=0 w=1u l=8u
X613 VDD bias_cell_0.VT_inh bias_cell_0.VT_inh VDD pfet_03v3 ad=0.308p pd=1.58u as=0.308p ps=1.58u w=0.88u l=1.12u
X614 VSS bias_cell_0.Vb VSS VSS nfet_03v3 ad=0.61p pd=3.22u as=0 ps=0 w=1u l=8u
X615 VSS VSS VSS VSS nfet_03v3 ad=0.2014p pd=1.98u as=0 ps=0 w=0.22u l=0.28u
X616 VSS VSS VSS VSS nfet_03v3 ad=0.61p pd=3.22u as=0 ps=0 w=1u l=8u
X617 VDD a_2244_98592# bias_cell_0.VK VDD pfet_03v3 ad=0.7315p pd=2.79u as=0.7315p ps=2.79u w=2.09u l=8u
X618 bias_cell_0.Vthr bias_cell_0.Vthr VDD VDD pfet_03v3 ad=0.1074p pd=1.08u as=0.1074p ps=1.08u w=0.22u l=0.28u
X619 VSS w[29] a_3364_92980# VSS nfet_03v3 ad=0.2014p pd=1.98u as=0.2014p ps=1.98u w=0.22u l=0.28u
X620 VSS VSS VSS VSS nfet_03v3 ad=0.61p pd=3.22u as=0 ps=0 w=1u l=8u
X621 VSS bias_cell_0.Vb VSS VSS nfet_03v3 ad=0.61p pd=3.22u as=0 ps=0 w=1u l=8u
X622 VSS VSS VSS VSS nfet_03v3 ad=0.61p pd=3.22u as=0 ps=0 w=1u l=8u
X623 VSS VSS VSS VSS nfet_03v3 ad=0.61p pd=3.22u as=0 ps=0 w=1u l=8u
X624 VSS VSS VSS VSS nfet_03v3 ad=0.2014p pd=1.98u as=0 ps=0 w=0.22u l=0.28u
X625 bias_cell_0.Vthr Iref VSS VSS nfet_03v3 ad=0.55205p pd=3.03u as=0.55205p ps=3.03u w=0.905u l=32u
X626 VSS VSS VSS VSS nfet_03v3 ad=0.2014p pd=1.98u as=0 ps=0 w=0.22u l=0.28u
X627 VDD VDD VDD VDD pfet_03v3 ad=0.65p pd=3.3u as=0 ps=0 w=1u l=1u
X628 VSS VSS VSS VSS nfet_03v3 ad=0.2014p pd=1.98u as=0 ps=0 w=0.22u l=0.28u
X629 bias_cell_0.VKdn a_2244_98592# VDD VDD pfet_03v3 ad=1.13225p pd=3.935u as=1.13225p ps=3.935u w=3.235u l=8u
X630 VSS bias_cell_0.Vlk bias_cell_0.Vlk VSS nfet_03v3 ad=0.61p pd=3.22u as=0.35p ps=1.7u w=1u l=1u
X631 bias_cell_0.Vthr bias_cell_0.Vthr VDD VDD pfet_03v3 ad=0.1074p pd=1.08u as=0.1074p ps=1.08u w=0.22u l=0.28u
X632 spike[4] VSS cap_mim_2f0_m4m5_noshield c_width=10u c_length=10u
X633 VSS VSS VSS VSS nfet_03v3 ad=0.2014p pd=1.98u as=0 ps=0 w=0.22u l=0.28u
X634 VSS VSS VSS VSS nfet_03v3 ad=0.2014p pd=1.98u as=0 ps=0 w=0.22u l=0.28u
X635 VSS VSS VSS VSS nfet_03v3 ad=0.2014p pd=1.98u as=0 ps=0 w=0.22u l=0.28u
X636 neuron_sized_1.VMEM VSS cap_mim_2f0_m4m5_noshield c_width=22.18u c_length=22.18u
X637 a_46472_20418# bias_cell_0.VKup VDD VDD pfet_03v3 ad=0.65p pd=3.3u as=0.65p ps=3.3u w=1u l=1u
X638 VSS w[23] a_5364_69692# VSS nfet_03v3 ad=0.2014p pd=1.98u as=0.2014p ps=1.98u w=0.22u l=0.28u
X639 VSS VSS VSS VSS nfet_03v3 ad=0.2014p pd=1.98u as=0 ps=0 w=0.22u l=0.28u
X640 VDD VDD VDD VDD pfet_03v3 ad=0.65p pd=3.3u as=0 ps=0 w=1u l=1u
X641 VDD VDD VDD VDD pfet_03v3 ad=0.65p pd=3.3u as=0 ps=0 w=1u l=1u
X642 VSS VSS VSS VSS nfet_03v3 ad=0.61p pd=3.22u as=0 ps=0 w=1u l=1u
X643 VSS VSS VSS VSS nfet_03v3 ad=0.61p pd=3.22u as=0 ps=0 w=1u l=8u
X644 VSS VSS VSS VSS nfet_03v3 ad=0.2014p pd=1.98u as=0 ps=0 w=0.22u l=0.28u
X645 VSS VSS VSS VSS nfet_03v3 ad=0.2014p pd=1.98u as=0 ps=0 w=0.22u l=0.28u
X646 bias_cell_0.VT_dpi bias_cell_0.VT_dpi VDD VDD pfet_03v3 ad=0.1074p pd=1.08u as=0.2166p ps=2.06u w=0.22u l=0.28u
X647 VSS VSS VSS VSS nfet_03v3 ad=0.2014p pd=1.98u as=0 ps=0 w=0.22u l=0.28u
X648 VDD VDD VDD VDD pfet_03v3 ad=0.2166p pd=2.06u as=0 ps=0 w=0.22u l=0.28u
X649 VSS VSS VSS VSS nfet_03v3 ad=0.2014p pd=1.98u as=0 ps=0 w=0.22u l=0.28u
X650 VSS VSS VSS VSS nfet_03v3 ad=0.2014p pd=1.98u as=0 ps=0 w=0.22u l=0.28u
X651 VDD VDD VDD VDD pfet_03v3 ad=0.2166p pd=2.06u as=0 ps=0 w=0.22u l=0.28u
X652 VDD bias_cell_0.Vthr bias_cell_0.Vthr VDD pfet_03v3 ad=0.1074p pd=1.08u as=0.1074p ps=1.08u w=0.22u l=0.28u
X653 a_45268_51268# bias_cell_0.Vamp_bias VSS VSS nfet_03v3 ad=0.2014p pd=1.98u as=0.2014p ps=1.98u w=0.22u l=0.28u
X654 VSS VSS VSS VSS nfet_03v3 ad=0.61p pd=3.22u as=0 ps=0 w=1u l=8u
X655 VSS VSS VSS VSS nfet_03v3 ad=0.61p pd=3.22u as=0 ps=0 w=1u l=8u
X656 VSS w[6] a_5364_23116# VSS nfet_03v3 ad=0.2014p pd=1.98u as=0.2014p ps=1.98u w=0.22u l=0.28u
X657 VSS VSS VSS VSS nfet_03v3 ad=0.2014p pd=1.98u as=0 ps=0 w=0.22u l=0.28u
X658 VSS VSS VSS VSS nfet_03v3 ad=0.2014p pd=1.98u as=0 ps=0 w=0.22u l=0.28u
X659 VDD VDD VDD VDD pfet_03v3 ad=0.2166p pd=2.06u as=0 ps=0 w=0.22u l=0.28u
X660 VSS VSS VSS VSS nfet_03v3 ad=0.2014p pd=1.98u as=0 ps=0 w=0.22u l=0.28u
X661 VSS VSS VSS VSS nfet_03v3 ad=0.2014p pd=1.98u as=0 ps=0 w=0.22u l=0.28u
X662 VSS VSS VSS VSS nfet_03v3 ad=0.2014p pd=1.98u as=0 ps=0 w=0.22u l=0.28u
X663 VSS VSS VSS VSS nfet_03v3 ad=0.2014p pd=1.98u as=0 ps=0 w=0.22u l=0.28u
X664 VSS VSS VSS VSS nfet_03v3 ad=0.2014p pd=1.98u as=0 ps=0 w=0.22u l=0.28u
X665 VSS VSS VSS VSS nfet_03v3 ad=0.2014p pd=1.98u as=0 ps=0 w=0.22u l=0.28u
X666 VSS VSS VSS VSS nfet_03v3 ad=0.2014p pd=1.98u as=0 ps=0 w=0.22u l=0.28u
X667 VSS VSS VSS VSS nfet_03v3 ad=0.61p pd=3.22u as=0 ps=0 w=1u l=1u
X668 VSS VSS VSS VSS nfet_03v3 ad=0.2014p pd=1.98u as=0 ps=0 w=0.22u l=0.28u
X669 VSS w[11] a_5364_34940# VSS nfet_03v3 ad=0.2014p pd=1.98u as=0.2014p ps=1.98u w=0.22u l=0.28u
X670 VSS VSS VSS VSS nfet_03v3 ad=0.2014p pd=1.98u as=0 ps=0 w=0.22u l=0.28u
X671 VSS VSS VSS VSS nfet_03v3 ad=0.2014p pd=1.98u as=0 ps=0 w=0.22u l=0.28u
X672 VDD VDD VDD VDD pfet_03v3 ad=0.65p pd=3.3u as=0 ps=0 w=1u l=1u
X673 VSS w[19] a_5364_58228# VSS nfet_03v3 ad=0.2014p pd=1.98u as=0.2014p ps=1.98u w=0.22u l=0.28u
X674 VSS VSS VSS VSS nfet_03v3 ad=0.61p pd=3.22u as=0 ps=0 w=1u l=8u
X675 VSS VSS VSS VSS nfet_03v3 ad=0.2014p pd=1.98u as=0 ps=0 w=0.22u l=0.28u
X676 VSS VSS VSS VSS nfet_03v3 ad=0.2014p pd=1.98u as=0 ps=0 w=0.22u l=0.28u
X677 VDD VDD VDD VDD pfet_03v3 ad=0.65p pd=3.3u as=0 ps=0 w=1u l=1u
X678 VDD VDD VDD VDD pfet_03v3 ad=0.65p pd=3.3u as=0 ps=0 w=1u l=1u
X679 VSS w[22] a_5364_69692# VSS nfet_03v3 ad=0.2014p pd=1.98u as=0.2014p ps=1.98u w=0.22u l=0.28u
X680 VSS VSS VSS VSS nfet_03v3 ad=0.2014p pd=1.98u as=0 ps=0 w=0.22u l=0.28u
X681 VSS w[9] a_5364_34940# VSS nfet_03v3 ad=0.2014p pd=1.98u as=0.2014p ps=1.98u w=0.22u l=0.28u
X682 VSS VSS VSS VSS nfet_03v3 ad=0.2014p pd=1.98u as=0 ps=0 w=0.22u l=0.28u
X683 VDD bias_cell_0.Vthr bias_cell_0.Vthr VDD pfet_03v3 ad=0.1074p pd=1.08u as=0.1074p ps=1.08u w=0.22u l=0.28u
X684 VDD VDD VDD VDD pfet_03v3 ad=0.65p pd=3.3u as=0 ps=0 w=1u l=1u
X685 VSS w[17] a_5364_58228# VSS nfet_03v3 ad=0.2014p pd=1.98u as=0.2014p ps=1.98u w=0.22u l=0.28u
X686 a_43278_8594# bias_cell_0.VNA VDD VDD pfet_03v3 ad=0.65p pd=3.3u as=0.65p ps=3.3u w=1u l=1u
X687 VSS bias_cell_0.Vb VSS VSS nfet_03v3 ad=0.61p pd=3.22u as=0 ps=0 w=1u l=8u
X688 VSS VSS VSS VSS nfet_03v3 ad=0.61p pd=3.22u as=0 ps=0 w=1u l=8u
X689 VSS bias_cell_0.Vb VSS VSS nfet_03v3 ad=0.61p pd=3.22u as=0 ps=0 w=1u l=8u
X690 VSS bias_cell_0.Vb VSS VSS nfet_03v3 ad=0.61p pd=3.22u as=0 ps=0 w=1u l=8u
X691 a_45268_51268# neuron_sized_1.VMEM a_44260_55592# VSS nfet_03v3 ad=0.2014p pd=1.98u as=0.2014p ps=1.98u w=0.22u l=0.28u
X692 VSS bias_cell_0.Vb VSS VSS nfet_03v3 ad=0.61p pd=3.22u as=0 ps=0 w=1u l=8u
X693 VSS VSS VSS VSS nfet_03v3 ad=0.61p pd=3.22u as=0 ps=0 w=1u l=1u
X694 VSS bias_cell_0.Vb VSS VSS nfet_03v3 ad=0.61p pd=3.22u as=0 ps=0 w=1u l=8u
X695 VSS VSS VSS VSS nfet_03v3 ad=0.2014p pd=1.98u as=0 ps=0 w=0.22u l=0.28u
X696 VSS VSS VSS VSS nfet_03v3 ad=0.2014p pd=1.98u as=0 ps=0 w=0.22u l=0.28u
X697 VSS VSS VSS VSS nfet_03v3 ad=0.61p pd=3.22u as=0 ps=0 w=1u l=8u
X698 VSS VSS VSS VSS nfet_03v3 ad=0.2014p pd=1.98u as=0 ps=0 w=0.22u l=0.28u
X699 VSS VSS VSS VSS nfet_03v3 ad=0.61p pd=3.22u as=0 ps=0 w=1u l=8u
X700 VSS bias_cell_0.Vb VSS VSS nfet_03v3 ad=0.61p pd=3.22u as=0 ps=0 w=1u l=8u
X701 VDD VDD VDD VDD pfet_03v3 ad=0.65p pd=3.3u as=0 ps=0 w=1u l=1u
X702 VSS VSS VSS VSS nfet_03v3 ad=0.61p pd=3.22u as=0 ps=0 w=1u l=8u
X703 VSS VSS VSS VSS nfet_03v3 ad=0.2014p pd=1.98u as=0 ps=0 w=0.22u l=0.28u
X704 VSS VSS VSS VSS nfet_03v3 ad=0.2014p pd=1.98u as=0 ps=0 w=0.22u l=0.28u
X705 VSS VSS VSS VSS nfet_03v3 ad=0.2014p pd=1.98u as=0 ps=0 w=0.22u l=0.28u
X706 VSS VSS VSS VSS nfet_03v3 ad=0.2014p pd=1.98u as=0 ps=0 w=0.22u l=0.28u
X707 VSS VSS VSS VSS nfet_03v3 ad=0.2014p pd=1.98u as=0 ps=0 w=0.22u l=0.28u
X708 bias_cell_0.Vthr bias_cell_0.Vthr VDD VDD pfet_03v3 ad=0.1074p pd=1.08u as=0.1074p ps=1.08u w=0.22u l=0.28u
X709 a_45030_78896# a_44260_78880# VDD VDD pfet_03v3 ad=0.2166p pd=2.06u as=0.2166p ps=2.06u w=0.22u l=0.28u
X710 VSS VSS VSS VSS nfet_03v3 ad=0.2014p pd=1.98u as=0 ps=0 w=0.22u l=0.28u
X711 VSS VSS VSS VSS nfet_03v3 ad=0.61p pd=3.22u as=0 ps=0 w=1u l=8u
X712 VSS VSS VSS VSS nfet_03v3 ad=0.2014p pd=1.98u as=0 ps=0 w=0.22u l=0.28u
X713 a_43986_74478# bias_cell_0.VK VSS VSS nfet_03v3 ad=0.61p pd=3.22u as=0.61p ps=3.22u w=1u l=1u
X714 VSS VSS VSS VSS nfet_03v3 ad=0.61p pd=3.22u as=0 ps=0 w=1u l=8u
X715 VDD VDD VDD VDD pfet_03v3 ad=0.2166p pd=2.06u as=0 ps=0 w=0.22u l=0.28u
X716 bias_cell_0.Vthr bias_cell_0.Vthr VDD VDD pfet_03v3 ad=0.1074p pd=1.08u as=0.1074p ps=1.08u w=0.22u l=0.28u
X717 VSS VSS VSS VSS nfet_03v3 ad=0.2014p pd=1.98u as=0 ps=0 w=0.22u l=0.28u
X718 VDD VDD VDD VDD pfet_03v3 ad=0.2166p pd=2.06u as=0 ps=0 w=0.22u l=0.28u
X719 VSS VSS VSS VSS nfet_03v3 ad=0.2014p pd=1.98u as=0 ps=0 w=0.22u l=0.28u
X720 a_48826_27902# a_50306_32320# spike[2] VSS nfet_03v3 ad=0.2014p pd=1.98u as=0.2014p ps=1.98u w=0.22u l=0.28u
X721 VDD a_2244_98592# a_2244_98592# VDD pfet_03v3 ad=3.25p pd=11.3u as=1.75p ps=5.7u w=5u l=8u
X722 VSS VSS VSS VSS nfet_03v3 ad=0.2014p pd=1.98u as=0 ps=0 w=0.22u l=0.28u
X723 VSS VSS VSS VSS nfet_03v3 ad=0.2014p pd=1.98u as=0 ps=0 w=0.22u l=0.28u
X724 VSS VSS VSS VSS nfet_03v3 ad=0.2014p pd=1.98u as=0 ps=0 w=0.22u l=0.28u
X725 a_45268_16156# bias_cell_0.Vamp_bias VSS VSS nfet_03v3 ad=0.2014p pd=1.98u as=0.2014p ps=1.98u w=0.22u l=0.28u
X726 VSS VSS VSS VSS nfet_03v3 ad=0.2014p pd=1.98u as=0 ps=0 w=0.22u l=0.28u
X727 VSS VSS VSS VSS nfet_03v3 ad=0.2014p pd=1.98u as=0 ps=0 w=0.22u l=0.28u
X728 VDD VDD VDD VDD pfet_03v3 ad=0.2166p pd=2.06u as=0 ps=0 w=0.22u l=0.28u
X729 neuron_sized_1.VMEM a_50306_55608# a_43278_55530# VDD pfet_03v3 ad=0.2166p pd=2.06u as=0.2166p ps=2.06u w=0.22u l=0.28u
X730 a_48826_27902# bias_cell_0.VKdn VSS VSS nfet_03v3 ad=0.61p pd=3.22u as=0.61p ps=3.22u w=1u l=1u
X731 bias_cell_0.VT_inh bias_cell_0.VT_inh VDD VDD pfet_03v3 ad=0.308p pd=1.58u as=0.308p ps=1.58u w=0.88u l=1.12u
X732 VSS VSS VSS VSS nfet_03v3 ad=0.2014p pd=1.98u as=0 ps=0 w=0.22u l=0.28u
X733 VSS bias_cell_0.Vb VSS VSS nfet_03v3 ad=0.61p pd=3.22u as=0 ps=0 w=1u l=8u
X734 VSS bias_cell_0.Vlk bias_cell_0.Vlk VSS nfet_03v3 ad=0.35p pd=1.7u as=0.35p ps=1.7u w=1u l=1u
X735 bias_cell_0.VKdn bias_cell_0.VKdn VSS VSS nfet_03v3 ad=0.35p pd=1.7u as=0.35p ps=1.7u w=1u l=1u
X736 VDD bias_cell_0.VT_dpi bias_cell_0.VT_dpi VDD pfet_03v3 ad=0.1074p pd=1.08u as=0.1074p ps=1.08u w=0.22u l=0.28u
X737 bias_cell_0.VT_inh bias_cell_0.VT_inh VDD VDD pfet_03v3 ad=0.308p pd=1.58u as=0.308p ps=1.58u w=0.88u l=1.12u
X738 VSS VSS VSS VSS nfet_03v3 ad=0.61p pd=3.22u as=0 ps=0 w=1u l=1u
X739 VSS VSS VSS VSS nfet_03v3 ad=0.61p pd=3.22u as=0 ps=0 w=1u l=1u
X740 a_50306_8672# a_45030_8672# VDD VDD pfet_03v3 ad=0.2166p pd=2.06u as=0.2166p ps=2.06u w=0.22u l=0.28u
X741 VDD VDD VDD VDD pfet_03v3 ad=0.65p pd=3.3u as=0 ps=0 w=1u l=1u
X742 VDD bias_cell_0.Vthr bias_cell_0.Vthr VDD pfet_03v3 ad=0.1074p pd=1.08u as=0.1074p ps=1.08u w=0.22u l=0.28u
X743 VDD VDD VDD VDD pfet_03v3 ad=0.2166p pd=2.06u as=0 ps=0 w=0.22u l=0.28u
X744 a_48106_51190# bias_cell_0.VIp VSS VSS nfet_03v3 ad=0.61p pd=3.22u as=0.61p ps=3.22u w=1u l=1u
X745 VDD VDD VDD VDD pfet_03v3 ad=0.65p pd=3.3u as=0 ps=0 w=1u l=1u
X746 VSS VSS VSS VSS nfet_03v3 ad=0.61p pd=3.22u as=0 ps=0 w=1u l=1u
X747 VDD VDD VDD VDD pfet_03v3 ad=0.65p pd=3.3u as=0 ps=0 w=1u l=1u
X748 VSS w[23] a_5364_69692# VSS nfet_03v3 ad=0.2014p pd=1.98u as=0.2014p ps=1.98u w=0.22u l=0.28u
X749 VDD VDD VDD VDD pfet_03v3 ad=0.65p pd=3.3u as=0 ps=0 w=1u l=1u
X750 VSS VSS VSS VSS nfet_03v3 ad=0.2014p pd=1.98u as=0 ps=0 w=0.22u l=0.28u
X751 VDD VDD VDD VDD pfet_03v3 ad=0.65p pd=3.3u as=0 ps=0 w=1u l=1u
X752 a_45268_4332# bias_cell_0.Vamp_bias VSS VSS nfet_03v3 ad=0.2014p pd=1.98u as=0.2014p ps=1.98u w=0.22u l=0.28u
X753 VSS VSS VSS VSS nfet_03v3 ad=0.2014p pd=1.98u as=0 ps=0 w=0.22u l=0.28u
X754 VSS VSS VSS VSS nfet_03v3 ad=0.2014p pd=1.98u as=0 ps=0 w=0.22u l=0.28u
X755 VDD VDD VDD VDD pfet_03v3 ad=0.65p pd=3.3u as=0 ps=0 w=1u l=1u
X756 VSS VSS VSS VSS nfet_03v3 ad=0.61p pd=3.22u as=0 ps=0 w=1u l=8u
X757 a_34406_50780# bias_cell_0.VT_dpi VDD VDD pfet_03v3 ad=0.2166p pd=2.06u as=0.2166p ps=2.06u w=0.22u l=0.28u
X758 DPI_inh_0.Iout VSS cap_mim_2f0_m4m5_noshield c_width=22.18u c_length=22.18u
X759 a_45268_16156# neuron_sized_3.VMEM a_44260_20480# VSS nfet_03v3 ad=0.2014p pd=1.98u as=0.2014p ps=1.98u w=0.22u l=0.28u
X760 bias_cell_0.VT_dpi bias_cell_0.VT_dpi VDD VDD pfet_03v3 ad=0.1074p pd=1.08u as=0.1074p ps=1.08u w=0.22u l=0.28u
X761 VSS VSS VSS VSS nfet_03v3 ad=0.61p pd=3.22u as=0 ps=0 w=1u l=8u
X762 a_34406_74068# bias_cell_0.VT_dpi VDD VDD pfet_03v3 ad=0.2166p pd=2.06u as=0.2166p ps=2.06u w=0.22u l=0.28u
X763 VSS VSS VSS VSS nfet_03v3 ad=0.2014p pd=1.98u as=0 ps=0 w=0.22u l=0.28u
X764 VDD VDD VDD VDD pfet_03v3 ad=0.65p pd=3.3u as=0 ps=0 w=1u l=1u
X765 VSS VSS VSS VSS nfet_03v3 ad=0.2014p pd=1.98u as=0 ps=0 w=0.22u l=0.28u
X766 VSS VSS VSS VSS nfet_03v3 ad=0.61p pd=3.22u as=0 ps=0 w=1u l=8u
X767 VSS bias_cell_0.Vb VSS VSS nfet_03v3 ad=0.61p pd=3.22u as=0 ps=0 w=1u l=8u
X768 VSS VSS VSS VSS nfet_03v3 ad=0.61p pd=3.22u as=0 ps=0 w=1u l=8u
X769 VSS VSS VSS VSS nfet_03v3 ad=0.2014p pd=1.98u as=0 ps=0 w=0.22u l=0.28u
X770 VDD bias_cell_0.Vthr DPI_4.Isum DPI_4.Isum nfet_03v3 ad=0.2014p pd=1.98u as=0.2014p ps=1.98u w=0.22u l=0.28u
X771 bias_cell_0.Vlk bias_cell_0.Vlk VSS VSS nfet_03v3 ad=0.35p pd=1.7u as=0.35p ps=1.7u w=1u l=1u
X772 VDD a_2244_98592# bias_cell_0.Vamp_bias VDD pfet_03v3 ad=2.9705p pd=10.44u as=1.5995p ps=5.27u w=4.57u l=8u
X773 VSS VSS VSS VSS nfet_03v3 ad=0.2014p pd=1.98u as=0 ps=0 w=0.22u l=0.28u
X774 VSS VSS VSS VSS nfet_03v3 ad=0.2014p pd=1.98u as=0 ps=0 w=0.22u l=0.28u
X775 VSS VSS VSS VSS nfet_03v3 ad=0.2014p pd=1.98u as=0 ps=0 w=0.22u l=0.28u
X776 VSS VSS VSS VSS nfet_03v3 ad=0.61p pd=3.22u as=0 ps=0 w=1u l=8u
X777 VSS VSS VSS VSS nfet_03v3 ad=0.2014p pd=1.98u as=0 ps=0 w=0.22u l=0.28u
X778 VSS VSS VSS VSS nfet_03v3 ad=0.61p pd=3.22u as=0 ps=0 w=1u l=8u
X779 VSS VSS VSS VSS nfet_03v3 ad=0.61p pd=3.22u as=0 ps=0 w=1u l=8u
X780 VDD bias_cell_0.VT_dpi bias_cell_0.VT_dpi VDD pfet_03v3 ad=0.1074p pd=1.08u as=0.1074p ps=1.08u w=0.22u l=0.28u
X781 VSS bias_cell_0.Vb VSS VSS nfet_03v3 ad=0.61p pd=3.22u as=0 ps=0 w=1u l=8u
X782 VSS VSS VSS VSS nfet_03v3 ad=0.61p pd=3.22u as=0 ps=0 w=1u l=8u
X783 VSS VSS VSS VSS nfet_03v3 ad=0.2014p pd=1.98u as=0 ps=0 w=0.22u l=0.28u
X784 bias_cell_0.VK a_2244_98592# VDD VDD pfet_03v3 ad=1.3585p pd=5.48u as=0.7315p ps=2.79u w=2.09u l=8u
X785 VSS VSS VSS VSS nfet_03v3 ad=0.61p pd=3.22u as=0 ps=0 w=1u l=8u
X786 VSS VSS VSS VSS nfet_03v3 ad=0.2014p pd=1.98u as=0 ps=0 w=0.22u l=0.28u
X787 VSS VSS VSS VSS nfet_03v3 ad=0.2014p pd=1.98u as=0 ps=0 w=0.22u l=0.28u
X788 VSS VSS VSS VSS nfet_03v3 ad=0.61p pd=3.22u as=0 ps=0 w=1u l=1u
X789 VDD bias_cell_0.Vthr bias_cell_0.Vthr VDD pfet_03v3 ad=0.1074p pd=1.08u as=0.1074p ps=1.08u w=0.22u l=0.28u
X790 VSS VSS VSS VSS nfet_03v3 ad=0.2014p pd=1.98u as=0 ps=0 w=0.22u l=0.28u
X791 VSS VSS VSS VSS nfet_03v3 ad=0.2014p pd=1.98u as=0 ps=0 w=0.22u l=0.28u
X792 VSS VSS VSS VSS nfet_03v3 ad=0.2014p pd=1.98u as=0 ps=0 w=0.22u l=0.28u
X793 VSS VSS VSS VSS nfet_03v3 ad=0.2014p pd=1.98u as=0 ps=0 w=0.22u l=0.28u
X794 VSS bias_cell_0.Vb VSS VSS nfet_03v3 ad=0.61p pd=3.22u as=0 ps=0 w=1u l=8u
X795 VSS VSS VSS VSS nfet_03v3 ad=0.2014p pd=1.98u as=0 ps=0 w=0.22u l=0.28u
X796 VSS bias_cell_0.Vb VSS VSS nfet_03v3 ad=0.61p pd=3.22u as=0 ps=0 w=1u l=8u
X797 VSS VSS VSS VSS nfet_03v3 ad=0.2014p pd=1.98u as=0 ps=0 w=0.22u l=0.28u
X798 a_46472_32242# a_50306_32320# spike[2] VDD pfet_03v3 ad=0.2166p pd=2.06u as=0.2166p ps=2.06u w=0.22u l=0.28u
X799 neuron_sized_4.VMEM bias_cell_0.Vlk VSS VSS nfet_03v3 ad=0.61p pd=3.22u as=0.61p ps=3.22u w=1u l=1u
X800 VSS VSS VSS VSS nfet_03v3 ad=0.2014p pd=1.98u as=0 ps=0 w=0.22u l=0.28u
X801 VSS VSS VSS VSS nfet_03v3 ad=0.2014p pd=1.98u as=0 ps=0 w=0.22u l=0.28u
X802 VDD a_44260_55592# a_44260_55592# VDD pfet_03v3 ad=0.2166p pd=2.06u as=0.2166p ps=2.06u w=0.22u l=0.28u
X803 VSS VSS VSS VSS nfet_03v3 ad=0.2014p pd=1.98u as=0 ps=0 w=0.22u l=0.28u
X804 neuron_sized_3.VMEM VSS cap_mim_2f0_m4m5_noshield c_width=22.18u c_length=22.18u
X805 VSS w[3] a_5364_11292# VSS nfet_03v3 ad=0.2014p pd=1.98u as=0.2014p ps=1.98u w=0.22u l=0.28u
X806 neuron_sized_4.VMEM spike[0] a_43986_4254# VSS nfet_03v3 ad=0.2014p pd=1.98u as=0.2014p ps=1.98u w=0.22u l=5u
X807 bias_cell_0.VT_dpi bias_cell_0.VT_dpi VDD VDD pfet_03v3 ad=0.1074p pd=1.08u as=0.1074p ps=1.08u w=0.22u l=0.28u
X808 VSS VSS VSS VSS nfet_03v3 ad=0.2014p pd=1.98u as=0 ps=0 w=0.22u l=0.28u
X809 bias_cell_0.Vthr bias_cell_0.Vthr VDD VDD pfet_03v3 ad=0.1074p pd=1.08u as=0.1074p ps=1.08u w=0.22u l=0.28u
X810 VSS VSS VSS VSS nfet_03v3 ad=0.2014p pd=1.98u as=0 ps=0 w=0.22u l=0.28u
X811 VSS VSS VSS VSS nfet_03v3 ad=0.2014p pd=1.98u as=0 ps=0 w=0.22u l=0.28u
X812 VSS VSS VSS VSS nfet_03v3 ad=0.2014p pd=1.98u as=0 ps=0 w=0.22u l=0.28u
X813 a_34406_15668# bias_cell_0.VT_dpi VDD VDD pfet_03v3 ad=0.2166p pd=2.06u as=0.2166p ps=2.06u w=0.22u l=0.28u
X814 VSS Iref a_2244_98592# VSS nfet_03v3 ad=3.05p pd=11.22u as=1.75p ps=5.7u w=5u l=8u
X815 VSS w[28] a_3364_92980# VSS nfet_03v3 ad=0.2014p pd=1.98u as=0.2014p ps=1.98u w=0.22u l=0.28u
X816 VSS VSS VSS VSS nfet_03v3 ad=0.2014p pd=1.98u as=0 ps=0 w=0.22u l=0.28u
X817 VSS VSS VSS VSS nfet_03v3 ad=0.2014p pd=1.98u as=0 ps=0 w=0.22u l=0.28u
X818 bias_cell_0.VT_inh bias_cell_0.VT_inh VDD VDD pfet_03v3 ad=0.308p pd=1.58u as=0.308p ps=1.58u w=0.88u l=1.12u
X819 VSS VSS VSS VSS nfet_03v3 ad=0.2014p pd=1.98u as=0 ps=0 w=0.22u l=0.28u
X820 VSS bias_cell_0.Vb VSS VSS nfet_03v3 ad=0.61p pd=3.22u as=0 ps=0 w=1u l=8u
X821 VSS VSS VSS VSS nfet_03v3 ad=0.2014p pd=1.98u as=0 ps=0 w=0.22u l=0.28u
X822 VSS VSS VSS VSS nfet_03v3 ad=0.61p pd=3.22u as=0 ps=0 w=1u l=8u
X823 bias_cell_0.VNA Iref VSS VSS nfet_03v3 ad=3.51055p pd=12.73u as=3.51055p ps=12.73u w=5.755u l=8u
X824 VDD bias_cell_0.VT_dpi bias_cell_0.VT_dpi VDD pfet_03v3 ad=0.1074p pd=1.08u as=0.1074p ps=1.08u w=0.22u l=0.28u
X825 VSS VSS VSS VSS nfet_03v3 ad=0.2014p pd=1.98u as=0 ps=0 w=0.22u l=0.28u
X826 VDD bias_cell_0.Vthr DPI_0.Isum DPI_0.Isum nfet_03v3 ad=0.2014p pd=1.98u as=0.2014p ps=1.98u w=0.22u l=0.28u
X827 VSS VSS VSS VSS nfet_03v3 ad=0.2014p pd=1.98u as=0 ps=0 w=0.22u l=0.28u
X828 VSS VSS VSS VSS nfet_03v3 ad=0.2014p pd=1.98u as=0 ps=0 w=0.22u l=0.28u
X829 VSS VSS VSS VSS nfet_03v3 ad=0.61p pd=3.22u as=0 ps=0 w=1u l=8u
X830 VSS VSS VSS VSS nfet_03v3 ad=0.2014p pd=1.98u as=0 ps=0 w=0.22u l=0.28u
X831 VSS VSS VSS VSS nfet_03v3 ad=0.2014p pd=1.98u as=0 ps=0 w=0.22u l=0.28u
X832 VSS bias_cell_0.Vb VSS VSS nfet_03v3 ad=0.61p pd=3.22u as=0 ps=0 w=1u l=8u
X833 VSS VSS VSS VSS nfet_03v3 ad=0.61p pd=3.22u as=0 ps=0 w=1u l=8u
X834 VSS VSS VSS VSS nfet_03v3 ad=0.2014p pd=1.98u as=0 ps=0 w=0.22u l=0.28u
X835 VSS VSS VSS VSS nfet_03v3 ad=0.2014p pd=1.98u as=0 ps=0 w=0.22u l=0.28u
X836 VSS bias_cell_0.Vb VSS VSS nfet_03v3 ad=0.61p pd=3.22u as=0 ps=0 w=1u l=8u
X837 VSS w[27] a_3364_81516# VSS nfet_03v3 ad=0.2014p pd=1.98u as=0.2014p ps=1.98u w=0.22u l=0.28u
X838 VSS VSS VSS VSS nfet_03v3 ad=0.2014p pd=1.98u as=0 ps=0 w=0.22u l=0.28u
X839 VSS bias_cell_0.Vb VSS VSS nfet_03v3 ad=0.61p pd=3.22u as=0 ps=0 w=1u l=8u
X840 VSS w[15] a_5364_46404# VSS nfet_03v3 ad=0.2014p pd=1.98u as=0.2014p ps=1.98u w=0.22u l=0.28u
X841 VSS bias_cell_0.Vb VSS VSS nfet_03v3 ad=0.61p pd=3.22u as=0 ps=0 w=1u l=8u
X842 VSS VSS VSS VSS nfet_03v3 ad=0.61p pd=3.22u as=0 ps=0 w=1u l=1u
X843 VSS VSS VSS VSS nfet_03v3 ad=0.61p pd=3.22u as=0 ps=0 w=1u l=1u
X844 a_43986_16078# bias_cell_0.VK VSS VSS nfet_03v3 ad=0.61p pd=3.22u as=0.61p ps=3.22u w=1u l=1u
X845 VSS VSS VSS VSS nfet_03v3 ad=0.61p pd=3.22u as=0 ps=0 w=1u l=1u
X846 bias_cell_0.VT_dpi bias_cell_0.VT_dpi VDD VDD pfet_03v3 ad=0.1074p pd=1.08u as=0.1074p ps=1.08u w=0.22u l=0.28u
X847 VSS VSS VSS VSS nfet_03v3 ad=0.2014p pd=1.98u as=0 ps=0 w=0.22u l=0.28u
X848 VSS VSS VSS VSS nfet_03v3 ad=0.61p pd=3.22u as=0 ps=0 w=1u l=8u
X849 VSS VSS VSS VSS nfet_03v3 ad=0.2014p pd=1.98u as=0 ps=0 w=0.22u l=0.28u
X850 VSS VSS VSS VSS nfet_03v3 ad=0.2014p pd=1.98u as=0 ps=0 w=0.22u l=0.28u
X851 VSS VSS VSS VSS nfet_03v3 ad=0.2014p pd=1.98u as=0 ps=0 w=0.22u l=0.28u
X852 VSS VSS VSS VSS nfet_03v3 ad=0.2014p pd=1.98u as=0 ps=0 w=0.22u l=0.28u
X853 VDD VDD VDD VDD pfet_03v3 ad=0.65p pd=3.3u as=0 ps=0 w=1u l=1u
X854 VSS bias_cell_0.Vb VSS VSS nfet_03v3 ad=0.61p pd=3.22u as=0 ps=0 w=1u l=8u
X855 VSS VSS VSS VSS nfet_03v3 ad=0.2014p pd=1.98u as=0 ps=0 w=0.22u l=0.28u
X856 VSS VSS VSS VSS nfet_03v3 ad=0.2014p pd=1.98u as=0 ps=0 w=0.22u l=0.28u
X857 VSS VSS VSS VSS nfet_03v3 ad=0.61p pd=3.22u as=0 ps=0 w=1u l=1u
X858 VSS VSS VSS VSS nfet_03v3 ad=0.61p pd=3.22u as=0 ps=0 w=1u l=8u
X859 spike[3] VSS cap_mim_2f0_m4m5_noshield c_width=10u c_length=10u
X860 VSS bias_cell_0.Vb VSS VSS nfet_03v3 ad=0.61p pd=3.22u as=0 ps=0 w=1u l=8u
X861 VSS bias_cell_0.Vb VSS VSS nfet_03v3 ad=0.61p pd=3.22u as=0 ps=0 w=1u l=8u
X862 VSS VSS VSS VSS nfet_03v3 ad=0.61p pd=3.22u as=0 ps=0 w=1u l=1u
X863 VSS VSS VSS VSS nfet_03v3 ad=0.2014p pd=1.98u as=0 ps=0 w=0.22u l=0.28u
X864 VSS VSS VSS VSS nfet_03v3 ad=0.2014p pd=1.98u as=0 ps=0 w=0.22u l=0.28u
X865 VSS VSS VSS VSS nfet_03v3 ad=0.2014p pd=1.98u as=0 ps=0 w=0.22u l=0.28u
X866 VSS VSS VSS VSS nfet_03v3 ad=0.2014p pd=1.98u as=0 ps=0 w=0.22u l=0.28u
X867 VDD VDD VDD VDD pfet_03v3 ad=0.2166p pd=2.06u as=0 ps=0 w=0.22u l=0.28u
X868 VSS w[26] a_3364_81516# VSS nfet_03v3 ad=0.2014p pd=1.98u as=0.2014p ps=1.98u w=0.22u l=0.28u
X869 VSS w[14] a_5364_46404# VSS nfet_03v3 ad=0.2014p pd=1.98u as=0.2014p ps=1.98u w=0.22u l=0.28u
X870 VSS w[8] a_5364_34940# VSS nfet_03v3 ad=0.2014p pd=1.98u as=0.2014p ps=1.98u w=0.22u l=0.28u
X871 VSS w[21] a_5364_69692# VSS nfet_03v3 ad=0.2014p pd=1.98u as=0.2014p ps=1.98u w=0.22u l=0.28u
X872 VSS w[16] a_5364_58228# VSS nfet_03v3 ad=0.2014p pd=1.98u as=0.2014p ps=1.98u w=0.22u l=0.28u
X873 a_43278_55530# bias_cell_0.VNA VDD VDD pfet_03v3 ad=0.65p pd=3.3u as=0.65p ps=3.3u w=1u l=1u
X874 VSS VSS VSS VSS nfet_03v3 ad=0.2014p pd=1.98u as=0 ps=0 w=0.22u l=0.28u
X875 DPI_inh_0.Iout bias_cell_0.Vlk VSS VSS nfet_03v3 ad=0.61p pd=3.22u as=0.61p ps=3.22u w=1u l=1u
X876 VSS bias_cell_0.Vb VSS VSS nfet_03v3 ad=0.61p pd=3.22u as=0 ps=0 w=1u l=8u
X877 VSS bias_cell_0.Vb VSS VSS nfet_03v3 ad=0.61p pd=3.22u as=0 ps=0 w=1u l=8u
X878 VSS VSS VSS VSS nfet_03v3 ad=0.2014p pd=1.98u as=0 ps=0 w=0.22u l=0.28u
X879 VSS VSS VSS VSS nfet_03v3 ad=0.2014p pd=1.98u as=0 ps=0 w=0.22u l=0.28u
X880 VDD VDD VDD VDD pfet_03v3 ad=0.65p pd=3.3u as=0 ps=0 w=1u l=1u
X881 VDD bias_cell_0.Vthr bias_cell_0.Vthr VDD pfet_03v3 ad=0.1074p pd=1.08u as=0.1074p ps=1.08u w=0.22u l=0.28u
X882 VSS VSS VSS VSS nfet_03v3 ad=0.2014p pd=1.98u as=0 ps=0 w=0.22u l=0.28u
X883 VDD bias_cell_0.Vthr DPI_1.Isum DPI_1.Isum nfet_03v3 ad=0.2014p pd=1.98u as=0.2014p ps=1.98u w=0.22u l=0.28u
X884 VSS VSS VSS VSS nfet_03v3 ad=0.2014p pd=1.98u as=0 ps=0 w=0.22u l=0.28u
X885 VSS bias_cell_0.Vb VSS VSS nfet_03v3 ad=0.61p pd=3.22u as=0 ps=0 w=1u l=8u
X886 VSS VSS VSS VSS nfet_03v3 ad=0.2014p pd=1.98u as=0 ps=0 w=0.22u l=0.28u
X887 VSS VSS VSS VSS nfet_03v3 ad=0.2014p pd=1.98u as=0 ps=0 w=0.22u l=0.28u
X888 VSS VSS VSS VSS nfet_03v3 ad=0.2014p pd=1.98u as=0 ps=0 w=0.22u l=0.28u
X889 VSS VSS VSS VSS nfet_03v3 ad=0.61p pd=3.22u as=0 ps=0 w=1u l=8u
X890 VSS VSS VSS VSS nfet_03v3 ad=0.61p pd=3.22u as=0 ps=0 w=1u l=8u
X891 VSS VSS VSS VSS nfet_03v3 ad=0.61p pd=3.22u as=0 ps=0 w=1u l=8u
X892 VSS VSS VSS VSS nfet_03v3 ad=0.61p pd=3.22u as=0 ps=0 w=1u l=8u
X893 VSS VSS VSS VSS nfet_03v3 ad=0.2014p pd=1.98u as=0 ps=0 w=0.22u l=0.28u
X894 VSS VSS VSS VSS nfet_03v3 ad=0.61p pd=3.22u as=0 ps=0 w=1u l=8u
X895 VSS VSS VSS VSS nfet_03v3 ad=0.2014p pd=1.98u as=0 ps=0 w=0.22u l=0.28u
X896 VSS VSS VSS VSS nfet_03v3 ad=0.2014p pd=1.98u as=0 ps=0 w=0.22u l=0.28u
X897 VSS VSS VSS VSS nfet_03v3 ad=0.2014p pd=1.98u as=0 ps=0 w=0.22u l=0.28u
X898 VSS bias_cell_0.Vb VSS VSS nfet_03v3 ad=0.61p pd=3.22u as=0 ps=0 w=1u l=8u
X899 VSS DPI_inh_0.DPI_sized_0.Isyn DPI_inh_0.Iout VSS nfet_03v3 ad=1.22p pd=5.22u as=1.22p ps=5.22u w=2u l=8u
X900 VSS VSS VSS VSS nfet_03v3 ad=0.2014p pd=1.98u as=0 ps=0 w=0.22u l=0.28u
X901 VDD VDD VDD VDD pfet_03v3 ad=0.2166p pd=2.06u as=0 ps=0 w=0.22u l=0.28u
X902 VSS bias_cell_0.Vb VSS VSS nfet_03v3 ad=0.61p pd=3.22u as=0 ps=0 w=1u l=8u
X903 VSS VSS VSS VSS nfet_03v3 ad=0.2014p pd=1.98u as=0 ps=0 w=0.22u l=0.28u
X904 VSS bias_cell_0.Vb VSS VSS nfet_03v3 ad=0.61p pd=3.22u as=0 ps=0 w=1u l=8u
X905 VSS bias_cell_0.Vb VSS VSS nfet_03v3 ad=0.61p pd=3.22u as=0 ps=0 w=1u l=8u
X906 VSS w[3] a_5364_11292# VSS nfet_03v3 ad=0.2014p pd=1.98u as=0.2014p ps=1.98u w=0.22u l=0.28u
X907 bias_cell_0.Vthr bias_cell_0.Vthr VDD VDD pfet_03v3 ad=0.1074p pd=1.08u as=0.1074p ps=1.08u w=0.22u l=0.28u
X908 VSS VSS VSS VSS nfet_03v3 ad=0.2014p pd=1.98u as=0 ps=0 w=0.22u l=0.28u
X909 VSS VSS VSS VSS nfet_03v3 ad=0.61p pd=3.22u as=0 ps=0 w=1u l=1u
X910 VSS VSS VSS VSS nfet_03v3 ad=0.2014p pd=1.98u as=0 ps=0 w=0.22u l=0.28u
X911 VSS VSS VSS VSS nfet_03v3 ad=0.61p pd=3.22u as=0 ps=0 w=1u l=1u
X912 VSS VSS VSS VSS nfet_03v3 ad=0.61p pd=3.22u as=0 ps=0 w=1u l=1u
X913 VSS VSS VSS VSS nfet_03v3 ad=0.2014p pd=1.98u as=0 ps=0 w=0.22u l=0.28u
X914 VSS w[7] a_5364_23116# VSS nfet_03v3 ad=0.2014p pd=1.98u as=0.2014p ps=1.98u w=0.22u l=0.28u
X915 VSS VSS VSS VSS nfet_03v3 ad=0.2014p pd=1.98u as=0 ps=0 w=0.22u l=0.28u
X916 VSS VSS VSS VSS nfet_03v3 ad=0.61p pd=3.22u as=0 ps=0 w=1u l=8u
X917 VSS VSS VSS VSS nfet_03v3 ad=0.61p pd=3.22u as=0 ps=0 w=1u l=1u
X918 VSS VSS VSS VSS nfet_03v3 ad=0.2014p pd=1.98u as=0 ps=0 w=0.22u l=0.28u
X919 VSS VSS VSS VSS nfet_03v3 ad=0.2014p pd=1.98u as=0 ps=0 w=0.22u l=0.28u
X920 VSS VSS VSS VSS nfet_03v3 ad=0.2014p pd=1.98u as=0 ps=0 w=0.22u l=0.28u
X921 VSS VSS VSS VSS nfet_03v3 ad=0.2014p pd=1.98u as=0 ps=0 w=0.22u l=0.28u
X922 VSS s[0] a_23094_79840# VSS nfet_03v3 ad=0.2014p pd=1.98u as=0.2014p ps=1.98u w=0.22u l=0.28u
X923 a_45030_32320# a_44260_32304# VDD VDD pfet_03v3 ad=0.2166p pd=2.06u as=0.2166p ps=2.06u w=0.22u l=0.28u
X924 VSS bias_cell_0.Vb VSS VSS nfet_03v3 ad=0.61p pd=3.22u as=0 ps=0 w=1u l=8u
X925 VSS VSS VSS VSS nfet_03v3 ad=0.2014p pd=1.98u as=0 ps=0 w=0.22u l=0.28u
X926 VSS VSS VSS VSS nfet_03v3 ad=0.2014p pd=1.98u as=0 ps=0 w=0.22u l=0.28u
X927 VSS VSS VSS VSS nfet_03v3 ad=0.2014p pd=1.98u as=0 ps=0 w=0.22u l=0.28u
X928 VSS VSS VSS VSS nfet_03v3 ad=0.2014p pd=1.98u as=0 ps=0 w=0.22u l=0.28u
X929 VSS VSS VSS VSS nfet_03v3 ad=0.2014p pd=1.98u as=0 ps=0 w=0.22u l=0.28u
X930 VSS w[23] a_5364_69692# VSS nfet_03v3 ad=0.2014p pd=1.98u as=0.2014p ps=1.98u w=0.22u l=0.28u
X931 VSS VSS VSS VSS nfet_03v3 ad=0.2014p pd=1.98u as=0 ps=0 w=0.22u l=0.28u
X932 VSS bias_cell_0.Vb VSS VSS nfet_03v3 ad=0.61p pd=3.22u as=0 ps=0 w=1u l=8u
X933 VSS DPI_inh_0.DPI_sized_0.Isyn DPI_inh_0.DPI_sized_0.Isyn VSS nfet_03v3 ad=1.22p pd=5.22u as=1.22p ps=5.22u w=2u l=8u
X934 a_34406_3844# VDD cap_mim_2f0_m4m5_noshield c_width=22.36u c_length=22.36u
X935 VSS w[6] a_5364_23116# VSS nfet_03v3 ad=0.2014p pd=1.98u as=0.2014p ps=1.98u w=0.22u l=0.28u
X936 VSS VSS VSS VSS nfet_03v3 ad=0.2014p pd=1.98u as=0 ps=0 w=0.22u l=0.28u
X937 VSS w[3] a_5364_11292# VSS nfet_03v3 ad=0.2014p pd=1.98u as=0.2014p ps=1.98u w=0.22u l=0.28u
X938 VSS VSS VSS VSS nfet_03v3 ad=0.2014p pd=1.98u as=0 ps=0 w=0.22u l=0.28u
X939 VSS w[21] a_5364_69692# VSS nfet_03v3 ad=0.2014p pd=1.98u as=0.2014p ps=1.98u w=0.22u l=0.28u
X940 VDD bias_cell_0.VT_inh bias_cell_0.VT_inh VDD pfet_03v3 ad=0.308p pd=1.58u as=0.308p ps=1.58u w=0.88u l=1.12u
X941 VSS VSS VSS VSS nfet_03v3 ad=0.2014p pd=1.98u as=0 ps=0 w=0.22u l=0.28u
X942 VSS bias_cell_0.Vb VSS VSS nfet_03v3 ad=0.61p pd=3.22u as=0 ps=0 w=1u l=8u
X943 a_43278_32242# bias_cell_0.VNA VDD VDD pfet_03v3 ad=0.65p pd=3.3u as=0.65p ps=3.3u w=1u l=1u
X944 VDD VDD VDD VDD pfet_03v3 ad=0.2166p pd=2.06u as=0 ps=0 w=0.22u l=0.28u
X945 VDD VDD VDD VDD pfet_03v3 ad=0.2166p pd=2.06u as=0 ps=0 w=0.22u l=0.28u
X946 VSS bias_cell_0.Vb VSS VSS nfet_03v3 ad=0.61p pd=3.22u as=0 ps=0 w=1u l=8u
X947 VSS VSS VSS VSS nfet_03v3 ad=0.2014p pd=1.98u as=0 ps=0 w=0.22u l=0.28u
X948 VSS VSS VSS VSS nfet_03v3 ad=0.61p pd=3.22u as=0 ps=0 w=1u l=8u
X949 VDD VDD VDD VDD pfet_03v3 ad=0.65p pd=3.3u as=0 ps=0 w=1u l=1u
X950 VDD bias_cell_0.Vthr DPI_3.Isum DPI_3.Isum nfet_03v3 ad=0.2014p pd=1.98u as=0.2014p ps=1.98u w=0.22u l=0.28u
X951 VSS VSS VSS VSS nfet_03v3 ad=0.2014p pd=1.98u as=0 ps=0 w=0.22u l=0.28u
X952 VDD VDD VDD VDD pfet_03v3 ad=0.2166p pd=2.06u as=0 ps=0 w=0.22u l=0.28u
X953 VSS VSS VSS VSS nfet_03v3 ad=0.2014p pd=1.98u as=0 ps=0 w=0.22u l=0.28u
X954 VSS VSS VSS VSS nfet_03v3 ad=0.2014p pd=1.98u as=0 ps=0 w=0.22u l=0.28u
X955 VSS VSS VSS VSS nfet_03v3 ad=0.61p pd=3.22u as=0 ps=0 w=1u l=8u
X956 VSS VSS VSS VSS nfet_03v3 ad=0.61p pd=3.22u as=0 ps=0 w=1u l=8u
X957 VSS VSS VSS VSS nfet_03v3 ad=0.61p pd=3.22u as=0 ps=0 w=1u l=8u
X958 VSS VSS VSS VSS nfet_03v3 ad=0.61p pd=3.22u as=0 ps=0 w=1u l=8u
X959 VSS VSS VSS VSS nfet_03v3 ad=0.61p pd=3.22u as=0 ps=0 w=1u l=1u
X960 VSS VSS VSS VSS nfet_03v3 ad=0.61p pd=3.22u as=0 ps=0 w=1u l=1u
X961 VSS VSS VSS VSS nfet_03v3 ad=0.2014p pd=1.98u as=0 ps=0 w=0.22u l=0.28u
X962 VDD VDD VDD VDD pfet_03v3 ad=0.65p pd=3.3u as=0 ps=0 w=1u l=1u
X963 VSS VSS VSS VSS nfet_03v3 ad=0.2014p pd=1.98u as=0 ps=0 w=0.22u l=0.28u
X964 DPI_inh_0.DPI_sized_0.Isyn a_34584_81836# VDD VDD pfet_03v3 ad=0.572p pd=3.06u as=0.572p ps=3.06u w=0.88u l=1.12u
X965 VSS VSS VSS VSS nfet_03v3 ad=0.61p pd=3.22u as=0 ps=0 w=1u l=1u
X966 VSS VSS VSS VSS nfet_03v3 ad=0.2014p pd=1.98u as=0 ps=0 w=0.22u l=0.28u
X967 VSS VSS VSS VSS nfet_03v3 ad=0.2014p pd=1.98u as=0 ps=0 w=0.22u l=0.28u
X968 VSS VSS VSS VSS nfet_03v3 ad=0.61p pd=3.22u as=0 ps=0 w=1u l=1u
X969 VSS w[26] a_3364_81516# VSS nfet_03v3 ad=0.2014p pd=1.98u as=0.2014p ps=1.98u w=0.22u l=0.28u
X970 VSS w[14] a_5364_46404# VSS nfet_03v3 ad=0.2014p pd=1.98u as=0.2014p ps=1.98u w=0.22u l=0.28u
X971 a_34406_27492# VDD cap_mim_2f0_m4m5_noshield c_width=22.36u c_length=22.36u
X972 VSS VSS VSS VSS nfet_03v3 ad=0.2014p pd=1.98u as=0 ps=0 w=0.22u l=0.28u
X973 VSS VSS VSS VSS nfet_03v3 ad=0.2014p pd=1.98u as=0 ps=0 w=0.22u l=0.28u
X974 VSS VSS VSS VSS nfet_03v3 ad=0.2014p pd=1.98u as=0 ps=0 w=0.22u l=0.28u
X975 VSS VSS VSS VSS nfet_03v3 ad=0.2014p pd=1.98u as=0 ps=0 w=0.22u l=0.28u
X976 a_48826_74478# a_50306_78896# spike[4] VSS nfet_03v3 ad=0.2014p pd=1.98u as=0.2014p ps=1.98u w=0.22u l=0.28u
X977 VSS VSS VSS VSS nfet_03v3 ad=0.2014p pd=1.98u as=0 ps=0 w=0.22u l=0.28u
X978 VSS w[2] a_5364_11292# VSS nfet_03v3 ad=0.2014p pd=1.98u as=0.2014p ps=1.98u w=0.22u l=0.28u
X979 VSS VSS VSS VSS nfet_03v3 ad=0.2014p pd=1.98u as=0 ps=0 w=0.22u l=0.28u
X980 VSS VSS VSS VSS nfet_03v3 ad=0.2014p pd=1.98u as=0 ps=0 w=0.22u l=0.28u
X981 VSS VSS VSS VSS nfet_03v3 ad=0.2014p pd=1.98u as=0 ps=0 w=0.22u l=0.28u
X982 VSS VSS VSS VSS nfet_03v3 ad=0.2014p pd=1.98u as=0 ps=0 w=0.22u l=0.28u
X983 DPI_inh_0.Iout a_50306_78896# a_43278_78818# VDD pfet_03v3 ad=0.2166p pd=2.06u as=0.2166p ps=2.06u w=0.22u l=0.28u
X984 VSS VSS VSS VSS nfet_03v3 ad=0.2014p pd=1.98u as=0 ps=0 w=0.22u l=0.28u
X985 VSS VSS VSS VSS nfet_03v3 ad=0.61p pd=3.22u as=0 ps=0 w=1u l=1u
X986 VSS VSS VSS VSS nfet_03v3 ad=0.2014p pd=1.98u as=0 ps=0 w=0.22u l=0.28u
X987 VSS w[31] a_3364_92980# VSS nfet_03v3 ad=0.2014p pd=1.98u as=0.2014p ps=1.98u w=0.22u l=0.28u
X988 VSS VSS VSS VSS nfet_03v3 ad=0.61p pd=3.22u as=0 ps=0 w=1u l=1u
X989 VSS VSS VSS VSS nfet_03v3 ad=0.2014p pd=1.98u as=0 ps=0 w=0.22u l=0.28u
X990 VSS bias_cell_0.Vb VSS VSS nfet_03v3 ad=0.61p pd=3.22u as=0 ps=0 w=1u l=8u
X991 VSS VSS VSS VSS nfet_03v3 ad=0.61p pd=3.22u as=0 ps=0 w=1u l=8u
X992 VDD bias_cell_0.VT_dpi bias_cell_0.VT_dpi VDD pfet_03v3 ad=0.1074p pd=1.08u as=0.1074p ps=1.08u w=0.22u l=0.28u
X993 VDD VDD VDD VDD pfet_03v3 ad=0.2166p pd=2.06u as=0 ps=0 w=0.22u l=0.28u
X994 VDD VDD VDD VDD pfet_03v3 ad=0.2166p pd=2.06u as=0 ps=0 w=0.22u l=0.28u
X995 a_3364_81516# spike[2] DAC_signed_1.DAC_binary_0.Isum VSS nfet_03v3 ad=0.2014p pd=1.98u as=0.2014p ps=1.98u w=0.22u l=0.28u
X996 VDD VDD VDD VDD pfet_03v3 ad=0.2166p pd=2.06u as=0 ps=0 w=0.22u l=0.28u
X997 a_5364_46404# spike[1] DPI_2.Isum VSS nfet_03v3 ad=0.2014p pd=1.98u as=0.2014p ps=1.98u w=0.22u l=0.28u
X998 bias_cell_0.VNA bias_cell_0.VNA VDD VDD pfet_03v3 ad=0.2166p pd=2.06u as=0.2166p ps=2.06u w=0.22u l=20u
X999 VDD VDD VDD VDD pfet_03v3 ad=0.2166p pd=2.06u as=0 ps=0 w=0.22u l=0.28u
X1000 neuron_sized_3.VMEM bias_cell_0.Vlk VSS VSS nfet_03v3 ad=0.61p pd=3.22u as=0.61p ps=3.22u w=1u l=1u
X1001 VDD VDD VDD VDD pfet_03v3 ad=0.2166p pd=2.06u as=0 ps=0 w=0.22u l=0.28u
X1002 VSS VSS VSS VSS nfet_03v3 ad=0.2014p pd=1.98u as=0 ps=0 w=0.22u l=0.28u
X1003 VSS VSS VSS VSS nfet_03v3 ad=0.61p pd=3.22u as=0 ps=0 w=1u l=8u
X1004 VSS VSS VSS VSS nfet_03v3 ad=0.2014p pd=1.98u as=0 ps=0 w=0.22u l=0.28u
X1005 VSS VSS VSS VSS nfet_03v3 ad=0.61p pd=3.22u as=0 ps=0 w=1u l=8u
X1006 VSS VSS VSS VSS nfet_03v3 ad=0.2014p pd=1.98u as=0 ps=0 w=0.22u l=0.28u
X1007 VSS VSS VSS VSS nfet_03v3 ad=0.2014p pd=1.98u as=0 ps=0 w=0.22u l=0.28u
X1008 VDD VDD VDD VDD pfet_03v3 ad=0.2166p pd=2.06u as=0 ps=0 w=0.22u l=0.28u
X1009 VSS VSS VSS VSS nfet_03v3 ad=0.2014p pd=1.98u as=0 ps=0 w=0.22u l=0.28u
X1010 VSS VSS VSS VSS nfet_03v3 ad=0.61p pd=3.22u as=0 ps=0 w=1u l=8u
X1011 VSS VSS VSS VSS nfet_03v3 ad=0.61p pd=3.22u as=0 ps=0 w=1u l=8u
X1012 VSS VSS VSS VSS nfet_03v3 ad=0.61p pd=3.22u as=0 ps=0 w=1u l=8u
X1013 VSS VSS VSS VSS nfet_03v3 ad=0.61p pd=3.22u as=0 ps=0 w=1u l=8u
X1014 VSS VSS VSS VSS nfet_03v3 ad=0.61p pd=3.22u as=0 ps=0 w=1u l=8u
X1015 VSS VSS VSS VSS nfet_03v3 ad=0.2014p pd=1.98u as=0 ps=0 w=0.22u l=0.28u
X1016 VSS VSS VSS VSS nfet_03v3 ad=0.2014p pd=1.98u as=0 ps=0 w=0.22u l=0.28u
X1017 VSS VSS VSS VSS nfet_03v3 ad=0.61p pd=3.22u as=0 ps=0 w=1u l=8u
X1018 VSS VSS VSS VSS nfet_03v3 ad=0.2014p pd=1.98u as=0 ps=0 w=0.22u l=0.28u
X1019 VSS VSS VSS VSS nfet_03v3 ad=0.2014p pd=1.98u as=0 ps=0 w=0.22u l=0.28u
X1020 VSS VSS VSS VSS nfet_03v3 ad=0.2014p pd=1.98u as=0 ps=0 w=0.22u l=0.28u
X1021 VSS VSS VSS VSS nfet_03v3 ad=0.2014p pd=1.98u as=0 ps=0 w=0.22u l=0.28u
X1022 VSS VSS VSS VSS nfet_03v3 ad=0.2014p pd=1.98u as=0 ps=0 w=0.22u l=0.28u
X1023 VDD a_44260_8656# a_44260_8656# VDD pfet_03v3 ad=0.2166p pd=2.06u as=0.2166p ps=2.06u w=0.22u l=0.28u
X1024 VSS w[6] a_5364_23116# VSS nfet_03v3 ad=0.2014p pd=1.98u as=0.2014p ps=1.98u w=0.22u l=0.28u
X1025 VDD bias_cell_0.VT_inh bias_cell_0.VT_inh VDD pfet_03v3 ad=0.572p pd=3.06u as=0.308p ps=1.58u w=0.88u l=1.12u
X1026 VSS VSS VSS VSS nfet_03v3 ad=0.2014p pd=1.98u as=0 ps=0 w=0.22u l=0.28u
X1027 a_50306_20496# a_45030_20496# VDD VDD pfet_03v3 ad=0.2166p pd=2.06u as=0.2166p ps=2.06u w=0.22u l=0.28u
X1028 VSS Iref Iref VSS nfet_03v3 ad=3.05p pd=11.22u as=1.75p ps=5.7u w=5u l=8u
X1029 bias_cell_0.VT_inh Iref VSS VSS nfet_03v3 ad=0.38125p pd=2.47u as=0.38125p ps=2.47u w=0.625u l=32u
X1030 VSS VSS VSS VSS nfet_03v3 ad=0.2014p pd=1.98u as=0 ps=0 w=0.22u l=0.28u
X1031 VSS VSS VSS VSS nfet_03v3 ad=0.2014p pd=1.98u as=0 ps=0 w=0.22u l=0.28u
X1032 a_48826_51190# a_50306_55608# spike[3] VSS nfet_03v3 ad=0.2014p pd=1.98u as=0.2014p ps=1.98u w=0.22u l=0.28u
X1033 a_48826_4254# a_50306_8672# spike[0] VSS nfet_03v3 ad=0.2014p pd=1.98u as=0.2014p ps=1.98u w=0.22u l=0.28u
X1034 a_48106_27902# bias_cell_0.VIp VSS VSS nfet_03v3 ad=0.61p pd=3.22u as=0.61p ps=3.22u w=1u l=1u
X1035 a_34584_81836# VDD cap_mim_2f0_m4m5_noshield c_width=22.36u c_length=22.36u
X1036 VSS VSS VSS VSS nfet_03v3 ad=0.2014p pd=1.98u as=0 ps=0 w=0.22u l=0.28u
X1037 VSS VSS VSS VSS nfet_03v3 ad=0.2014p pd=1.98u as=0 ps=0 w=0.22u l=0.28u
X1038 VSS VSS VSS VSS nfet_03v3 ad=0.2014p pd=1.98u as=0 ps=0 w=0.22u l=0.28u
X1039 bias_cell_0.VT_inh bias_cell_0.VT_inh VDD VDD pfet_03v3 ad=0.308p pd=1.58u as=0.308p ps=1.58u w=0.88u l=1.12u
X1040 VSS w[11] a_5364_34940# VSS nfet_03v3 ad=0.2014p pd=1.98u as=0.2014p ps=1.98u w=0.22u l=0.28u
X1041 VSS w[19] a_5364_58228# VSS nfet_03v3 ad=0.2014p pd=1.98u as=0.2014p ps=1.98u w=0.22u l=0.28u
X1042 VSS VSS VSS VSS nfet_03v3 ad=0.61p pd=3.22u as=0 ps=0 w=1u l=1u
X1043 VDD bias_cell_0.Vthr bias_cell_0.Vthr VDD pfet_03v3 ad=0.1074p pd=1.08u as=0.1074p ps=1.08u w=0.22u l=0.28u
X1044 VDD a_44260_78880# a_44260_78880# VDD pfet_03v3 ad=0.2166p pd=2.06u as=0.2166p ps=2.06u w=0.22u l=0.28u
X1045 VDD VDD VDD VDD pfet_03v3 ad=0.2166p pd=2.06u as=0 ps=0 w=0.22u l=0.28u
X1046 VSS VSS VSS VSS nfet_03v3 ad=0.2014p pd=1.98u as=0 ps=0 w=0.22u l=0.28u
X1047 VSS VSS VSS VSS nfet_03v3 ad=0.2014p pd=1.98u as=0 ps=0 w=0.22u l=0.28u
X1048 VSS VSS VSS VSS nfet_03v3 ad=0.2014p pd=1.98u as=0 ps=0 w=0.22u l=0.28u
X1049 VSS VSS VSS VSS nfet_03v3 ad=0.2014p pd=1.98u as=0 ps=0 w=0.22u l=0.28u
X1050 VDD VDD VDD VDD pfet_03v3 ad=0.2166p pd=2.06u as=0 ps=0 w=0.22u l=0.28u
X1051 VSS VSS VSS VSS nfet_03v3 ad=0.2014p pd=1.98u as=0 ps=0 w=0.22u l=0.28u
X1052 VDD VDD VDD VDD pfet_03v3 ad=0.2166p pd=2.06u as=0 ps=0 w=0.22u l=0.28u
X1053 VSS VSS VSS VSS nfet_03v3 ad=0.2014p pd=1.98u as=0 ps=0 w=0.22u l=0.28u
X1054 VDD VDD VDD VDD pfet_03v3 ad=0.2166p pd=2.06u as=0 ps=0 w=0.22u l=0.28u
X1055 a_5364_23116# pulse[1] DPI_3.Isum VSS nfet_03v3 ad=0.2014p pd=1.98u as=0.2014p ps=1.98u w=0.22u l=0.28u
X1056 bias_cell_0.VT_dpi bias_cell_0.VT_dpi VDD VDD pfet_03v3 ad=0.1074p pd=1.08u as=0.1074p ps=1.08u w=0.22u l=0.28u
X1057 VSS VSS VSS VSS nfet_03v3 ad=0.2014p pd=1.98u as=0 ps=0 w=0.22u l=0.28u
X1058 VSS VSS VSS VSS nfet_03v3 ad=0.2014p pd=1.98u as=0 ps=0 w=0.22u l=0.28u
X1059 VSS VSS VSS VSS nfet_03v3 ad=0.61p pd=3.22u as=0 ps=0 w=1u l=8u
X1060 VSS VSS VSS VSS nfet_03v3 ad=0.61p pd=3.22u as=0 ps=0 w=1u l=8u
X1061 VSS VSS VSS VSS nfet_03v3 ad=0.2014p pd=1.98u as=0 ps=0 w=0.22u l=0.28u
X1062 VSS VSS VSS VSS nfet_03v3 ad=0.61p pd=3.22u as=0 ps=0 w=1u l=8u
X1063 VSS VSS VSS VSS nfet_03v3 ad=0.61p pd=3.22u as=0 ps=0 w=1u l=8u
X1064 VSS VSS VSS VSS nfet_03v3 ad=0.61p pd=3.22u as=0 ps=0 w=1u l=1u
X1065 VDD VDD VDD VDD pfet_03v3 ad=0.2166p pd=2.06u as=0 ps=0 w=0.22u l=0.28u
X1066 VSS w[27] a_3364_81516# VSS nfet_03v3 ad=0.2014p pd=1.98u as=0.2014p ps=1.98u w=0.22u l=0.28u
X1067 VSS VSS VSS VSS nfet_03v3 ad=0.61p pd=3.22u as=0 ps=0 w=1u l=8u
X1068 VSS VSS VSS VSS nfet_03v3 ad=0.2014p pd=1.98u as=0 ps=0 w=0.22u l=0.28u
X1069 VSS w[15] a_5364_46404# VSS nfet_03v3 ad=0.2014p pd=1.98u as=0.2014p ps=1.98u w=0.22u l=0.28u
X1070 VSS VSS VSS VSS nfet_03v3 ad=0.2014p pd=1.98u as=0 ps=0 w=0.22u l=0.28u
X1071 VSS VSS VSS VSS nfet_03v3 ad=0.61p pd=3.22u as=0 ps=0 w=1u l=8u
X1072 VDD VDD VDD VDD pfet_03v3 ad=0.65p pd=3.3u as=0 ps=0 w=1u l=1u
X1073 VSS VSS VSS VSS nfet_03v3 ad=0.2014p pd=1.98u as=0 ps=0 w=0.22u l=0.28u
X1074 VSS VSS VSS VSS nfet_03v3 ad=0.61p pd=3.22u as=0 ps=0 w=1u l=8u
X1075 VSS VSS VSS VSS nfet_03v3 ad=0.61p pd=3.22u as=0 ps=0 w=1u l=8u
X1076 VSS VSS VSS VSS nfet_03v3 ad=0.61p pd=3.22u as=0 ps=0 w=1u l=8u
X1077 VSS VSS VSS VSS nfet_03v3 ad=0.61p pd=3.22u as=0 ps=0 w=1u l=8u
X1078 VSS VSS VSS VSS nfet_03v3 ad=0.61p pd=3.22u as=0 ps=0 w=1u l=8u
X1079 VSS VSS VSS VSS nfet_03v3 ad=0.61p pd=3.22u as=0 ps=0 w=1u l=8u
X1080 VDD VDD VDD VDD pfet_03v3 ad=0.65p pd=3.3u as=0 ps=0 w=1u l=1u
X1081 VSS VSS VSS VSS nfet_03v3 ad=0.2014p pd=1.98u as=0 ps=0 w=0.22u l=0.28u
X1082 VSS VSS VSS VSS nfet_03v3 ad=0.61p pd=3.22u as=0 ps=0 w=1u l=8u
X1083 neuron_sized_2.VMEM spike[2] a_43986_27902# VSS nfet_03v3 ad=0.2014p pd=1.98u as=0.2014p ps=1.98u w=0.22u l=5u
X1084 VSS w[31] a_3364_92980# VSS nfet_03v3 ad=0.2014p pd=1.98u as=0.2014p ps=1.98u w=0.22u l=0.28u
X1085 VSS VSS VSS VSS nfet_03v3 ad=0.2014p pd=1.98u as=0 ps=0 w=0.22u l=0.28u
X1086 VDD bias_cell_0.VT_dpi bias_cell_0.VT_dpi VDD pfet_03v3 ad=0.1074p pd=1.08u as=0.1074p ps=1.08u w=0.22u l=0.28u
X1087 VSS VSS VSS VSS nfet_03v3 ad=0.2014p pd=1.98u as=0 ps=0 w=0.22u l=0.28u
X1088 VSS VSS VSS VSS nfet_03v3 ad=0.61p pd=3.22u as=0 ps=0 w=1u l=1u
X1089 VSS VSS VSS VSS nfet_03v3 ad=0.2014p pd=1.98u as=0 ps=0 w=0.22u l=0.28u
X1090 VSS VSS VSS VSS nfet_03v3 ad=0.2014p pd=1.98u as=0 ps=0 w=0.22u l=0.28u
X1091 a_48826_16078# a_50306_20496# spike[1] VSS nfet_03v3 ad=0.2014p pd=1.98u as=0.2014p ps=1.98u w=0.22u l=0.28u
X1092 VDD bias_cell_0.VT_inh bias_cell_0.VT_inh VDD pfet_03v3 ad=0.308p pd=1.58u as=0.308p ps=1.58u w=0.88u l=1.12u
X1093 VSS VSS VSS VSS nfet_03v3 ad=0.2014p pd=1.98u as=0 ps=0 w=0.22u l=0.28u
X1094 VSS VSS VSS VSS nfet_03v3 ad=0.2014p pd=1.98u as=0 ps=0 w=0.22u l=0.28u
X1095 VSS VSS VSS VSS nfet_03v3 ad=0.2014p pd=1.98u as=0 ps=0 w=0.22u l=0.28u
X1096 VSS VSS VSS VSS nfet_03v3 ad=0.2014p pd=1.98u as=0 ps=0 w=0.22u l=0.28u
X1097 DAC_signed_0.DAC_binary_0.Isum a_23094_91304# DPI_0.Isum VSS nfet_03v3 ad=0.2014p pd=1.98u as=0.2014p ps=1.98u w=0.22u l=0.28u
X1098 VSS w[27] a_3364_81516# VSS nfet_03v3 ad=0.2014p pd=1.98u as=0.2014p ps=1.98u w=0.22u l=0.28u
X1099 VSS VSS VSS VSS nfet_03v3 ad=0.2014p pd=1.98u as=0 ps=0 w=0.22u l=0.28u
X1100 VSS w[15] a_5364_46404# VSS nfet_03v3 ad=0.2014p pd=1.98u as=0.2014p ps=1.98u w=0.22u l=0.28u
X1101 VSS VSS VSS VSS nfet_03v3 ad=0.2014p pd=1.98u as=0 ps=0 w=0.22u l=0.28u
X1102 VSS VSS VSS VSS nfet_03v3 ad=0.61p pd=3.22u as=0 ps=0 w=1u l=1u
X1103 VDD s[0] a_23094_79840# VDD pfet_03v3 ad=0.286p pd=2.18u as=0.286p ps=2.18u w=0.44u l=0.28u
X1104 VSS VSS VSS VSS nfet_03v3 ad=0.2014p pd=1.98u as=0 ps=0 w=0.22u l=0.28u
X1105 VSS VSS VSS VSS nfet_03v3 ad=0.2014p pd=1.98u as=0 ps=0 w=0.22u l=0.28u
X1106 VDD VDD VDD VDD pfet_03v3 ad=0.2166p pd=2.06u as=0 ps=0 w=0.22u l=0.28u
X1107 VSS w[20] a_5364_69692# VSS nfet_03v3 ad=0.2014p pd=1.98u as=0.2014p ps=1.98u w=0.22u l=0.28u
X1108 a_46472_8594# a_50306_8672# spike[0] VDD pfet_03v3 ad=0.2166p pd=2.06u as=0.2166p ps=2.06u w=0.22u l=0.28u
X1109 a_48106_4254# bias_cell_0.VIp VSS VSS nfet_03v3 ad=0.61p pd=3.22u as=0.61p ps=3.22u w=1u l=1u
X1110 VSS VSS VSS VSS nfet_03v3 ad=0.2014p pd=1.98u as=0 ps=0 w=0.22u l=0.28u
X1111 VSS VSS VSS VSS nfet_03v3 ad=0.2014p pd=1.98u as=0 ps=0 w=0.22u l=0.28u
X1112 VSS VSS VSS VSS nfet_03v3 ad=0.2014p pd=1.98u as=0 ps=0 w=0.22u l=0.28u
X1113 VSS VSS VSS VSS nfet_03v3 ad=0.2014p pd=1.98u as=0 ps=0 w=0.22u l=0.28u
X1114 bias_cell_0.VT_dpi bias_cell_0.VT_dpi VDD VDD pfet_03v3 ad=0.1074p pd=1.08u as=0.1074p ps=1.08u w=0.22u l=0.28u
X1115 VSS w[31] a_3364_92980# VSS nfet_03v3 ad=0.2014p pd=1.98u as=0.2014p ps=1.98u w=0.22u l=0.28u
X1116 VSS VSS VSS VSS nfet_03v3 ad=0.2014p pd=1.98u as=0 ps=0 w=0.22u l=0.28u
X1117 VSS VSS VSS VSS nfet_03v3 ad=0.2014p pd=1.98u as=0 ps=0 w=0.22u l=0.28u
X1118 VSS VSS VSS VSS nfet_03v3 ad=0.61p pd=3.22u as=0 ps=0 w=1u l=8u
X1119 VSS bias_cell_0.Vb VSS VSS nfet_03v3 ad=0.61p pd=3.22u as=0 ps=0 w=1u l=8u
X1120 VSS VSS VSS VSS nfet_03v3 ad=0.2014p pd=1.98u as=0 ps=0 w=0.22u l=0.28u
X1121 VSS VSS VSS VSS nfet_03v3 ad=0.2014p pd=1.98u as=0 ps=0 w=0.22u l=0.28u
X1122 VSS bias_cell_0.Vb VSS VSS nfet_03v3 ad=0.61p pd=3.22u as=0 ps=0 w=1u l=8u
X1123 a_34584_81836# a_34584_81836# DPI_inh_0.Isum DPI_inh_0.Isum nfet_03v3 ad=0.5368p pd=2.98u as=0.5368p ps=2.98u w=0.88u l=1.12u
X1124 VSS VSS VSS VSS nfet_03v3 ad=0.2014p pd=1.98u as=0 ps=0 w=0.22u l=0.28u
X1125 VSS bias_cell_0.Vb VSS VSS nfet_03v3 ad=0.61p pd=3.22u as=0 ps=0 w=1u l=8u
X1126 VSS VSS VSS VSS nfet_03v3 ad=0.2014p pd=1.98u as=0 ps=0 w=0.22u l=0.28u
X1127 VSS VSS VSS VSS nfet_03v3 ad=0.2014p pd=1.98u as=0 ps=0 w=0.22u l=0.28u
X1128 VSS bias_cell_0.Vb VSS VSS nfet_03v3 ad=0.61p pd=3.22u as=0 ps=0 w=1u l=8u
X1129 VSS VSS VSS VSS nfet_03v3 ad=0.2014p pd=1.98u as=0 ps=0 w=0.22u l=0.28u
X1130 a_50306_32320# a_45030_32320# a_48106_27902# VSS nfet_03v3 ad=0.2014p pd=1.98u as=0.2014p ps=1.98u w=0.22u l=0.28u
X1131 VSS bias_cell_0.Vb VSS VSS nfet_03v3 ad=0.61p pd=3.22u as=0 ps=0 w=1u l=8u
X1132 VSS VSS VSS VSS nfet_03v3 ad=0.2014p pd=1.98u as=0 ps=0 w=0.22u l=0.28u
X1133 VSS VSS VSS VSS nfet_03v3 ad=0.2014p pd=1.98u as=0 ps=0 w=0.22u l=0.28u
X1134 VSS VSS VSS VSS nfet_03v3 ad=0.2014p pd=1.98u as=0 ps=0 w=0.22u l=0.28u
X1135 VSS VSS VSS VSS nfet_03v3 ad=0.2014p pd=1.98u as=0 ps=0 w=0.22u l=0.28u
X1136 VSS VSS VSS VSS nfet_03v3 ad=0.2014p pd=1.98u as=0 ps=0 w=0.22u l=0.28u
X1137 VSS w[7] a_5364_23116# VSS nfet_03v3 ad=0.2014p pd=1.98u as=0.2014p ps=1.98u w=0.22u l=0.28u
X1138 a_2244_98592# a_2244_98592# VDD VDD pfet_03v3 ad=1.75p pd=5.7u as=3.25p ps=11.3u w=5u l=8u
X1139 a_46472_78818# bias_cell_0.VKup VDD VDD pfet_03v3 ad=0.65p pd=3.3u as=0.65p ps=3.3u w=1u l=1u
X1140 VDD VDD VDD VDD pfet_03v3 ad=0.65p pd=3.3u as=0 ps=0 w=1u l=1u
X1141 VDD bias_cell_0.Vthr bias_cell_0.Vthr VDD pfet_03v3 ad=0.1074p pd=1.08u as=0.1074p ps=1.08u w=0.22u l=0.28u
X1142 VSS w[26] a_3364_81516# VSS nfet_03v3 ad=0.2014p pd=1.98u as=0.2014p ps=1.98u w=0.22u l=0.28u
X1143 VSS w[14] a_5364_46404# VSS nfet_03v3 ad=0.2014p pd=1.98u as=0.2014p ps=1.98u w=0.22u l=0.28u
X1144 VSS w[11] a_5364_34940# VSS nfet_03v3 ad=0.2014p pd=1.98u as=0.2014p ps=1.98u w=0.22u l=0.28u
X1145 VDD VDD VDD VDD pfet_03v3 ad=0.65p pd=3.3u as=0 ps=0 w=1u l=1u
X1146 VSS VSS VSS VSS nfet_03v3 ad=0.2014p pd=1.98u as=0 ps=0 w=0.22u l=0.28u
X1147 VSS w[19] a_5364_58228# VSS nfet_03v3 ad=0.2014p pd=1.98u as=0.2014p ps=1.98u w=0.22u l=0.28u
X1148 VSS VSS VSS VSS nfet_03v3 ad=0.61p pd=3.22u as=0 ps=0 w=1u l=8u
X1149 VSS VSS VSS VSS nfet_03v3 ad=0.2014p pd=1.98u as=0 ps=0 w=0.22u l=0.28u
X1150 VSS VSS VSS VSS nfet_03v3 ad=0.61p pd=3.22u as=0 ps=0 w=1u l=1u
X1151 VSS VSS VSS VSS nfet_03v3 ad=0.2014p pd=1.98u as=0 ps=0 w=0.22u l=0.28u
X1152 VSS VSS VSS VSS nfet_03v3 ad=0.61p pd=3.22u as=0 ps=0 w=1u l=1u
X1153 VSS VSS VSS VSS nfet_03v3 ad=0.61p pd=3.22u as=0 ps=0 w=1u l=8u
X1154 VSS VSS VSS VSS nfet_03v3 ad=0.2014p pd=1.98u as=0 ps=0 w=0.22u l=0.28u
X1155 VSS VSS VSS VSS nfet_03v3 ad=0.2014p pd=1.98u as=0 ps=0 w=0.22u l=0.28u
X1156 VDD bias_cell_0.Vthr bias_cell_0.Vthr VDD pfet_03v3 ad=0.1074p pd=1.08u as=0.1074p ps=1.08u w=0.22u l=0.28u
X1157 VSS bias_cell_0.Vb VSS VSS nfet_03v3 ad=0.61p pd=3.22u as=0 ps=0 w=1u l=8u
X1158 VSS VSS VSS VSS nfet_03v3 ad=0.2014p pd=1.98u as=0 ps=0 w=0.22u l=0.28u
X1159 VSS VSS VSS VSS nfet_03v3 ad=0.61p pd=3.22u as=0 ps=0 w=1u l=8u
X1160 VSS VSS VSS VSS nfet_03v3 ad=0.2014p pd=1.98u as=0 ps=0 w=0.22u l=0.28u
X1161 VSS VSS VSS VSS nfet_03v3 ad=0.2014p pd=1.98u as=0 ps=0 w=0.22u l=0.28u
X1162 VSS s[1] a_23094_91304# VSS nfet_03v3 ad=0.2014p pd=1.98u as=0.2014p ps=1.98u w=0.22u l=0.28u
X1163 VSS VSS VSS VSS nfet_03v3 ad=0.2014p pd=1.98u as=0 ps=0 w=0.22u l=0.28u
X1164 VSS w[30] a_3364_92980# VSS nfet_03v3 ad=0.2014p pd=1.98u as=0.2014p ps=1.98u w=0.22u l=0.28u
X1165 VSS VSS VSS VSS nfet_03v3 ad=0.2014p pd=1.98u as=0 ps=0 w=0.22u l=0.28u
X1166 VSS VSS VSS VSS nfet_03v3 ad=0.61p pd=3.22u as=0 ps=0 w=1u l=1u
X1167 VSS VSS VSS VSS nfet_03v3 ad=0.2014p pd=1.98u as=0 ps=0 w=0.22u l=0.28u
X1168 VSS VSS VSS VSS nfet_03v3 ad=0.2014p pd=1.98u as=0 ps=0 w=0.22u l=0.28u
X1169 a_48826_4254# bias_cell_0.VKdn VSS VSS nfet_03v3 ad=0.61p pd=3.22u as=0.61p ps=3.22u w=1u l=1u
X1170 VSS w[7] a_5364_23116# VSS nfet_03v3 ad=0.2014p pd=1.98u as=0.2014p ps=1.98u w=0.22u l=0.28u
X1171 VSS VSS VSS VSS nfet_03v3 ad=0.2014p pd=1.98u as=0 ps=0 w=0.22u l=0.28u
X1172 a_43986_51190# bias_cell_0.VK VSS VSS nfet_03v3 ad=0.61p pd=3.22u as=0.61p ps=3.22u w=1u l=1u
X1173 VSS VSS VSS VSS nfet_03v3 ad=0.61p pd=3.22u as=0 ps=0 w=1u l=1u
X1174 VSS VSS VSS VSS nfet_03v3 ad=0.2014p pd=1.98u as=0 ps=0 w=0.22u l=0.28u
X1175 VDD VDD VDD VDD pfet_03v3 ad=0.2166p pd=2.06u as=0 ps=0 w=0.22u l=0.28u
X1176 VSS VSS VSS VSS nfet_03v3 ad=0.2014p pd=1.98u as=0 ps=0 w=0.22u l=0.28u
X1177 VSS VSS VSS VSS nfet_03v3 ad=0.2014p pd=1.98u as=0 ps=0 w=0.22u l=0.28u
X1178 VSS VSS VSS VSS nfet_03v3 ad=0.2014p pd=1.98u as=0 ps=0 w=0.22u l=0.28u
X1179 bias_cell_0.Vthr bias_cell_0.Vthr VDD VDD pfet_03v3 ad=0.1074p pd=1.08u as=0.1074p ps=1.08u w=0.22u l=0.28u
X1180 VSS w[11] a_5364_34940# VSS nfet_03v3 ad=0.2014p pd=1.98u as=0.2014p ps=1.98u w=0.22u l=0.28u
X1181 a_34406_27492# a_34406_27492# DPI_2.Isum DPI_2.Isum nfet_03v3 ad=0.2014p pd=1.98u as=0.2014p ps=1.98u w=0.22u l=0.28u
X1182 DPI_inh_0.Isum s[1] DAC_signed_0.DAC_binary_0.Isum VSS nfet_03v3 ad=0.2014p pd=1.98u as=0.2014p ps=1.98u w=0.22u l=0.28u
X1183 VSS VSS VSS VSS nfet_03v3 ad=0.2014p pd=1.98u as=0 ps=0 w=0.22u l=0.28u
X1184 VSS w[19] a_5364_58228# VSS nfet_03v3 ad=0.2014p pd=1.98u as=0.2014p ps=1.98u w=0.22u l=0.28u
X1185 VSS VSS VSS VSS nfet_03v3 ad=0.2014p pd=1.98u as=0 ps=0 w=0.22u l=0.28u
X1186 neuron_sized_2.VMEM a_50306_32320# a_43278_32242# VDD pfet_03v3 ad=0.2166p pd=2.06u as=0.2166p ps=2.06u w=0.22u l=0.28u
X1187 a_45030_8672# a_44260_8656# VDD VDD pfet_03v3 ad=0.2166p pd=2.06u as=0.2166p ps=2.06u w=0.22u l=0.28u
X1188 VSS VSS VSS VSS nfet_03v3 ad=0.2014p pd=1.98u as=0 ps=0 w=0.22u l=0.28u
X1189 VSS VSS VSS VSS nfet_03v3 ad=0.2014p pd=1.98u as=0 ps=0 w=0.22u l=0.28u
X1190 VSS VSS VSS VSS nfet_03v3 ad=0.2014p pd=1.98u as=0 ps=0 w=0.22u l=0.28u
X1191 VSS VSS VSS VSS nfet_03v3 ad=0.61p pd=3.22u as=0 ps=0 w=1u l=8u
X1192 VSS bias_cell_0.Vb VSS VSS nfet_03v3 ad=0.61p pd=3.22u as=0 ps=0 w=1u l=8u
X1193 VSS VSS VSS VSS nfet_03v3 ad=0.61p pd=3.22u as=0 ps=0 w=1u l=1u
X1194 VSS VSS VSS VSS nfet_03v3 ad=0.2014p pd=1.98u as=0 ps=0 w=0.22u l=0.28u
X1195 VSS bias_cell_0.Vb VSS VSS nfet_03v3 ad=0.61p pd=3.22u as=0 ps=0 w=1u l=8u
X1196 a_34406_74068# VDD cap_mim_2f0_m4m5_noshield c_width=22.36u c_length=22.36u
X1197 VDD bias_cell_0.VT_dpi bias_cell_0.VT_dpi VDD pfet_03v3 ad=0.1074p pd=1.08u as=0.1074p ps=1.08u w=0.22u l=0.28u
X1198 VSS bias_cell_0.Vb VSS VSS nfet_03v3 ad=0.61p pd=3.22u as=0 ps=0 w=1u l=8u
X1199 VSS bias_cell_0.Vb VSS VSS nfet_03v3 ad=0.61p pd=3.22u as=0 ps=0 w=1u l=8u
X1200 VSS VSS VSS VSS nfet_03v3 ad=0.2014p pd=1.98u as=0 ps=0 w=0.22u l=0.28u
X1201 neuron_sized_2.VMEM a_34406_27492# VDD VDD pfet_03v3 ad=0.2166p pd=2.06u as=0.2166p ps=2.06u w=0.22u l=0.28u
X1202 VSS VSS VSS VSS nfet_03v3 ad=0.2014p pd=1.98u as=0 ps=0 w=0.22u l=0.28u
X1203 VSS bias_cell_0.Vb VSS VSS nfet_03v3 ad=0.61p pd=3.22u as=0 ps=0 w=1u l=8u
X1204 VDD VDD VDD VDD pfet_03v3 ad=0.2166p pd=2.06u as=0 ps=0 w=0.22u l=0.28u
X1205 VSS VSS VSS VSS nfet_03v3 ad=0.2014p pd=1.98u as=0 ps=0 w=0.22u l=0.28u
X1206 VSS w[27] a_3364_81516# VSS nfet_03v3 ad=0.2014p pd=1.98u as=0.2014p ps=1.98u w=0.22u l=0.28u
X1207 VSS VSS VSS VSS nfet_03v3 ad=0.2014p pd=1.98u as=0 ps=0 w=0.22u l=0.28u
X1208 VSS w[15] a_5364_46404# VSS nfet_03v3 ad=0.2014p pd=1.98u as=0.2014p ps=1.98u w=0.22u l=0.28u
X1209 VSS VSS VSS VSS nfet_03v3 ad=0.2014p pd=1.98u as=0 ps=0 w=0.22u l=0.28u
X1210 VSS VSS VSS VSS nfet_03v3 ad=0.61p pd=3.22u as=0 ps=0 w=1u l=8u
X1211 VSS bias_cell_0.Vb VSS VSS nfet_03v3 ad=0.61p pd=3.22u as=0 ps=0 w=1u l=8u
X1212 VSS VSS VSS VSS nfet_03v3 ad=0.2014p pd=1.98u as=0 ps=0 w=0.22u l=0.28u
X1213 VSS w[6] a_5364_23116# VSS nfet_03v3 ad=0.2014p pd=1.98u as=0.2014p ps=1.98u w=0.22u l=0.28u
X1214 VSS VSS VSS VSS nfet_03v3 ad=0.61p pd=3.22u as=0 ps=0 w=1u l=8u
X1215 VSS w[3] a_5364_11292# VSS nfet_03v3 ad=0.2014p pd=1.98u as=0.2014p ps=1.98u w=0.22u l=0.28u
X1216 VSS VSS VSS VSS nfet_03v3 ad=0.2014p pd=1.98u as=0 ps=0 w=0.22u l=0.28u
X1217 VSS VSS VSS VSS nfet_03v3 ad=0.61p pd=3.22u as=0 ps=0 w=1u l=8u
X1218 VSS bias_cell_0.Vb VSS VSS nfet_03v3 ad=0.61p pd=3.22u as=0 ps=0 w=1u l=8u
X1219 VSS VSS VSS VSS nfet_03v3 ad=0.61p pd=3.22u as=0 ps=0 w=1u l=8u
X1220 VSS VSS VSS VSS nfet_03v3 ad=0.2014p pd=1.98u as=0 ps=0 w=0.22u l=0.28u
X1221 VSS w[10] a_5364_34940# VSS nfet_03v3 ad=0.2014p pd=1.98u as=0.2014p ps=1.98u w=0.22u l=0.28u
X1222 a_45030_32320# VT a_45268_27980# VSS nfet_03v3 ad=0.2014p pd=1.98u as=0.2014p ps=1.98u w=0.22u l=0.28u
X1223 VSS bias_cell_0.Vb VSS VSS nfet_03v3 ad=0.61p pd=3.22u as=0 ps=0 w=1u l=8u
X1224 VSS VSS VSS VSS nfet_03v3 ad=0.2014p pd=1.98u as=0 ps=0 w=0.22u l=0.28u
X1225 VSS w[18] a_5364_58228# VSS nfet_03v3 ad=0.2014p pd=1.98u as=0.2014p ps=1.98u w=0.22u l=0.28u
X1226 VSS bias_cell_0.Vb VSS VSS nfet_03v3 ad=0.61p pd=3.22u as=0 ps=0 w=1u l=8u
X1227 VSS VSS VSS VSS nfet_03v3 ad=0.2014p pd=1.98u as=0 ps=0 w=0.22u l=0.28u
X1228 VSS VSS VSS VSS nfet_03v3 ad=0.2014p pd=1.98u as=0 ps=0 w=0.22u l=0.28u
X1229 VSS VSS VSS VSS nfet_03v3 ad=0.2014p pd=1.98u as=0 ps=0 w=0.22u l=0.28u
X1230 VSS VSS VSS VSS nfet_03v3 ad=0.61p pd=3.22u as=0 ps=0 w=1u l=1u
X1231 VSS VSS VSS VSS nfet_03v3 ad=0.2014p pd=1.98u as=0 ps=0 w=0.22u l=0.28u
X1232 VSS VSS VSS VSS nfet_03v3 ad=0.61p pd=3.22u as=0 ps=0 w=1u l=8u
X1233 VSS bias_cell_0.Vb VSS VSS nfet_03v3 ad=0.61p pd=3.22u as=0 ps=0 w=1u l=8u
X1234 VSS VSS VSS VSS nfet_03v3 ad=0.61p pd=3.22u as=0 ps=0 w=1u l=8u
X1235 VSS VSS VSS VSS nfet_03v3 ad=0.2014p pd=1.98u as=0 ps=0 w=0.22u l=0.28u
X1236 VSS VSS VSS VSS nfet_03v3 ad=0.2014p pd=1.98u as=0 ps=0 w=0.22u l=0.28u
X1237 VSS VSS VSS VSS nfet_03v3 ad=0.2014p pd=1.98u as=0 ps=0 w=0.22u l=0.28u
X1238 a_2244_98592# Iref VSS VSS nfet_03v3 ad=1.75p pd=5.7u as=3.05p ps=11.22u w=5u l=8u
X1239 VSS VSS VSS VSS nfet_03v3 ad=0.2014p pd=1.98u as=0 ps=0 w=0.22u l=0.28u
X1240 a_34584_81836# bias_cell_0.VT_inh VDD VDD pfet_03v3 ad=0.572p pd=3.06u as=0.572p ps=3.06u w=0.88u l=1.12u
X1241 VSS VSS VSS VSS nfet_03v3 ad=0.2014p pd=1.98u as=0 ps=0 w=0.22u l=0.28u
X1242 VSS VSS VSS VSS nfet_03v3 ad=0.2014p pd=1.98u as=0 ps=0 w=0.22u l=0.28u
X1243 bias_cell_0.VK bias_cell_0.VK VSS VSS nfet_03v3 ad=0.2014p pd=1.98u as=0.2014p ps=1.98u w=0.22u l=40u
X1244 VDD VDD VDD VDD pfet_03v3 ad=0.2166p pd=2.06u as=0 ps=0 w=0.22u l=0.28u
X1245 VSS VSS VSS VSS nfet_03v3 ad=0.2014p pd=1.98u as=0 ps=0 w=0.22u l=0.28u
X1246 VSS VSS VSS VSS nfet_03v3 ad=0.2014p pd=1.98u as=0 ps=0 w=0.22u l=0.28u
X1247 VSS VSS VSS VSS nfet_03v3 ad=0.2014p pd=1.98u as=0 ps=0 w=0.22u l=0.28u
X1248 a_34406_15668# VDD cap_mim_2f0_m4m5_noshield c_width=22.36u c_length=22.36u
X1249 VSS w[2] a_5364_11292# VSS nfet_03v3 ad=0.2014p pd=1.98u as=0.2014p ps=1.98u w=0.22u l=0.28u
X1250 VDD bias_cell_0.Vthr DPI_inh_0.Isum DPI_inh_0.Isum nfet_03v3 ad=0.5368p pd=2.98u as=0.5368p ps=2.98u w=0.88u l=1.12u
X1251 VSS VSS VSS VSS nfet_03v3 ad=1.22p pd=5.22u as=0 ps=0 w=2u l=8u
X1252 VSS VSS VSS VSS nfet_03v3 ad=0.2014p pd=1.98u as=0 ps=0 w=0.22u l=0.28u
X1253 VSS VSS VSS VSS nfet_03v3 ad=0.2014p pd=1.98u as=0 ps=0 w=0.22u l=0.28u
X1254 a_43278_20418# bias_cell_0.VNA VDD VDD pfet_03v3 ad=0.65p pd=3.3u as=0.65p ps=3.3u w=1u l=1u
X1255 VSS VSS VSS VSS nfet_03v3 ad=0.2014p pd=1.98u as=0 ps=0 w=0.22u l=0.28u
X1256 VDD VDD VDD VDD pfet_03v3 ad=0.65p pd=3.3u as=0 ps=0 w=1u l=1u
X1257 VSS VSS VSS VSS nfet_03v3 ad=0.2014p pd=1.98u as=0 ps=0 w=0.22u l=0.28u
X1258 VSS bias_cell_0.Vb VSS VSS nfet_03v3 ad=0.61p pd=3.22u as=0 ps=0 w=1u l=8u
X1259 VSS VSS VSS VSS nfet_03v3 ad=0.2014p pd=1.98u as=0 ps=0 w=0.22u l=0.28u
X1260 VSS VSS VSS VSS nfet_03v3 ad=0.2014p pd=1.98u as=0 ps=0 w=0.22u l=0.28u
X1261 bias_cell_0.VT_inh bias_cell_0.VT_inh VDD VDD pfet_03v3 ad=0.308p pd=1.58u as=0.572p ps=3.06u w=0.88u l=1.12u
X1262 VSS VSS VSS VSS nfet_03v3 ad=0.2014p pd=1.98u as=0 ps=0 w=0.22u l=0.28u
X1263 VSS VSS VSS VSS nfet_03v3 ad=0.2014p pd=1.98u as=0 ps=0 w=0.22u l=0.28u
X1264 VSS VSS VSS VSS nfet_03v3 ad=0.2014p pd=1.98u as=0 ps=0 w=0.22u l=0.28u
X1265 VDD a_44260_32304# a_44260_32304# VDD pfet_03v3 ad=0.2166p pd=2.06u as=0.2166p ps=2.06u w=0.22u l=0.28u
X1266 VDD VDD VDD VDD pfet_03v3 ad=0.65p pd=3.3u as=0 ps=0 w=1u l=1u
X1267 VSS VSS VSS VSS nfet_03v3 ad=0.61p pd=3.22u as=0 ps=0 w=1u l=8u
X1268 VSS VSS VSS VSS nfet_03v3 ad=0.2014p pd=1.98u as=0 ps=0 w=0.22u l=0.28u
X1269 VDD bias_cell_0.Vthr bias_cell_0.Vthr VDD pfet_03v3 ad=0.1074p pd=1.08u as=0.1074p ps=1.08u w=0.22u l=0.28u
X1270 VSS VSS VSS VSS nfet_03v3 ad=0.2014p pd=1.98u as=0 ps=0 w=0.22u l=0.28u
X1271 VSS VSS VSS VSS nfet_03v3 ad=0.61p pd=3.22u as=0 ps=0 w=1u l=8u
X1272 VSS VSS VSS VSS nfet_03v3 ad=0.2014p pd=1.98u as=0 ps=0 w=0.22u l=0.28u
X1273 VSS VSS VSS VSS nfet_03v3 ad=0.61p pd=3.22u as=0 ps=0 w=1u l=8u
X1274 VSS VSS VSS VSS nfet_03v3 ad=0.2014p pd=1.98u as=0 ps=0 w=0.22u l=0.28u
X1275 bias_cell_0.Vb a_2244_98592# VDD VDD pfet_03v3 ad=0.93275p pd=4.17u as=0.93275p ps=4.17u w=1.435u l=8u
X1276 VSS VSS VSS VSS nfet_03v3 ad=0.2014p pd=1.98u as=0 ps=0 w=0.22u l=0.28u
X1277 VSS VSS VSS VSS nfet_03v3 ad=0.2014p pd=1.98u as=0 ps=0 w=0.22u l=0.28u
X1278 VSS VSS VSS VSS nfet_03v3 ad=0.2014p pd=1.98u as=0 ps=0 w=0.22u l=0.28u
X1279 a_50306_55608# a_45030_55608# VDD VDD pfet_03v3 ad=0.2166p pd=2.06u as=0.2166p ps=2.06u w=0.22u l=0.28u
X1280 VSS VSS VSS VSS nfet_03v3 ad=0.2014p pd=1.98u as=0 ps=0 w=0.22u l=0.28u
X1281 VSS bias_cell_0.Vb VSS VSS nfet_03v3 ad=0.61p pd=3.22u as=0 ps=0 w=1u l=8u
X1282 VSS w[7] a_5364_23116# VSS nfet_03v3 ad=0.2014p pd=1.98u as=0.2014p ps=1.98u w=0.22u l=0.28u
X1283 VSS VSS VSS VSS nfet_03v3 ad=0.2014p pd=1.98u as=0 ps=0 w=0.22u l=0.28u
X1284 VSS VSS VSS VSS nfet_03v3 ad=0.61p pd=3.22u as=0 ps=0 w=1u l=8u
X1285 VSS VSS VSS VSS nfet_03v3 ad=0.61p pd=3.22u as=0 ps=0 w=1u l=1u
X1286 VSS VSS VSS VSS nfet_03v3 ad=0.61p pd=3.22u as=0 ps=0 w=1u l=8u
X1287 VSS VSS VSS VSS nfet_03v3 ad=0.61p pd=3.22u as=0 ps=0 w=1u l=1u
X1288 VSS VSS VSS VSS nfet_03v3 ad=0.2014p pd=1.98u as=0 ps=0 w=0.22u l=0.28u
X1289 VSS bias_cell_0.Vb VSS VSS nfet_03v3 ad=0.61p pd=3.22u as=0 ps=0 w=1u l=8u
X1290 bias_cell_0.Vthr bias_cell_0.Vthr VDD VDD pfet_03v3 ad=0.1074p pd=1.08u as=0.1074p ps=1.08u w=0.22u l=0.28u
X1291 VSS bias_cell_0.Vb VSS VSS nfet_03v3 ad=0.61p pd=3.22u as=0 ps=0 w=1u l=8u
X1292 VSS VSS VSS VSS nfet_03v3 ad=0.61p pd=3.22u as=0 ps=0 w=1u l=8u
X1293 VSS VSS VSS VSS nfet_03v3 ad=0.61p pd=3.22u as=0 ps=0 w=1u l=8u
X1294 VSS VSS VSS VSS nfet_03v3 ad=0.2014p pd=1.98u as=0 ps=0 w=0.22u l=0.28u
X1295 VDD bias_cell_0.VT_inh bias_cell_0.VT_inh VDD pfet_03v3 ad=0.308p pd=1.58u as=0.308p ps=1.58u w=0.88u l=1.12u
X1296 VSS VSS VSS VSS nfet_03v3 ad=0.61p pd=3.22u as=0 ps=0 w=1u l=1u
X1297 VSS bias_cell_0.Vb VSS VSS nfet_03v3 ad=0.61p pd=3.22u as=0 ps=0 w=1u l=8u
X1298 VSS bias_cell_0.Vb VSS VSS nfet_03v3 ad=0.61p pd=3.22u as=0 ps=0 w=1u l=8u
X1299 VSS VSS VSS VSS nfet_03v3 ad=0.61p pd=3.22u as=0 ps=0 w=1u l=8u
X1300 bias_cell_0.VIp a_2244_98592# VDD VDD pfet_03v3 ad=1.51775p pd=5.97u as=1.51775p ps=5.97u w=2.335u l=8u
X1301 VSS VSS VSS VSS nfet_03v3 ad=0.2014p pd=1.98u as=0 ps=0 w=0.22u l=0.28u
X1302 bias_cell_0.VT_dpi Iref VSS VSS nfet_03v3 ad=0.71065p pd=3.55u as=0.71065p ps=3.55u w=1.165u l=32u
X1303 VSS bias_cell_0.Vb VSS VSS nfet_03v3 ad=0.61p pd=3.22u as=0 ps=0 w=1u l=8u
X1304 VSS VSS VSS VSS nfet_03v3 ad=0.2014p pd=1.98u as=0 ps=0 w=0.22u l=0.28u
X1305 VSS w[23] a_5364_69692# VSS nfet_03v3 ad=0.2014p pd=1.98u as=0.2014p ps=1.98u w=0.22u l=0.28u
X1306 VDD VDD VDD VDD pfet_03v3 ad=0.2166p pd=2.06u as=0 ps=0 w=0.22u l=0.28u
X1307 VSS bias_cell_0.Vb VSS VSS nfet_03v3 ad=0.61p pd=3.22u as=0 ps=0 w=1u l=8u
X1308 VSS VSS VSS VSS nfet_03v3 ad=0.61p pd=3.22u as=0 ps=0 w=1u l=8u
X1309 VDD VDD VDD VDD pfet_03v3 ad=0.2166p pd=2.06u as=0 ps=0 w=0.22u l=0.28u
X1310 spike[0] VSS cap_mim_2f0_m4m5_noshield c_width=10u c_length=10u
X1311 VSS VSS VSS VSS nfet_03v3 ad=0.2014p pd=1.98u as=0 ps=0 w=0.22u l=0.28u
X1312 VSS VSS VSS VSS nfet_03v3 ad=0.2014p pd=1.98u as=0 ps=0 w=0.22u l=0.28u
X1313 VSS VSS VSS VSS nfet_03v3 ad=0.2014p pd=1.98u as=0 ps=0 w=0.22u l=0.28u
X1314 a_48826_74478# bias_cell_0.VKdn VSS VSS nfet_03v3 ad=0.61p pd=3.22u as=0.61p ps=3.22u w=1u l=1u
X1315 VSS VSS VSS VSS nfet_03v3 ad=0.2014p pd=1.98u as=0 ps=0 w=0.22u l=0.28u
X1316 VSS bias_cell_0.Vb VSS VSS nfet_03v3 ad=0.61p pd=3.22u as=0 ps=0 w=1u l=8u
X1317 bias_cell_0.Vlk bias_cell_0.Vlk VSS VSS nfet_03v3 ad=0.35p pd=1.7u as=0.61p ps=3.22u w=1u l=1u
X1318 VSS bias_cell_0.VKdn bias_cell_0.VKdn VSS nfet_03v3 ad=0.35p pd=1.7u as=0.35p ps=1.7u w=1u l=1u
X1319 spike[1] VSS cap_mim_2f0_m4m5_noshield c_width=10u c_length=10u
X1320 VSS VSS VSS VSS nfet_03v3 ad=0.2014p pd=1.98u as=0 ps=0 w=0.22u l=0.28u
X1321 VSS VSS VSS VSS nfet_03v3 ad=0.2014p pd=1.98u as=0 ps=0 w=0.22u l=0.28u
X1322 VSS bias_cell_0.Vb VSS VSS nfet_03v3 ad=0.61p pd=3.22u as=0 ps=0 w=1u l=8u
X1323 VSS VSS VSS VSS nfet_03v3 ad=0.61p pd=3.22u as=0 ps=0 w=1u l=8u
X1324 VSS VSS VSS VSS nfet_03v3 ad=0.61p pd=3.22u as=0 ps=0 w=1u l=1u
X1325 VSS VSS VSS VSS nfet_03v3 ad=0.61p pd=3.22u as=0 ps=0 w=1u l=8u
X1326 VSS bias_cell_0.Vb VSS VSS nfet_03v3 ad=0.61p pd=3.22u as=0 ps=0 w=1u l=8u
X1327 VSS VSS VSS VSS nfet_03v3 ad=0.2014p pd=1.98u as=0 ps=0 w=0.22u l=0.28u
X1328 VSS VSS VSS VSS nfet_03v3 ad=0.2014p pd=1.98u as=0 ps=0 w=0.22u l=0.28u
X1329 VSS VSS VSS VSS nfet_03v3 ad=0.2014p pd=1.98u as=0 ps=0 w=0.22u l=0.28u
X1330 VSS VSS VSS VSS nfet_03v3 ad=0.2014p pd=1.98u as=0 ps=0 w=0.22u l=0.28u
X1331 VSS VSS VSS VSS nfet_03v3 ad=0.2014p pd=1.98u as=0 ps=0 w=0.22u l=0.28u
X1332 VSS w[25] a_3364_81516# VSS nfet_03v3 ad=0.2014p pd=1.98u as=0.2014p ps=1.98u w=0.22u l=0.28u
X1333 VSS w[13] a_5364_46404# VSS nfet_03v3 ad=0.2014p pd=1.98u as=0.2014p ps=1.98u w=0.22u l=0.28u
X1334 VSS bias_cell_0.Vb VSS VSS nfet_03v3 ad=0.61p pd=3.22u as=0 ps=0 w=1u l=8u
X1335 VSS bias_cell_0.Vlk bias_cell_0.Vlk VSS nfet_03v3 ad=0.35p pd=1.7u as=0.35p ps=1.7u w=1u l=1u
X1336 VSS VSS VSS VSS nfet_03v3 ad=0.2014p pd=1.98u as=0 ps=0 w=0.22u l=0.28u
X1337 VSS VSS VSS VSS nfet_03v3 ad=0.61p pd=3.22u as=0 ps=0 w=1u l=8u
X1338 VSS VSS VSS VSS nfet_03v3 ad=0.2014p pd=1.98u as=0 ps=0 w=0.22u l=0.28u
X1339 VSS VSS VSS VSS nfet_03v3 ad=0.61p pd=3.22u as=0 ps=0 w=1u l=8u
X1340 VSS VSS VSS VSS nfet_03v3 ad=0.61p pd=3.22u as=0 ps=0 w=1u l=1u
X1341 bias_cell_0.VT_inh bias_cell_0.VT_inh VDD VDD pfet_03v3 ad=0.308p pd=1.58u as=0.308p ps=1.58u w=0.88u l=1.12u
X1342 a_34406_3844# a_34406_3844# DPI_4.Isum DPI_4.Isum nfet_03v3 ad=0.2014p pd=1.98u as=0.2014p ps=1.98u w=0.22u l=0.28u
X1343 VSS bias_cell_0.VKdn bias_cell_0.VKdn VSS nfet_03v3 ad=0.61p pd=3.22u as=0.35p ps=1.7u w=1u l=1u
X1344 VSS bias_cell_0.Vb VSS VSS nfet_03v3 ad=0.61p pd=3.22u as=0 ps=0 w=1u l=8u
X1345 VSS bias_cell_0.Vb VSS VSS nfet_03v3 ad=0.61p pd=3.22u as=0 ps=0 w=1u l=8u
X1346 VSS VSS VSS VSS nfet_03v3 ad=0.61p pd=3.22u as=0 ps=0 w=1u l=1u
X1347 neuron_sized_1.VMEM bias_cell_0.Vlk VSS VSS nfet_03v3 ad=0.61p pd=3.22u as=0.61p ps=3.22u w=1u l=1u
X1348 VSS bias_cell_0.Vb VSS VSS nfet_03v3 ad=0.61p pd=3.22u as=0 ps=0 w=1u l=8u
X1349 VSS VSS VSS VSS nfet_03v3 ad=0.2014p pd=1.98u as=0 ps=0 w=0.22u l=0.28u
X1350 VSS w[2] a_5364_11292# VSS nfet_03v3 ad=0.2014p pd=1.98u as=0.2014p ps=1.98u w=0.22u l=0.28u
X1351 VSS VSS VSS VSS nfet_03v3 ad=0.61p pd=3.22u as=0 ps=0 w=1u l=8u
X1352 DPI_inh_0.Iout spike[4] a_43986_74478# VSS nfet_03v3 ad=0.2014p pd=1.98u as=0.2014p ps=1.98u w=0.22u l=5u
X1353 VSS VSS VSS VSS nfet_03v3 ad=0.2014p pd=1.98u as=0 ps=0 w=0.22u l=0.28u
X1354 VDD VDD VDD VDD pfet_03v3 ad=0.2166p pd=2.06u as=0 ps=0 w=0.22u l=0.28u
X1355 VSS VSS VSS VSS nfet_03v3 ad=0.2014p pd=1.98u as=0 ps=0 w=0.22u l=0.28u
X1356 VSS VSS VSS VSS nfet_03v3 ad=0.61p pd=3.22u as=0 ps=0 w=1u l=8u
X1357 VSS VSS VSS VSS nfet_03v3 ad=0.2014p pd=1.98u as=0 ps=0 w=0.22u l=0.28u
X1358 bias_cell_0.VT_dpi bias_cell_0.VT_dpi VDD VDD pfet_03v3 ad=0.1074p pd=1.08u as=0.1074p ps=1.08u w=0.22u l=0.28u
X1359 VSS VSS VSS VSS nfet_03v3 ad=0.2014p pd=1.98u as=0 ps=0 w=0.22u l=0.28u
X1360 VSS VSS VSS VSS nfet_03v3 ad=0.2014p pd=1.98u as=0 ps=0 w=0.22u l=0.28u
X1361 bias_cell_0.Vb bias_cell_0.Vb VSS VSS nfet_03v3 ad=0.61p pd=3.22u as=0.61p ps=3.22u w=1u l=8u
X1362 VSS bias_cell_0.Vb VSS VSS nfet_03v3 ad=0.61p pd=3.22u as=0 ps=0 w=1u l=8u
X1363 VSS VSS VSS VSS nfet_03v3 ad=0.2014p pd=1.98u as=0 ps=0 w=0.22u l=0.28u
X1364 VSS VSS VSS VSS nfet_03v3 ad=0.2014p pd=1.98u as=0 ps=0 w=0.22u l=0.28u
X1365 VSS bias_cell_0.Vb VSS VSS nfet_03v3 ad=0.61p pd=3.22u as=0 ps=0 w=1u l=8u
X1366 VSS bias_cell_0.Vb VSS VSS nfet_03v3 ad=0.61p pd=3.22u as=0 ps=0 w=1u l=8u
X1367 VSS bias_cell_0.Vb VSS VSS nfet_03v3 ad=0.61p pd=3.22u as=0 ps=0 w=1u l=8u
X1368 bias_cell_0.Vlk bias_cell_0.Vlk VSS VSS nfet_03v3 ad=0.35p pd=1.7u as=0.35p ps=1.7u w=1u l=1u
X1369 VSS VSS VSS VSS nfet_03v3 ad=0.2014p pd=1.98u as=0 ps=0 w=0.22u l=0.28u
X1370 VSS VSS VSS VSS nfet_03v3 ad=0.2014p pd=1.98u as=0 ps=0 w=0.22u l=0.28u
X1371 VDD bias_cell_0.VT_dpi bias_cell_0.VT_dpi VDD pfet_03v3 ad=0.1074p pd=1.08u as=0.1074p ps=1.08u w=0.22u l=0.28u
X1372 VSS VSS VSS VSS nfet_03v3 ad=0.2014p pd=1.98u as=0 ps=0 w=0.22u l=0.28u
X1373 VSS VSS VSS VSS nfet_03v3 ad=0.2014p pd=1.98u as=0 ps=0 w=0.22u l=0.28u
X1374 VSS VSS VSS VSS nfet_03v3 ad=0.61p pd=3.22u as=0 ps=0 w=1u l=8u
X1375 VSS VSS VSS VSS nfet_03v3 ad=0.2014p pd=1.98u as=0 ps=0 w=0.22u l=0.28u
X1376 VSS VSS VSS VSS nfet_03v3 ad=0.2014p pd=1.98u as=0 ps=0 w=0.22u l=0.28u
X1377 a_5364_11292# pulse[0] DPI_4.Isum VSS nfet_03v3 ad=0.2014p pd=1.98u as=0.2014p ps=1.98u w=0.22u l=0.28u
X1378 VSS bias_cell_0.Vb VSS VSS nfet_03v3 ad=0.61p pd=3.22u as=0 ps=0 w=1u l=8u
X1379 a_45030_8672# VT a_45268_4332# VSS nfet_03v3 ad=0.2014p pd=1.98u as=0.2014p ps=1.98u w=0.22u l=0.28u
X1380 VSS VSS VSS VSS nfet_03v3 ad=0.2014p pd=1.98u as=0 ps=0 w=0.22u l=0.28u
X1381 VSS VSS VSS VSS nfet_03v3 ad=0.2014p pd=1.98u as=0 ps=0 w=0.22u l=0.28u
X1382 VSS bias_cell_0.Vb VSS VSS nfet_03v3 ad=0.61p pd=3.22u as=0 ps=0 w=1u l=8u
X1383 VSS VSS VSS VSS nfet_03v3 ad=0.61p pd=3.22u as=0 ps=0 w=1u l=1u
X1384 VSS VSS VSS VSS nfet_03v3 ad=0.2014p pd=1.98u as=0 ps=0 w=0.22u l=0.28u
X1385 VSS w[27] a_3364_81516# VSS nfet_03v3 ad=0.2014p pd=1.98u as=0.2014p ps=1.98u w=0.22u l=0.28u
X1386 VSS VSS VSS VSS nfet_03v3 ad=0.2014p pd=1.98u as=0 ps=0 w=0.22u l=0.28u
X1387 a_50306_78896# a_45030_78896# a_48106_74478# VSS nfet_03v3 ad=0.2014p pd=1.98u as=0.2014p ps=1.98u w=0.22u l=0.28u
X1388 VSS w[15] a_5364_46404# VSS nfet_03v3 ad=0.2014p pd=1.98u as=0.2014p ps=1.98u w=0.22u l=0.28u
X1389 VSS VSS VSS VSS nfet_03v3 ad=0.2014p pd=1.98u as=0 ps=0 w=0.22u l=0.28u
X1390 VSS VSS VSS VSS nfet_03v3 ad=0.61p pd=3.22u as=0 ps=0 w=1u l=1u
X1391 VSS VSS VSS VSS nfet_03v3 ad=0.2014p pd=1.98u as=0 ps=0 w=0.22u l=0.28u
X1392 VSS VSS VSS VSS nfet_03v3 ad=0.2014p pd=1.98u as=0 ps=0 w=0.22u l=0.28u
X1393 VSS bias_cell_0.Vb VSS VSS nfet_03v3 ad=0.61p pd=3.22u as=0 ps=0 w=1u l=8u
C0 pulse[1] w[27] 0.04779f
C1 VDD DPI_inh_0.DPI_sized_0.Isyn 0.4276f
C2 w[29] a_3364_92980# 0.01696f
C3 a_48826_16078# neuron_sized_3.VMEM 0.01311f
C4 neuron_sized_4.VMEM bias_cell_0.Vlk 0.35388f
C5 bias_cell_0.VIp DPI_inh_0.Iout 0.22855f
C6 a_45030_55608# VT 0.24678f
C7 bias_cell_0.VT_inh bias_cell_0.Vamp_bias 0.05504f
C8 DPI_2.Isum s[1] 7.21473f
C9 bias_cell_0.VIp a_45030_8672# 0.05738f
C10 bias_cell_0.Vamp_bias a_44260_8656# 0.12068f
C11 DPI_1.Isum VDD 0.11203f
C12 bias_cell_0.Vthr spike[1] 0.2223f
C13 bias_cell_0.VK a_44260_78880# 0.02735f
C14 w[29] DPI_1.Isum 0.09558f
C15 bias_cell_0.VK a_43986_4254# 0.23589f
C16 DPI_inh_0.Isum w[30] 0.05737f
C17 bias_cell_0.VIp a_45268_27980# 0.15156f
C18 DPI_4.Isum w[6] 0.04779f
C19 w[9] w[8] 15.2966f
C20 DPI_4.Isum w[27] 0.04779f
C21 DPI_1.Isum w[24] 0.09558f
C22 a_48826_4254# a_50306_8672# 0.33343f
C23 VDD bias_cell_0.VKup 12.7978f
C24 w[18] spike[1] 0.04779f
C25 DPI_inh_0.DPI_sized_0.Isyn a_34584_81836# 0.64551f
C26 bias_cell_0.VIp a_48106_4254# 0.26988f
C27 w[25] DPI_inh_0.Isum 0.02869f
C28 DPI_2.Isum w[16] 0.09558f
C29 VDD a_44260_20480# 1.58946f
C30 w[2] w[1] 5.7614f
C31 a_48106_74478# spike[4] 0.05233f
C32 w[9] w[11] 1.52394f
C33 DPI_4.Isum a_5364_11292# 0.36625f
C34 w[9] VDD 0.10127f
C35 a_43986_74478# DPI_inh_0.Iout 0.27007f
C36 a_43278_32242# a_46472_32242# 0.22613f
C37 bias_cell_0.Vamp_bias VT 44.3464f
C38 bias_cell_0.VT_inh spike[3] 0.0151f
C39 DPI_1.Isum w[21] 0.09593f
C40 bias_cell_0.VIp a_2244_98592# 0.43727f
C41 bias_cell_0.Vthr bias_cell_0.Vb 0.064f
C42 bias_cell_0.VT_dpi bias_cell_0.VT_inh 5.87131f
C43 s[1] DPI_inh_0.Isum 2.88492f
C44 bias_cell_0.VIp VDD 1.04537f
C45 bias_cell_0.VKdn neuron_sized_2.VMEM 0.24119f
C46 w[27] spike[0] 0.18905f
C47 neuron_sized_4.VMEM a_45030_8672# 0.35423f
C48 w[7] w[5] 1.52394f
C49 w[12] w[11] 14.4528f
C50 VDD w[30] 0.10124f
C51 w[12] VDD 0.10124f
C52 w[17] w[19] 1.52394f
C53 DPI_1.Isum spike[2] 0.13134f
C54 a_5364_58228# w[18] 0.0335f
C55 a_50306_55608# spike[3] 1.46926f
C56 VT spike[0] 0.0792f
C57 a_43278_55530# a_46472_55530# 0.22613f
C58 DPI_0.Isum DPI_inh_0.Iout 0.1429f
C59 w[29] w[30] 40.1649f
C60 DPI_2.Isum a_34406_27492# 0.65893f
C61 VDD a_46472_20418# 3.99075f
C62 w[25] VDD 0.10128f
C63 w[22] pulse[1] 0.04779f
C64 DAC_signed_0.DAC_binary_0.Isum a_23094_91304# 0.02156f
C65 spike[3] w[27] 0.01489f
C66 a_46472_78818# spike[4] 0.16612f
C67 a_43986_16078# a_44260_20480# 0.61849f
C68 bias_cell_0.VKup a_43278_8594# 0.15534f
C69 a_45268_74556# a_45030_78896# 0.09185f
C70 DPI_inh_0.Isum DPI_0.Isum 10.1727f
C71 neuron_sized_4.VMEM a_48106_4254# 0.01311f
C72 bias_cell_0.VKup spike[2] 0.01309f
C73 bias_cell_0.VT_inh Iref 0.39913f
C74 VDD w[0] 0.15379f
C75 VT spike[3] 0.07958f
C76 neuron_sized_1.VMEM bias_cell_0.VK 0.37062f
C77 DPI_3.Isum bias_cell_0.Vthr 1.271f
C78 pulse[0] w[18] 0.04779f
C79 w[25] w[24] 35.2235f
C80 bias_cell_0.Vthr a_34406_74068# 0.23618f
C81 s[1] VDD 0.35234f
C82 bias_cell_0.VIp a_43986_27902# 0.08414f
C83 bias_cell_0.VKdn a_45030_78896# 0.05334f
C84 a_43986_16078# bias_cell_0.VIp 0.08414f
C85 w[16] w[15] 18.9541f
C86 pulse[0] spike[1] 0.1349f
C87 bias_cell_0.VKup a_44260_78880# 0.1559f
C88 DPI_4.Isum w[22] 0.04779f
C89 DPI_3.Isum w[18] 0.04779f
C90 w[29] s[1] 0.03824f
C91 a_44260_32304# a_45268_27980# 0.12841f
C92 neuron_sized_4.VMEM VDD 5.90387f
C93 a_3364_81516# w[27] 0.06768f
C94 bias_cell_0.VIp spike[2] 0.20429f
C95 neuron_sized_1.VMEM a_45268_51268# 0.23666f
C96 bias_cell_0.VKup a_45030_32320# 0.13361f
C97 bias_cell_0.VKup a_43278_55530# 0.15534f
C98 spike[2] w[30] 0.04797f
C99 a_34406_50780# bias_cell_0.VT_dpi 1.57349f
C100 DPI_3.Isum spike[1] 0.07106f
C101 bias_cell_0.Vamp_bias spike[4] 0.17989f
C102 bias_cell_0.VNA bias_cell_0.Vamp_bias 0.80447f
C103 a_45030_20496# bias_cell_0.VKdn 0.05334f
C104 a_50306_20496# a_43278_20418# 0.39394f
C105 DPI_0.Isum VDD 0.11921f
C106 w[16] VDD 0.10124f
C107 s[0] spike[1] 0.86828f
C108 VDD a_50306_32320# 2.72209f
C109 bias_cell_0.VIp a_44260_78880# 0.11998f
C110 w[25] spike[2] 0.39304f
C111 a_44260_55592# VT 0.64213f
C112 s[1] a_34584_81836# 0.01083f
C113 w[29] DPI_0.Isum 0.07647f
C114 neuron_sized_1.VMEM a_46472_55530# 0.01577f
C115 bias_cell_0.VK bias_cell_0.VKdn 0.25937f
C116 bias_cell_0.VIp a_43986_4254# 0.08414f
C117 w[22] spike[0] 0.09558f
C118 DPI_0.Isum w[24] 0.05102f
C119 VT neuron_sized_3.VMEM 0.39927f
C120 bias_cell_0.VIp a_45030_32320# 0.05738f
C121 bias_cell_0.VK a_43986_51190# 0.23589f
C122 a_44260_32304# VDD 1.58946f
C123 a_43278_32242# neuron_sized_2.VMEM 0.47933f
C124 bias_cell_0.VNA a_43278_20418# 0.49118f
C125 DPI_4.Isum pulse[1] 0.0572f
C126 s[1] spike[2] 0.53868f
C127 a_45030_55608# bias_cell_0.Vamp_bias 0.13368f
C128 a_50306_78896# DPI_inh_0.Iout 0.03443f
C129 neuron_sized_4.VMEM a_43278_8594# 0.47933f
C130 DPI_0.Isum a_34584_81836# 0.01316f
C131 bias_cell_0.Vlk VT 0.2952f
C132 a_34406_27492# VDD 7.49484f
C133 spike[4] spike[3] 0.50608f
C134 a_45268_51268# a_43986_51190# 1.24342f
C135 pulse[1] w[13] 0.04779f
C136 a_43986_74478# a_44260_78880# 0.61849f
C137 DPI_2.Isum w[27] 0.09558f
C138 bias_cell_0.VT_dpi bias_cell_0.VNA 1.18111f
C139 a_50306_32320# a_43986_27902# 0.0934f
C140 w[20] w[22] 0.73399f
C141 a_43986_16078# a_48826_16078# 0.54225f
C142 a_50306_20496# a_48106_16078# 0.0395f
C143 a_5364_23116# w[6] 0.0335f
C144 neuron_sized_1.VMEM bias_cell_0.VKup 0.43145f
C145 DPI_0.Isum spike[2] 0.05928f
C146 pulse[0] w[3] 0.05862f
C147 w[14] spike[1] 0.0624f
C148 pulse[1] spike[0] 0.66288f
C149 a_44260_32304# a_43986_27902# 0.61849f
C150 a_45030_8672# a_44260_8656# 0.36022f
C151 a_50306_32320# spike[2] 1.46926f
C152 w[1] w[0] 5.55135f
C153 neuron_sized_4.VMEM a_43986_4254# 0.27007f
C154 DPI_inh_0.Isum bias_cell_0.VT_inh 0.04459f
C155 w[17] w[18] 25.1106f
C156 a_50306_20496# neuron_sized_3.VMEM 0.03443f
C157 DPI_4.Isum w[13] 0.04779f
C158 a_45030_55608# spike[3] 0.34277f
C159 a_43278_78818# DPI_inh_0.Iout 0.47933f
C160 DPI_3.Isum s[0] 0.05542f
C161 bias_cell_0.VNA Iref 0.93992f
C162 w[17] spike[1] 0.04779f
C163 neuron_sized_1.VMEM bias_cell_0.VIp 0.22734f
C164 DPI_1.Isum w[19] 0.04779f
C165 w[31] bias_cell_0.Vthr 0.60386f
C166 a_50306_78896# VDD 2.72209f
C167 DPI_4.Isum spike[0] 0.06677f
C168 a_50306_32320# a_45030_32320# 0.70062f
C169 VDD a_23094_79840# 0.13775f
C170 w[9] w[10] 15.5067f
C171 w[28] spike[1] 0.37996f
C172 a_48826_27902# a_43986_27902# 0.54225f
C173 bias_cell_0.VNA neuron_sized_3.VMEM 0.96558f
C174 VT DPI_inh_0.Iout 0.31865f
C175 w[26] DPI_1.Isum 0.09558f
C176 w[20] pulse[1] 0.04779f
C177 bias_cell_0.Vamp_bias spike[0] 0.17989f
C178 DPI_inh_0.Isum w[27] 0.02869f
C179 a_45268_27980# a_48106_27902# 0.02025f
C180 bias_cell_0.VKup bias_cell_0.VKdn 35.2953f
C181 VT a_45030_8672# 0.24678f
C182 a_44260_32304# a_45030_32320# 0.36022f
C183 bias_cell_0.VKdn a_44260_20480# 0.11969f
C184 w[13] spike[0] 0.04779f
C185 VDD bias_cell_0.VT_inh 11.2528f
C186 a_48826_27902# spike[2] 0.14308f
C187 bias_cell_0.VIp a_45268_74556# 0.15156f
C188 DPI_4.Isum spike[3] 0.10174f
C189 VDD a_44260_8656# 1.58946f
C190 VT a_45268_27980# 0.51443f
C191 w[31] spike[1] 1.02673f
C192 bias_cell_0.VNA bias_cell_0.Vlk 35.5082f
C193 bias_cell_0.VT_dpi DPI_4.Isum 0.02996f
C194 w[17] a_5364_58228# 0.01696f
C195 a_48826_74478# DPI_inh_0.Iout 0.01311f
C196 w[14] pulse[0] 0.04779f
C197 a_44260_55592# a_45030_55608# 0.36022f
C198 bias_cell_0.Vamp_bias spike[3] 0.17989f
C199 bias_cell_0.VIp bias_cell_0.VKdn 33.7095f
C200 DPI_4.Isum w[20] 0.04779f
C201 bias_cell_0.VT_dpi bias_cell_0.Vamp_bias 0.0547f
C202 a_45268_16156# spike[1] 0.11297f
C203 DPI_2.Isum w[22] 0.09558f
C204 VDD a_50306_55608# 2.72209f
C205 VDD a_43278_78818# 2.21359f
C206 w[23] spike[1] 0.10641f
C207 DPI_3.Isum w[14] 0.04779f
C208 bias_cell_0.VIp a_43986_51190# 0.08414f
C209 VDD w[6] 0.10124f
C210 a_48826_27902# a_45030_32320# 0.04671f
C211 VDD w[27] 0.22829f
C212 w[17] pulse[0] 0.04779f
C213 spike[3] spike[0] 6.39642f
C214 bias_cell_0.VT_inh a_34584_81836# 1.51222f
C215 a_46472_32242# neuron_sized_2.VMEM 0.01577f
C216 a_45268_51268# a_48106_51190# 0.02025f
C217 a_45268_74556# a_43986_74478# 1.24342f
C218 VDD VT 0.2377f
C219 a_45030_20496# spike[1] 0.34277f
C220 w[28] pulse[0] 0.04779f
C221 DPI_3.Isum w[17] 0.04779f
C222 w[20] spike[0] 0.09558f
C223 bias_cell_0.Vamp_bias Iref 0.09525f
C224 w[25] w[26] 35.4336f
C225 a_44260_55592# bias_cell_0.Vamp_bias 0.12068f
C226 a_44260_8656# a_43278_8594# 0.27251f
C227 a_48106_74478# DPI_inh_0.Iout 0.01311f
C228 a_43986_74478# bias_cell_0.VKdn 0.04997f
C229 pulse[0] w[7] 0.04779f
C230 DPI_3.Isum w[28] 0.04779f
C231 bias_cell_0.VT_dpi spike[3] 0.14625f
C232 a_34406_50780# VDD 7.49484f
C233 bias_cell_0.Vamp_bias neuron_sized_3.VMEM 0.24174f
C234 bias_cell_0.VNA DPI_inh_0.Iout 2.08712f
C235 DPI_inh_0.Iout spike[4] 0.06805f
C236 w[31] pulse[0] 4.96127f
C237 bias_cell_0.Vthr a_34406_15668# 0.23618f
C238 w[28] s[0] 0.03824f
C239 a_48106_27902# a_43986_27902# 1.21169f
C240 neuron_sized_4.VMEM bias_cell_0.VKdn 0.17963f
C241 s[1] a_23094_91304# 0.72184f
C242 bias_cell_0.VIp a_45268_4332# 0.15156f
C243 DPI_3.Isum w[7] 0.04779f
C244 a_43278_32242# bias_cell_0.VKup 0.15534f
C245 a_48106_27902# spike[2] 0.05233f
C246 VT a_43986_27902# 0.15694f
C247 pulse[0] w[23] 0.04779f
C248 a_43986_4254# a_44260_8656# 0.61849f
C249 a_50306_8672# a_46472_8594# 0.43603f
C250 DPI_3.Isum w[31] 0.05428f
C251 a_43986_16078# VT 0.15694f
C252 bias_cell_0.Vlk bias_cell_0.Vamp_bias 0.89548f
C253 spike[2] w[27] 0.0587f
C254 a_43278_20418# neuron_sized_3.VMEM 0.47933f
C255 bias_cell_0.VK bias_cell_0.Vb 0.42352f
C256 w[31] s[0] 0.04953f
C257 bias_cell_0.Vthr DPI_1.Isum 2.892f
C258 a_48826_16078# bias_cell_0.VKdn 0.30387f
C259 a_50306_20496# VDD 2.72209f
C260 a_44260_78880# a_43278_78818# 0.27251f
C261 a_46472_78818# DPI_inh_0.Iout 0.01577f
C262 DPI_0.Isum a_23094_91304# 0.17374f
C263 VT spike[2] 0.07981f
C264 a_48826_51190# a_50306_55608# 0.33343f
C265 DPI_3.Isum w[23] 0.04779f
C266 bias_cell_0.VT_dpi Iref 0.6935f
C267 a_44260_32304# bias_cell_0.VKdn 0.11969f
C268 w[26] DPI_0.Isum 0.03824f
C269 neuron_sized_4.VMEM a_48826_4254# 0.01311f
C270 a_50306_55608# a_43278_55530# 0.39394f
C271 DPI_1.Isum w[18] 0.04784f
C272 w[2] pulse[0] 0.0624f
C273 bias_cell_0.VNA a_2244_98592# 0.01697f
C274 a_34406_3844# s[1] 0.01244f
C275 VDD w[22] 0.10124f
C276 bias_cell_0.Vthr bias_cell_0.VKup 0.15237f
C277 a_48106_27902# a_45030_32320# 0.2196f
C278 DPI_2.Isum w[13] 0.09593f
C279 VT a_44260_78880# 0.64213f
C280 bias_cell_0.VNA VDD 9.9497f
C281 VDD spike[4] 3.67025f
C282 DPI_1.Isum spike[1] 0.1792f
C283 w[4] w[6] 0.73399f
C284 VT a_43986_4254# 0.15694f
C285 neuron_sized_4.VMEM a_34406_3844# 0.90462f
C286 VT a_45030_32320# 0.24678f
C287 w[2] w[3] 6.03387f
C288 DPI_2.Isum spike[0] 0.1397f
C289 neuron_sized_4.VMEM a_45268_4332# 0.23666f
C290 w[15] pulse[1] 0.04779f
C291 bias_cell_0.VIp a_48106_51190# 0.26988f
C292 bias_cell_0.VKdn a_48826_27902# 0.30387f
C293 a_50306_20496# a_43986_16078# 0.0934f
C294 pulse[1] w[8] 0.04779f
C295 a_48106_16078# neuron_sized_3.VMEM 0.01311f
C296 bias_cell_0.VKup spike[1] 0.01309f
C297 w[1] a_5364_11292# 0.01696f
C298 bias_cell_0.Vamp_bias DPI_inh_0.Iout 0.27758f
C299 bias_cell_0.Vthr w[30] 0.01574f
C300 bias_cell_0.Vamp_bias a_45030_8672# 0.13368f
C301 DPI_2.Isum spike[3] 0.22581f
C302 w[21] w[22] 29.8419f
C303 VDD a_46472_78818# 3.99075f
C304 VDD a_45030_55608# 4.15363f
C305 pulse[1] w[11] 0.04779f
C306 DPI_2.Isum bias_cell_0.VT_dpi 0.09043f
C307 a_5364_58228# DPI_1.Isum 0.36625f
C308 VDD pulse[1] 0.1464f
C309 bias_cell_0.Vamp_bias a_45268_27980# 0.67458f
C310 w[15] DPI_4.Isum 0.04779f
C311 DPI_2.Isum w[20] 0.09558f
C312 w[29] pulse[1] 0.04779f
C313 bias_cell_0.VIp spike[1] 0.20429f
C314 DPI_4.Isum w[8] 0.04779f
C315 bias_cell_0.VNA a_43278_8594# 0.49118f
C316 a_45030_8672# spike[0] 0.34277f
C317 neuron_sized_1.VMEM a_50306_55608# 0.03443f
C318 bias_cell_0.Vlk Iref 0.05154f
C319 pulse[1] w[24] 0.04779f
C320 w[30] spike[1] 0.56366f
C321 DPI_3.Isum a_34406_15668# 0.65893f
C322 a_5364_69692# w[23] 0.06768f
C323 spike[2] spike[4] 0.75071f
C324 w[12] spike[1] 1.23291f
C325 a_43278_32242# a_50306_32320# 0.39394f
C326 bias_cell_0.Vb bias_cell_0.VKup 0.08637f
C327 s[1] bias_cell_0.Vthr 2.2142f
C328 w[15] w[13] 1.52394f
C329 bias_cell_0.Vlk neuron_sized_3.VMEM 0.40379f
C330 DPI_4.Isum w[11] 0.04779f
C331 DPI_4.Isum VDD 0.11437f
C332 a_46472_20418# spike[1] 0.16612f
C333 w[25] spike[1] 0.2497f
C334 a_2244_98592# bias_cell_0.Vamp_bias 0.77275f
C335 a_44260_32304# a_43278_32242# 0.27251f
C336 neuron_sized_1.VMEM VT 0.39927f
C337 w[14] a_5364_46404# 0.0335f
C338 bias_cell_0.VT_dpi DPI_inh_0.Iout 0.11749f
C339 w[15] spike[0] 0.04779f
C340 w[21] pulse[1] 0.04779f
C341 a_48106_4254# spike[0] 0.05233f
C342 VDD bias_cell_0.Vamp_bias 0.32943f
C343 w[29] DPI_4.Isum 0.04779f
C344 bias_cell_0.VKdn a_44260_8656# 0.11969f
C345 DPI_inh_0.Isum spike[3] 0.13029f
C346 w[6] w[5] 10.634f
C347 bias_cell_0.VKup a_46472_32242# 0.35765f
C348 w[8] spike[0] 1.00283f
C349 DPI_4.Isum w[24] 0.04779f
C350 VDD w[13] 0.10124f
C351 bias_cell_0.VNA a_43278_55530# 0.49118f
C352 DPI_1.Isum s[0] 0.10964f
C353 bias_cell_0.VT_dpi DPI_inh_0.Isum 0.06189f
C354 bias_cell_0.VIp bias_cell_0.Vb 0.11336f
C355 DPI_0.Isum bias_cell_0.Vthr 1.08047f
C356 s[1] spike[1] 0.66616f
C357 w[9] pulse[0] 0.04779f
C358 a_34406_50780# neuron_sized_1.VMEM 0.90462f
C359 pulse[1] spike[2] 3.12016f
C360 bias_cell_0.VKdn a_43278_78818# 3.14096f
C361 DPI_2.Isum a_5364_34940# 0.36625f
C362 bias_cell_0.VK neuron_sized_2.VMEM 0.37062f
C363 w[11] spike[0] 0.05862f
C364 a_45268_74556# VT 0.51443f
C365 VDD spike[0] 5.13693f
C366 bias_cell_0.VKdn a_48106_27902# 0.22172f
C367 a_43278_32242# a_48826_27902# 0.06007f
C368 VDD a_43278_20418# 2.21359f
C369 a_50306_55608# a_43986_51190# 0.0934f
C370 DPI_4.Isum w[21] 0.04779f
C371 w[16] w[18] 0.73399f
C372 DPI_3.Isum w[9] 0.04779f
C373 w[29] spike[0] 0.25613f
C374 a_48826_51190# a_45030_55608# 0.04671f
C375 pulse[0] w[30] 0.04779f
C376 w[12] pulse[0] 0.04779f
C377 bias_cell_0.VKdn VT 0.18185f
C378 w[24] spike[0] 0.14479f
C379 VDD spike[3] 3.61819f
C380 a_45030_55608# a_43278_55530# 0.09781f
C381 bias_cell_0.Vamp_bias a_43986_27902# 0.04253f
C382 w[16] spike[1] 0.04779f
C383 a_43986_16078# bias_cell_0.Vamp_bias 0.04253f
C384 DPI_4.Isum spike[2] 0.06385f
C385 w[26] w[27] 35.7061f
C386 a_48826_16078# spike[1] 0.14308f
C387 VT a_43986_51190# 0.15694f
C388 w[25] pulse[0] 0.04779f
C389 bias_cell_0.VT_dpi VDD 16.752f
C390 w[29] spike[3] 0.43545f
C391 a_45268_16156# a_45030_20496# 0.09185f
C392 a_34406_27492# bias_cell_0.Vthr 0.23618f
C393 w[4] pulse[1] 0.77274f
C394 DPI_3.Isum w[30] 0.04783f
C395 DPI_3.Isum w[12] 0.04779f
C396 bias_cell_0.Vamp_bias spike[2] 0.17989f
C397 s[0] w[30] 0.03824f
C398 VDD w[20] 0.10124f
C399 a_45268_4332# a_44260_8656# 0.12841f
C400 w[21] spike[0] 0.09558f
C401 a_48826_74478# bias_cell_0.VKdn 0.30387f
C402 pulse[0] w[0] 0.54687f
C403 bias_cell_0.Vlk DPI_inh_0.Iout 0.40617f
C404 DPI_3.Isum w[25] 0.04779f
C405 neuron_sized_1.VMEM bias_cell_0.VNA 0.96558f
C406 w[25] s[0] 0.03824f
C407 bias_cell_0.Vamp_bias a_44260_78880# 0.12068f
C408 a_43278_8594# spike[0] 0.14379f
C409 a_3364_92980# DAC_signed_0.DAC_binary_0.Isum 0.36625f
C410 a_5364_69692# DPI_1.Isum 0.36625f
C411 a_2244_98592# Iref 4.21035f
C412 bias_cell_0.Vamp_bias a_43986_4254# 0.04253f
C413 DPI_0.Isum DAC_signed_1.DAC_binary_0.Isum 0.0791f
C414 spike[2] spike[0] 6.87524f
C415 VDD Iref 1.90288f
C416 DPI_4.Isum w[4] 0.04779f
C417 bias_cell_0.Vamp_bias a_45030_32320# 0.13368f
C418 w[17] DPI_1.Isum 0.04814f
C419 VDD a_44260_55592# 1.58946f
C420 bias_cell_0.VT_dpi a_34584_81836# 0.07818f
C421 DPI_4.Isum w[1] 0.04814f
C422 DPI_3.Isum s[1] 2.66573f
C423 a_48106_74478# a_45268_74556# 0.02025f
C424 s[1] a_34406_74068# 0.01083f
C425 s[1] s[0] 31.1565f
C426 VDD neuron_sized_3.VMEM 5.90387f
C427 w[21] w[20] 29.6319f
C428 w[28] DPI_1.Isum 0.09558f
C429 a_45268_4332# VT 0.51443f
C430 a_45268_74556# spike[4] 0.11297f
C431 w[31] a_3364_92980# 0.06768f
C432 spike[2] spike[3] 3.74058f
C433 w[16] pulse[0] 0.04779f
C434 a_43986_4254# spike[0] 0.24447f
C435 neuron_sized_1.VMEM a_45030_55608# 0.35423f
C436 a_50306_32320# a_46472_32242# 0.43603f
C437 a_48106_74478# bias_cell_0.VKdn 0.22172f
C438 a_5364_34940# w[11] 0.06768f
C439 bias_cell_0.VKup neuron_sized_2.VMEM 0.43145f
C440 bias_cell_0.Vlk a_2244_98592# 0.36863f
C441 DPI_2.Isum w[15] 0.09558f
C442 bias_cell_0.VNA bias_cell_0.VKdn 8.98734f
C443 bias_cell_0.VKdn spike[4] 0.11443f
C444 w[14] w[12] 0.73399f
C445 bias_cell_0.Vthr bias_cell_0.VT_inh 0.36878f
C446 DPI_2.Isum w[8] 0.06067f
C447 DPI_3.Isum w[16] 0.04779f
C448 DPI_0.Isum a_34406_74068# 0.65893f
C449 bias_cell_0.Vlk VDD 1.28343f
C450 w[31] DPI_1.Isum 0.11822f
C451 bias_cell_0.VKup a_46472_8594# 0.35765f
C452 neuron_sized_4.VMEM a_50306_8672# 0.03443f
C453 a_43986_16078# a_48106_16078# 1.21169f
C454 a_48826_51190# spike[3] 0.14308f
C455 DPI_0.Isum s[0] 0.09212f
C456 a_43278_55530# spike[3] 0.14379f
C457 pulse[1] w[5] 0.39304f
C458 a_50306_55608# a_48106_51190# 0.0395f
C459 DPI_2.Isum w[11] 0.04779f
C460 bias_cell_0.VIp neuron_sized_2.VMEM 0.22734f
C461 DPI_1.Isum w[23] 0.09558f
C462 DPI_2.Isum VDD 0.11203f
C463 w[10] pulse[1] 0.04779f
C464 a_43986_16078# neuron_sized_3.VMEM 0.27007f
C465 w[31] bias_cell_0.VKup 0.01616f
C466 DPI_2.Isum w[29] 0.09558f
C467 a_45030_55608# bias_cell_0.VKdn 0.05334f
C468 w[28] w[30] 0.73399f
C469 neuron_sized_1.VMEM bias_cell_0.Vamp_bias 0.24174f
C470 bias_cell_0.VKup a_45030_78896# 0.13361f
C471 DPI_2.Isum w[24] 0.09558f
C472 a_48106_4254# a_45030_8672# 0.2196f
C473 a_45268_16156# a_44260_20480# 0.12841f
C474 a_45030_55608# a_43986_51190# 0.09251f
C475 DPI_4.Isum w[5] 0.04779f
C476 w[19] pulse[1] 0.04779f
C477 w[10] DPI_4.Isum 0.04779f
C478 a_23094_79840# DAC_signed_1.DAC_binary_0.Isum 0.02156f
C479 a_44260_55592# a_43278_55530# 0.27251f
C480 w[26] pulse[1] 0.04779f
C481 VDD DPI_inh_0.Iout 6.37524f
C482 w[31] w[30] 40.4374f
C483 DPI_2.Isum w[21] 0.09558f
C484 a_45030_20496# bias_cell_0.VKup 0.13361f
C485 a_45268_74556# bias_cell_0.Vamp_bias 0.67458f
C486 bias_cell_0.VIp a_45030_78896# 0.05738f
C487 w[27] spike[1] 0.32355f
C488 VDD a_45030_8672# 4.15363f
C489 a_45268_16156# bias_cell_0.VIp 0.15156f
C490 a_45030_20496# a_44260_20480# 0.36022f
C491 a_34406_50780# bias_cell_0.Vthr 0.23618f
C492 bias_cell_0.VK bias_cell_0.VKup 0.18707f
C493 bias_cell_0.Vb bias_cell_0.VT_inh 0.06425f
C494 w[28] s[1] 0.05102f
C495 VT spike[1] 0.07549f
C496 DPI_inh_0.Isum VDD 0.10325f
C497 bias_cell_0.VK a_44260_20480# 0.02735f
C498 neuron_sized_1.VMEM spike[3] 0.06805f
C499 DPI_2.Isum spike[2] 0.13134f
C500 DPI_4.Isum w[19] 0.04779f
C501 bias_cell_0.VKdn bias_cell_0.Vamp_bias 35.6387f
C502 w[29] DPI_inh_0.Isum 0.05737f
C503 w[10] spike[0] 0.0624f
C504 neuron_sized_4.VMEM a_46472_8594# 0.01577f
C505 a_43278_32242# bias_cell_0.VNA 0.49118f
C506 w[26] DPI_4.Isum 0.04779f
C507 a_45030_20496# bias_cell_0.VIp 0.05738f
C508 w[15] VDD 0.10124f
C509 w[16] w[17] 24.9006f
C510 DPI_inh_0.Isum w[24] 0.04147f
C511 bias_cell_0.Vamp_bias a_43986_51190# 0.04253f
C512 s[1] w[31] 0.48269f
C513 VDD w[8] 0.10124f
C514 a_50306_32320# neuron_sized_2.VMEM 0.03443f
C515 bias_cell_0.VIp bias_cell_0.VK 44.3696f
C516 DPI_0.Isum DAC_signed_0.DAC_binary_0.Isum 0.0791f
C517 w[28] DPI_0.Isum 0.08925f
C518 a_23094_79840# s[0] 0.72184f
C519 bias_cell_0.VKdn spike[0] 0.11443f
C520 a_43986_74478# a_45030_78896# 0.09251f
C521 a_43278_20418# bias_cell_0.VKdn 3.14096f
C522 a_45030_20496# a_46472_20418# 0.05399f
C523 VDD a_2244_98592# 36.0299f
C524 DPI_inh_0.Isum a_34584_81836# 0.92125f
C525 a_44260_32304# neuron_sized_2.VMEM 1.43869f
C526 w[19] spike[0] 0.10641f
C527 VDD w[11] 0.15576f
C528 a_45030_8672# a_43278_8594# 0.09781f
C529 bias_cell_0.VKup a_46472_55530# 0.35765f
C530 pulse[0] w[6] 0.04779f
C531 w[26] spike[0] 0.16956f
C532 a_45268_27980# a_43986_27902# 1.24342f
C533 bias_cell_0.VNA bias_cell_0.Vthr 0.78386f
C534 a_34406_3844# DPI_4.Isum 0.66222f
C535 neuron_sized_1.VMEM a_44260_55592# 1.43869f
C536 a_45268_51268# bias_cell_0.VIp 0.15156f
C537 w[31] DPI_0.Isum 0.1152f
C538 bias_cell_0.VKdn spike[3] 0.11443f
C539 pulse[0] w[27] 0.04779f
C540 w[29] VDD 0.10124f
C541 w[2] w[0] 0.73399f
C542 a_50306_20496# spike[1] 1.46926f
C543 VDD w[24] 0.10124f
C544 DPI_inh_0.Isum spike[2] 0.04949f
C545 a_43986_51190# spike[3] 0.24447f
C546 a_34406_27492# neuron_sized_2.VMEM 0.90462f
C547 a_44260_78880# DPI_inh_0.Iout 1.43869f
C548 a_45268_27980# spike[2] 0.11297f
C549 bias_cell_0.VK a_43986_74478# 0.23589f
C550 DPI_3.Isum w[6] 0.04784f
C551 bias_cell_0.Vamp_bias a_45268_4332# 0.67458f
C552 DPI_3.Isum w[27] 0.04779f
C553 a_48826_4254# spike[0] 0.14308f
C554 a_48826_27902# neuron_sized_2.VMEM 0.01311f
C555 a_43986_4254# a_45030_8672# 0.09251f
C556 w[22] spike[1] 0.11018f
C557 s[0] w[27] 0.03824f
C558 w[19] w[20] 23.5966f
C559 a_45030_55608# a_48106_51190# 0.2196f
C560 VDD a_34584_81836# 7.70171f
C561 neuron_sized_4.VMEM bias_cell_0.VK 0.31832f
C562 a_3364_92980# w[30] 0.0335f
C563 VDD w[21] 0.10124f
C564 spike[4] spike[1] 5.16991f
C565 a_34406_3844# spike[0] 0.01082f
C566 w[3] a_5364_11292# 0.06768f
C567 neuron_sized_1.VMEM bias_cell_0.Vlk 0.40379f
C568 bias_cell_0.VKdn a_48106_16078# 0.22172f
C569 a_45268_27980# a_45030_32320# 0.09185f
C570 a_48826_16078# a_45030_20496# 0.04671f
C571 a_45268_4332# spike[0] 0.11297f
C572 VDD a_43278_8594# 2.21359f
C573 a_44260_55592# bias_cell_0.VKdn 0.11969f
C574 bias_cell_0.VKup a_44260_20480# 0.1559f
C575 VDD spike[2] 3.79421f
C576 a_48106_4254# a_43986_4254# 1.21169f
C577 w[26] a_3364_81516# 0.0335f
C578 DPI_1.Isum w[30] 0.09561f
C579 bias_cell_0.VKdn neuron_sized_3.VMEM 0.24119f
C580 a_44260_55592# a_43986_51190# 0.61849f
C581 a_34406_3844# spike[3] 0.1436f
C582 w[10] a_5364_34940# 0.0335f
C583 pulse[1] w[18] 0.04779f
C584 w[29] spike[2] 0.04792f
C585 a_34406_3844# bias_cell_0.VT_dpi 1.51616f
C586 w[25] DPI_1.Isum 0.09558f
C587 s[1] a_34406_15668# 0.01083f
C588 a_44260_32304# bias_cell_0.VK 0.02735f
C589 spike[2] w[24] 2.64218f
C590 bias_cell_0.VIp bias_cell_0.VKup 35.2263f
C591 VDD a_44260_78880# 1.58946f
C592 pulse[1] spike[1] 0.59747f
C593 DPI_4.Isum bias_cell_0.Vthr 1.11694f
C594 bias_cell_0.VNA bias_cell_0.Vb 0.06456f
C595 bias_cell_0.VIp a_44260_20480# 0.11998f
C596 bias_cell_0.Vlk bias_cell_0.VKdn 10.4661f
C597 VDD a_45030_32320# 4.15363f
C598 DPI_2.Isum w[10] 0.04784f
C599 bias_cell_0.Vthr bias_cell_0.Vamp_bias 0.05453f
C600 VDD a_43278_55530# 2.21359f
C601 a_5364_23116# w[5] 0.01696f
C602 pulse[0] w[22] 0.04779f
C603 bias_cell_0.VKup a_46472_20418# 0.35765f
C604 VDD w[4] 0.10124f
C605 s[1] DPI_1.Isum 7.21473f
C606 DPI_4.Isum w[18] 0.04779f
C607 VDD w[1] 0.10124f
C608 spike[2] a_43986_27902# 0.24447f
C609 DPI_4.Isum spike[1] 0.07092f
C610 a_50306_78896# a_45030_78896# 0.70062f
C611 DPI_3.Isum w[22] 0.04779f
C612 DPI_2.Isum w[19] 0.09558f
C613 a_48106_27902# neuron_sized_2.VMEM 0.01311f
C614 bias_cell_0.Vamp_bias spike[1] 0.17989f
C615 DPI_2.Isum w[26] 0.09558f
C616 spike[3] a_48106_51190# 0.05233f
C617 a_45268_74556# DPI_inh_0.Iout 0.23666f
C618 w[16] DPI_1.Isum 0.06067f
C619 w[13] spike[1] 0.39304f
C620 w[28] w[27] 32.7404f
C621 VT neuron_sized_2.VMEM 0.39927f
C622 w[18] spike[0] 0.11018f
C623 neuron_sized_4.VMEM bias_cell_0.VKup 0.3696f
C624 a_43986_27902# a_45030_32320# 0.09251f
C625 bias_cell_0.Vthr spike[3] 0.24415f
C626 w[6] w[7] 10.9065f
C627 pulse[0] pulse[1] 4.91643f
C628 bias_cell_0.VT_dpi bias_cell_0.Vthr 41.1443f
C629 bias_cell_0.VIp a_43986_74478# 0.08414f
C630 bias_cell_0.VKdn DPI_inh_0.Iout 0.24203f
C631 spike[0] spike[1] 1.53628f
C632 spike[2] a_45030_32320# 0.34277f
C633 a_43278_20418# spike[1] 0.14379f
C634 bias_cell_0.VKdn a_45030_8672# 0.05334f
C635 s[1] w[30] 0.03824f
C636 a_45030_78896# a_43278_78818# 0.09781f
C637 neuron_sized_1.VMEM VDD 5.90387f
C638 neuron_sized_4.VMEM bias_cell_0.VIp 0.17183f
C639 DPI_3.Isum pulse[1] 0.06983f
C640 bias_cell_0.Vb bias_cell_0.Vamp_bias 11.2722f
C641 w[10] w[8] 0.73399f
C642 spike[3] spike[1] 4.96058f
C643 pulse[1] s[0] 0.10369f
C644 bias_cell_0.VK bias_cell_0.VT_inh 0.22634f
C645 a_44260_32304# bias_cell_0.VKup 0.1559f
C646 bias_cell_0.VK a_44260_8656# 0.02735f
C647 a_48826_51190# a_43278_55530# 0.06007f
C648 bias_cell_0.VT_dpi spike[1] 0.17979f
C649 DPI_4.Isum pulse[0] 0.05407f
C650 VT a_45030_78896# 0.24678f
C651 a_45268_16156# VT 0.51443f
C652 bias_cell_0.Vthr Iref 0.64052f
C653 w[26] DPI_inh_0.Isum 0.02869f
C654 a_48106_4254# bias_cell_0.VKdn 0.22172f
C655 VDD w[5] 0.10124f
C656 w[10] w[11] 15.7792f
C657 DPI_0.Isum w[30] 0.07651f
C658 w[20] spike[1] 1.74087f
C659 w[10] VDD 0.10161f
C660 a_48826_4254# a_45030_8672# 0.04671f
C661 a_5364_69692# w[22] 0.0335f
C662 pulse[0] w[13] 0.04779f
C663 DPI_4.Isum w[3] 0.04779f
C664 bias_cell_0.VKdn a_2244_98592# 1.22616f
C665 a_44260_32304# bias_cell_0.VIp 0.11998f
C666 w[25] DPI_0.Isum 0.03824f
C667 DPI_4.Isum s[0] 0.05542f
C668 a_45030_20496# VT 0.24678f
C669 a_48826_74478# a_45030_78896# 0.04671f
C670 a_48106_16078# spike[1] 0.05233f
C671 VDD bias_cell_0.VKdn 1.82665f
C672 pulse[0] spike[0] 0.08827f
C673 DPI_3.Isum w[13] 0.04779f
C674 w[19] VDD 0.15576f
C675 bias_cell_0.VK VT 10.5263f
C676 bias_cell_0.VNA neuron_sized_2.VMEM 0.96558f
C677 w[2] a_5364_11292# 0.0335f
C678 a_45268_4332# a_45030_8672# 0.09185f
C679 bias_cell_0.VT_dpi bias_cell_0.Vb 0.06409f
C680 VDD a_23094_91304# 0.13775f
C681 a_48106_4254# a_48826_4254# 0.81727f
C682 s[1] DPI_0.Isum 6.90185f
C683 spike[1] neuron_sized_3.VMEM 0.06805f
C684 w[26] VDD 0.10171f
C685 w[14] pulse[1] 0.04779f
C686 DPI_3.Isum spike[0] 0.06677f
C687 DPI_2.Isum bias_cell_0.Vthr 2.892f
C688 s[0] spike[0] 0.0678f
C689 a_50306_55608# a_46472_55530# 0.43603f
C690 a_45268_51268# VT 0.51443f
C691 w[26] w[24] 0.73399f
C692 neuron_sized_1.VMEM a_48826_51190# 0.01311f
C693 DAC_signed_1.DAC_binary_0.Isum a_3364_81516# 0.36625f
C694 a_48106_4254# a_45268_4332# 0.02025f
C695 w[31] bias_cell_0.VNA 0.0345f
C696 DPI_3.Isum spike[3] 0.10174f
C697 pulse[0] w[20] 0.04779f
C698 neuron_sized_1.VMEM a_43278_55530# 0.47933f
C699 a_48106_74478# a_45030_78896# 0.2196f
C700 a_50306_8672# spike[0] 1.46926f
C701 bias_cell_0.VKdn a_43986_27902# 0.04997f
C702 w[17] pulse[1] 0.04779f
C703 a_43986_16078# bias_cell_0.VKdn 0.04997f
C704 bias_cell_0.Vb Iref 35.7772f
C705 DPI_2.Isum w[18] 0.09558f
C706 s[0] spike[3] 2.14979f
C707 DPI_3.Isum bias_cell_0.VT_dpi 0.0901f
C708 bias_cell_0.VKdn a_43278_8594# 3.14096f
C709 w[22] w[23] 30.1144f
C710 a_50306_20496# a_45030_20496# 0.70062f
C711 w[14] DPI_4.Isum 0.04779f
C712 bias_cell_0.VT_dpi a_34406_74068# 1.57349f
C713 a_34406_3844# VDD 7.53972f
C714 a_45030_78896# spike[4] 0.34277f
C715 w[28] pulse[1] 0.04779f
C716 bias_cell_0.VT_inh bias_cell_0.VKup 0.05593f
C717 bias_cell_0.VKdn spike[2] 0.11443f
C718 a_45268_74556# a_44260_78880# 0.12841f
C719 s[1] a_34406_27492# 0.01083f
C720 DPI_3.Isum w[20] 0.04779f
C721 DPI_2.Isum spike[1] 0.1792f
C722 bias_cell_0.VKup a_44260_8656# 0.1559f
C723 bias_cell_0.Vthr DPI_inh_0.Iout 0.35705f
C724 DPI_1.Isum w[27] 0.09558f
C725 w[14] w[13] 20.238f
C726 w[4] w[5] 10.424f
C727 pulse[1] w[7] 0.05862f
C728 w[26] spike[2] 0.06245f
C729 bias_cell_0.VKdn a_44260_78880# 0.11969f
C730 w[17] DPI_4.Isum 0.04779f
C731 a_48826_51190# bias_cell_0.VKdn 0.30387f
C732 w[31] pulse[1] 2.51204f
C733 bias_cell_0.VKup a_43278_78818# 0.15534f
C734 bias_cell_0.VKdn a_43986_4254# 0.04997f
C735 DPI_inh_0.Isum bias_cell_0.Vthr 2.90764f
C736 bias_cell_0.Vlk bias_cell_0.Vb 12.4973f
C737 bias_cell_0.VKdn a_45030_32320# 0.05334f
C738 w[14] spike[0] 0.04779f
C739 a_46472_78818# a_45030_78896# 0.05399f
C740 bias_cell_0.VNA bias_cell_0.VK 0.28952f
C741 w[28] DPI_4.Isum 0.04779f
C742 bias_cell_0.VKdn a_43278_55530# 3.14096f
C743 bias_cell_0.Vamp_bias neuron_sized_2.VMEM 0.24174f
C744 a_43278_32242# VDD 2.21359f
C745 bias_cell_0.VIp a_44260_8656# 0.11998f
C746 a_48826_51190# a_43986_51190# 0.54225f
C747 a_48826_4254# a_43278_8594# 0.06007f
C748 pulse[1] w[23] 0.04779f
C749 a_34406_50780# DPI_1.Isum 0.65893f
C750 bias_cell_0.VKup VT 0.24489f
C751 DPI_4.Isum w[7] 0.04779f
C752 a_48826_27902# a_50306_32320# 0.33343f
C753 a_50306_78896# a_43986_74478# 0.0934f
C754 VT a_44260_20480# 0.64213f
C755 w[17] spike[0] 0.44083f
C756 w[31] DPI_4.Isum 0.04785f
C757 a_34406_3844# spike[2] 0.01983f
C758 bias_cell_0.VIp a_48106_27902# 0.26988f
C759 a_48826_4254# a_43986_4254# 0.54225f
C760 w[28] spike[0] 0.21651f
C761 w[31] bias_cell_0.Vamp_bias 0.04058f
C762 a_46472_8594# spike[0] 0.16612f
C763 bias_cell_0.Vthr VDD 15.0363f
C764 bias_cell_0.VIp VT 0.1833f
C765 DPI_4.Isum w[23] 0.04779f
C766 w[15] spike[1] 0.05862f
C767 bias_cell_0.Vamp_bias a_45030_78896# 0.13368f
C768 a_45268_16156# bias_cell_0.Vamp_bias 0.67458f
C769 w[25] w[27] 1.52394f
C770 DPI_0.Isum a_23094_79840# 0.17374f
C771 w[28] spike[3] 2.90662f
C772 VDD w[18] 0.10161f
C773 neuron_sized_4.VMEM a_44260_8656# 1.43869f
C774 a_45268_4332# a_43986_4254# 1.24342f
C775 DPI_2.Isum s[0] 0.10964f
C776 w[31] spike[0] 0.78179f
C777 a_45268_51268# a_45030_55608# 0.09185f
C778 a_43278_32242# spike[2] 0.14379f
C779 DPI_3.Isum a_5364_23116# 0.36625f
C780 DPI_1.Isum w[22] 0.09563f
C781 DPI_inh_0.Isum DAC_signed_1.DAC_binary_0.Isum 0.03922f
C782 neuron_sized_1.VMEM bias_cell_0.VKdn 0.24119f
C783 VDD spike[1] 7.32373f
C784 w[2] DPI_4.Isum 0.04784f
C785 a_45030_20496# bias_cell_0.Vamp_bias 0.13368f
C786 bias_cell_0.Vthr a_34584_81836# 0.27422f
C787 w[23] spike[0] 0.09558f
C788 neuron_sized_1.VMEM a_43986_51190# 0.27007f
C789 w[29] spike[1] 0.45707f
C790 w[31] spike[3] 0.18505f
C791 a_45030_55608# a_46472_55530# 0.05399f
C792 bias_cell_0.VK bias_cell_0.Vamp_bias 0.34412f
C793 a_43986_74478# VT 0.15694f
C794 w[24] spike[1] 0.09558f
C795 a_43278_32242# a_45030_32320# 0.09781f
C796 a_5364_46404# w[13] 0.01696f
C797 a_34406_74068# DPI_inh_0.Iout 1.01662f
C798 bias_cell_0.VNA bias_cell_0.VKup 11.8121f
C799 bias_cell_0.VKup spike[4] 0.01309f
C800 neuron_sized_4.VMEM VT 0.47142f
C801 a_45030_20496# a_43278_20418# 0.09781f
C802 bias_cell_0.Vb a_2244_98592# 0.35938f
C803 DPI_0.Isum w[27] 0.03824f
C804 a_48106_27902# a_50306_32320# 0.0395f
C805 a_48826_74478# a_43986_74478# 0.54225f
C806 w[15] pulse[0] 0.04779f
C807 a_34406_50780# s[1] 0.01083f
C808 a_45268_51268# bias_cell_0.Vamp_bias 0.67458f
C809 w[21] spike[1] 0.44083f
C810 bias_cell_0.Vb VDD 36.2007f
C811 a_48826_51190# a_48106_51190# 0.81727f
C812 pulse[0] w[8] 0.04779f
C813 a_48106_74478# bias_cell_0.VIp 0.26988f
C814 DPI_inh_0.Isum s[0] 2.77766f
C815 a_43986_16078# spike[1] 0.24447f
C816 a_50306_20496# a_46472_20418# 0.43603f
C817 DPI_2.Isum w[14] 0.09563f
C818 a_50306_8672# a_45030_8672# 0.70062f
C819 bias_cell_0.VIp spike[4] 0.20429f
C820 bias_cell_0.VNA bias_cell_0.VIp 0.49047f
C821 DPI_3.Isum w[15] 0.04779f
C822 bias_cell_0.VKdn a_43986_51190# 0.04997f
C823 a_45268_16156# a_48106_16078# 0.02025f
C824 spike[2] spike[1] 3.54711f
C825 bias_cell_0.VNA w[30] 0.01794f
C826 bias_cell_0.Vlk neuron_sized_2.VMEM 0.40379f
C827 bias_cell_0.VKup a_46472_78818# 0.35765f
C828 pulse[0] w[11] 0.04779f
C829 a_45030_55608# bias_cell_0.VKup 0.13361f
C830 DPI_3.Isum w[8] 0.04779f
C831 pulse[0] VDD 0.10124f
C832 VDD a_46472_32242# 3.99075f
C833 a_44260_32304# VT 0.64213f
C834 DPI_2.Isum w[17] 0.09558f
C835 w[29] pulse[0] 0.04779f
C836 w[9] pulse[1] 0.04779f
C837 DPI_3.Isum w[11] 0.04779f
C838 a_45268_16156# neuron_sized_3.VMEM 0.23666f
C839 a_48106_4254# a_50306_8672# 0.0395f
C840 DPI_3.Isum VDD 0.11203f
C841 pulse[0] w[24] 0.04779f
C842 VDD w[3] 0.10124f
C843 a_45030_20496# a_48106_16078# 0.2196f
C844 VDD a_34406_74068# 7.49484f
C845 a_45268_51268# spike[3] 0.11297f
C846 a_48826_27902# a_48106_27902# 0.81727f
C847 a_48826_4254# bias_cell_0.VKdn 0.30387f
C848 a_48106_74478# a_43986_74478# 1.21169f
C849 DPI_2.Isum w[28] 0.09558f
C850 VDD s[0] 0.33244f
C851 bias_cell_0.VIp a_45030_55608# 0.05738f
C852 DPI_3.Isum w[29] 0.04779f
C853 a_43986_74478# spike[4] 0.24447f
C854 DPI_3.Isum w[24] 0.04779f
C855 w[29] s[0] 0.03824f
C856 pulse[1] w[30] 0.04779f
C857 w[12] pulse[1] 0.04779f
C858 bias_cell_0.VK Iref 0.07177f
C859 spike[3] a_46472_55530# 0.16612f
C860 pulse[0] w[21] 0.04779f
C861 bias_cell_0.VK a_44260_55592# 0.02735f
C862 VDD a_50306_8672# 2.72209f
C863 a_45030_20496# neuron_sized_3.VMEM 0.35423f
C864 s[0] w[24] 0.05102f
C865 a_50306_20496# a_48826_16078# 0.33343f
C866 bias_cell_0.VKup bias_cell_0.Vamp_bias 10.5178f
C867 w[9] DPI_4.Isum 0.04779f
C868 neuron_sized_4.VMEM bias_cell_0.VNA 0.48325f
C869 DPI_2.Isum w[31] 0.11822f
C870 DPI_1.Isum spike[0] 0.07311f
C871 w[25] pulse[1] 0.04779f
C872 a_5364_23116# w[7] 0.06768f
C873 bias_cell_0.VK neuron_sized_3.VMEM 0.37062f
C874 bias_cell_0.Vamp_bias a_44260_20480# 0.12068f
C875 bias_cell_0.VT_dpi a_34406_15668# 1.57349f
C876 a_50306_78896# a_43278_78818# 0.39394f
C877 neuron_sized_1.VMEM a_48106_51190# 0.01311f
C878 w[14] w[15] 20.5105f
C879 DPI_3.Isum w[21] 0.04779f
C880 spike[2] a_46472_32242# 0.16612f
C881 DPI_2.Isum w[23] 0.09558f
C882 a_45268_51268# a_44260_55592# 0.12841f
C883 DPI_1.Isum spike[3] 0.22808f
C884 DPI_4.Isum w[30] 0.04783f
C885 w[12] DPI_4.Isum 0.04779f
C886 a_45030_8672# a_46472_8594# 0.05399f
C887 bias_cell_0.VKup spike[0] 0.01309f
C888 bias_cell_0.VIp bias_cell_0.Vamp_bias 20.9823f
C889 a_45268_27980# neuron_sized_2.VMEM 0.23666f
C890 a_43278_20418# bias_cell_0.VKup 0.15534f
C891 a_43278_32242# bias_cell_0.VKdn 3.14096f
C892 DPI_inh_0.Isum DAC_signed_0.DAC_binary_0.Isum 0.03922f
C893 w[28] DPI_inh_0.Isum 0.07015f
C894 bias_cell_0.Vlk bias_cell_0.VK 47.3911f
C895 bias_cell_0.VT_dpi DPI_1.Isum 0.09043f
C896 DPI_3.Isum spike[2] 0.06385f
C897 a_43278_20418# a_44260_20480# 0.27251f
C898 w[9] spike[0] 0.39304f
C899 w[25] DPI_4.Isum 0.04779f
C900 w[14] VDD 0.10124f
C901 s[0] spike[2] 16.3132f
C902 DPI_1.Isum w[20] 0.10846f
C903 w[12] w[13] 20.0279f
C904 a_46472_32242# a_45030_32320# 0.05399f
C905 bias_cell_0.VKup spike[3] 0.01309f
C906 a_50306_8672# a_43278_8594# 0.39394f
C907 DPI_2.Isum a_5364_46404# 0.36625f
C908 DPI_4.Isum w[0] 0.06489f
C909 bias_cell_0.VIp spike[0] 0.20429f
C910 bias_cell_0.VT_dpi bias_cell_0.VKup 0.05504f
C911 a_45030_78896# DPI_inh_0.Iout 0.35423f
C912 pulse[0] w[4] 0.04779f
C913 a_34406_15668# neuron_sized_3.VMEM 0.90462f
C914 VT a_44260_8656# 0.64213f
C915 a_50306_78896# a_48826_74478# 0.33343f
C916 w[31] DPI_inh_0.Isum 0.08127f
C917 bias_cell_0.VKdn a_48106_51190# 0.22172f
C918 w[30] spike[0] 0.31407f
C919 pulse[0] w[1] 0.39304f
C920 w[12] spike[0] 0.04779f
C921 w[16] pulse[1] 0.04779f
C922 s[1] DPI_4.Isum 2.66579f
C923 w[17] VDD 0.10127f
C924 bias_cell_0.Vthr bias_cell_0.VKdn 0.03054f
C925 VDD neuron_sized_2.VMEM 5.90387f
C926 a_43986_51190# a_48106_51190# 1.21169f
C927 a_43986_74478# bias_cell_0.Vamp_bias 0.04253f
C928 w[25] spike[0] 0.15537f
C929 w[3] w[4] 5.16772f
C930 DPI_3.Isum w[4] 0.06067f
C931 bias_cell_0.VIp spike[3] 0.20429f
C932 w[7] w[8] 9.81028f
C933 w[28] VDD 0.10124f
C934 a_43278_20418# a_46472_20418# 0.22613f
C935 w[1] w[3] 1.52394f
C936 VDD a_46472_8594# 3.99075f
C937 a_50306_8672# a_43986_4254# 0.0934f
C938 spike[3] w[30] 0.11582f
C939 bias_cell_0.VT_dpi bias_cell_0.VIp 0.01862f
C940 neuron_sized_4.VMEM bias_cell_0.Vamp_bias 0.17824f
C941 w[28] w[29] 39.9548f
C942 bias_cell_0.VKup Iref 0.97865f
C943 bias_cell_0.VK DPI_inh_0.Iout 0.37176f
C944 a_44260_55592# bias_cell_0.VKup 0.1559f
C945 w[16] DPI_4.Isum 0.04779f
C946 a_5364_69692# w[21] 0.01696f
C947 VDD w[7] 0.10124f
C948 w[19] w[18] 25.3831f
C949 bias_cell_0.VKdn spike[1] 0.11443f
C950 s[1] spike[0] 0.05942f
C951 a_48826_74478# a_43278_78818# 0.06007f
C952 w[31] VDD 0.10124f
C953 bias_cell_0.VKup neuron_sized_3.VMEM 0.43145f
C954 a_48106_74478# a_50306_78896# 0.0395f
C955 w[19] spike[1] 0.04779f
C956 a_44260_20480# neuron_sized_3.VMEM 1.43869f
C957 neuron_sized_4.VMEM spike[0] 0.06805f
C958 bias_cell_0.VIp a_48106_16078# 0.26988f
C959 w[29] w[31] 1.52394f
C960 a_43986_27902# neuron_sized_2.VMEM 0.27007f
C961 VDD a_45030_78896# 4.15363f
C962 a_50306_78896# spike[4] 1.46926f
C963 w[26] spike[1] 0.28156f
C964 s[1] spike[3] 0.89517f
C965 VDD w[23] 0.10342f
C966 bias_cell_0.VIp a_44260_55592# 0.11998f
C967 a_44260_32304# bias_cell_0.Vamp_bias 0.12068f
C968 a_34406_3844# bias_cell_0.Vthr 0.23039f
C969 a_5364_46404# w[15] 0.06768f
C970 bias_cell_0.Vlk bias_cell_0.VKup 0.20771f
C971 spike[2] neuron_sized_2.VMEM 0.06805f
C972 w[25] a_3364_81516# 0.01696f
C973 w[16] spike[0] 1.51079f
C974 bias_cell_0.VIp neuron_sized_3.VMEM 0.22734f
C975 w[9] a_5364_34940# 0.01696f
C976 bias_cell_0.VNA bias_cell_0.VT_inh 0.80376f
C977 a_46472_8594# a_43278_8594# 0.22613f
C978 w[23] w[24] 28.0978f
C979 w[28] spike[2] 0.04789f
C980 pulse[0] w[5] 0.04779f
C981 a_45030_20496# VDD 4.15363f
C982 a_48826_16078# a_43278_20418# 0.06007f
C983 bias_cell_0.VK a_2244_98592# 1.01603f
C984 bias_cell_0.Vb bias_cell_0.VKdn 0.24595f
C985 a_5364_58228# w[19] 0.06768f
C986 w[10] pulse[0] 0.04779f
C987 w[2] VDD 0.10124f
C988 DPI_0.Isum spike[3] 0.20315f
C989 a_50306_78896# a_46472_78818# 0.43603f
C990 bias_cell_0.VK VDD 2.84515f
C991 a_46472_20418# neuron_sized_3.VMEM 0.01577f
C992 DPI_inh_0.Iout DPI_inh_0.DPI_sized_0.Isyn 0.33569f
C993 a_34406_3844# spike[1] 0.02073f
C994 bias_cell_0.Vlk bias_cell_0.VIp 0.28321f
C995 DPI_3.Isum w[5] 0.04814f
C996 bias_cell_0.VNA a_43278_78818# 0.49118f
C997 bias_cell_0.VT_dpi DPI_0.Isum 0.09043f
C998 a_43278_78818# spike[4] 0.14379f
C999 DPI_2.Isum w[9] 0.04814f
C1000 w[21] w[23] 1.52394f
C1001 a_45030_32320# neuron_sized_2.VMEM 0.35423f
C1002 a_45268_16156# a_43986_16078# 1.24342f
C1003 DPI_3.Isum w[10] 0.04779f
C1004 w[31] spike[2] 4.95947f
C1005 pulse[0] w[19] 0.04779f
C1006 VT spike[4] 0.01121f
C1007 bias_cell_0.VNA VT 0.20675f
C1008 DPI_2.Isum w[30] 0.09561f
C1009 w[26] pulse[0] 0.04779f
C1010 DPI_2.Isum w[12] 0.10846f
C1011 a_43986_16078# a_45030_20496# 0.09251f
C1012 bias_cell_0.VKup DPI_inh_0.Iout 0.43242f
C1013 DPI_3.Isum w[19] 0.04779f
C1014 a_48826_16078# a_48106_16078# 0.81727f
C1015 a_45030_78896# a_44260_78880# 0.36022f
C1016 a_46472_78818# a_43278_78818# 0.22613f
C1017 bias_cell_0.VKup a_45030_8672# 0.13361f
C1018 a_50306_55608# a_45030_55608# 0.70062f
C1019 a_48106_74478# a_48826_74478# 0.81727f
C1020 DPI_2.Isum w[25] 0.09558f
C1021 bias_cell_0.VK a_43986_27902# 0.23589f
C1022 VDD a_46472_55530# 3.99075f
C1023 a_43986_16078# bias_cell_0.VK 0.23589f
C1024 VDD a_34406_15668# 7.49484f
C1025 DPI_3.Isum w[26] 0.04779f
C1026 a_34406_27492# bias_cell_0.VT_dpi 1.57349f
C1027 a_48826_74478# spike[4] 0.14308f
C1028 pulse[1] w[6] 0.0624f
C1029 w[26] s[0] 0.03824f
C1030 pulse[0] VSS 3.82724f
C1031 w[0] VSS 5.08075f
C1032 w[1] VSS 3.45534f
C1033 w[2] VSS 8.80537f
C1034 w[3] VSS 12.0136f
C1035 pulse[1] VSS 4.98463f
C1036 w[4] VSS 5.24504f
C1037 w[5] VSS 3.8968f
C1038 w[6] VSS 9.24533f
C1039 w[7] VSS 12.5648f
C1040 w[8] VSS 5.67067f
C1041 w[9] VSS 4.31356f
C1042 w[10] VSS 9.66808f
C1043 w[11] VSS 13.1017f
C1044 w[12] VSS 6.04051f
C1045 w[13] VSS 4.75145f
C1046 w[14] VSS 10.1066f
C1047 w[15] VSS 13.6279f
C1048 spike[0] VSS 47.6846f
C1049 w[16] VSS 6.54225f
C1050 w[17] VSS 5.20181f
C1051 w[18] VSS 10.5563f
C1052 w[19] VSS 14.1868f
C1053 spike[1] VSS 44.7481f
C1054 w[20] VSS 6.92876f
C1055 w[21] VSS 5.6397f
C1056 w[22] VSS 10.9949f
C1057 w[23] VSS 14.7106f
C1058 VT VSS 22.5351f
C1059 spike[4] VSS 35.1219f
C1060 s[0] VSS 7.13738f
C1061 spike[2] VSS 37.4862f
C1062 w[24] VSS 7.57015f
C1063 w[25] VSS 6.24748f
C1064 w[26] VSS 11.6099f
C1065 w[27] VSS 15.708f
C1066 s[1] VSS 8.87827f
C1067 spike[3] VSS 83.9677f
C1068 w[28] VSS 7.94606f
C1069 w[29] VSS 6.67188f
C1070 w[30] VSS 12.0262f
C1071 w[31] VSS 19.5824f
C1072 Iref VSS 74.3765f
C1073 VDD VSS 1.26827p
C1074 a_48826_4254# VSS 2.67696f
C1075 a_48106_4254# VSS 1.45233f
C1076 a_45268_4332# VSS 1.4805f
C1077 a_43986_4254# VSS 4.85902f
C1078 a_50306_8672# VSS 2.78312f
C1079 a_46472_8594# VSS 2.65127f
C1080 a_45030_8672# VSS 5.85582f
C1081 a_44260_8656# VSS 1.92749f
C1082 a_43278_8594# VSS 6.13033f
C1083 neuron_sized_4.VMEM VSS 23.6098f
C1084 a_34406_3844# VSS 7.14621f
C1085 a_5364_11292# VSS 15.09f
C1086 a_48826_16078# VSS 2.67696f
C1087 a_48106_16078# VSS 1.45233f
C1088 a_45268_16156# VSS 1.4805f
C1089 a_43986_16078# VSS 4.85902f
C1090 a_50306_20496# VSS 2.78312f
C1091 a_46472_20418# VSS 2.65127f
C1092 a_45030_20496# VSS 5.85582f
C1093 a_44260_20480# VSS 1.92749f
C1094 a_43278_20418# VSS 6.13033f
C1095 neuron_sized_3.VMEM VSS 23.4886f
C1096 a_34406_15668# VSS 7.23578f
C1097 a_5364_23116# VSS 15.09f
C1098 a_48826_27902# VSS 2.67696f
C1099 a_48106_27902# VSS 1.45233f
C1100 a_45268_27980# VSS 1.4805f
C1101 a_43986_27902# VSS 4.85902f
C1102 a_50306_32320# VSS 2.78312f
C1103 a_46472_32242# VSS 2.65127f
C1104 a_45030_32320# VSS 5.85582f
C1105 a_44260_32304# VSS 1.92749f
C1106 a_43278_32242# VSS 6.13033f
C1107 neuron_sized_2.VMEM VSS 23.4886f
C1108 a_34406_27492# VSS 7.23578f
C1109 a_5364_34940# VSS 15.09f
C1110 a_5364_46404# VSS 15.09f
C1111 a_48826_51190# VSS 2.67696f
C1112 a_48106_51190# VSS 1.45233f
C1113 a_45268_51268# VSS 1.4805f
C1114 a_43986_51190# VSS 4.85902f
C1115 a_50306_55608# VSS 2.78312f
C1116 a_46472_55530# VSS 2.65127f
C1117 a_45030_55608# VSS 5.85582f
C1118 a_44260_55592# VSS 1.92749f
C1119 a_43278_55530# VSS 6.13033f
C1120 neuron_sized_1.VMEM VSS 23.4886f
C1121 a_34406_50780# VSS 7.23578f
C1122 a_5364_58228# VSS 15.09f
C1123 a_5364_69692# VSS 15.09f
C1124 a_48826_74478# VSS 2.67696f
C1125 a_48106_74478# VSS 1.45233f
C1126 a_45268_74556# VSS 1.4805f
C1127 a_43986_74478# VSS 4.85902f
C1128 a_50306_78896# VSS 2.78312f
C1129 a_46472_78818# VSS 2.65127f
C1130 a_45030_78896# VSS 5.85582f
C1131 a_44260_78880# VSS 1.92749f
C1132 a_43278_78818# VSS 6.13033f
C1133 a_34406_74068# VSS 7.23317f
C1134 DPI_inh_0.Iout VSS 28.4036f
C1135 DPI_inh_0.DPI_sized_0.Isyn VSS 7.66099f
C1136 a_34584_81836# VSS 7.01257f
C1137 a_23094_79840# VSS 1.9463f
C1138 DAC_signed_1.DAC_binary_0.Isum VSS 2.16604f
C1139 a_3364_81516# VSS 15.09f
C1140 a_23094_91304# VSS 1.9463f
C1141 DAC_signed_0.DAC_binary_0.Isum VSS 2.16604f
C1142 a_3364_92980# VSS 15.09f
C1143 bias_cell_0.VT_inh VSS 8.73408f
C1144 bias_cell_0.VT_dpi VSS 27.1696f
C1145 bias_cell_0.Vthr VSS 19.3392f
C1146 bias_cell_0.VKup VSS 19.7137f
C1147 bias_cell_0.VNA VSS 34.5806f
C1148 bias_cell_0.Vamp_bias VSS 20.4194f
C1149 bias_cell_0.VK VSS 29.829f
C1150 bias_cell_0.VIp VSS 17.9192f
C1151 bias_cell_0.VKdn VSS 20.8198f
C1152 bias_cell_0.Vlk VSS 23.7541f
C1153 bias_cell_0.Vb VSS 0.4702p
C1154 a_2244_98592# VSS 16.8591f
C1155 DPI_4.Isum VSS 6.09973f
C1156 DPI_3.Isum VSS 6.02985f
C1157 DPI_2.Isum VSS 10.8028f
C1158 DPI_1.Isum VSS 10.8252f
C1159 DPI_0.Isum VSS 6.44124f
C1160 DPI_inh_0.Isum VSS 3.82969f
.ends
