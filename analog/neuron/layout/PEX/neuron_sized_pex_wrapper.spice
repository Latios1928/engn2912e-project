* neuron_sized_pex: post-layout neuron_sized with the pin order of analog/neuron/neuron_sized.sym.
* GENERATED by make_pex_wrapper.py (2026-11-12); do not edit, re-run extract.sh.
* Extraction: neuron_sized_pex.spice (Magic, RC_extract.sh) of neuron_sized.gds, md5 f8c0e5f946c4151b1e8247031d836878
* Magic's pin order: VSS Vlk VK VT Vamp_bias VIp VKdn VNA VKup VMEM spike VDD
.include /foss/designs/engn2912e-project/analog/neuron/layout/PEX/neuron_sized_pex.spice

.subckt neuron_sized_pex VSS VDD VMEM VNA Vlk VK VIp VKup VKdn Vamp_bias VT spike
Xpex VSS Vlk VK VT Vamp_bias VIp VKdn VNA VKup VMEM spike VDD neuron_sized_flat
.ends neuron_sized_pex
