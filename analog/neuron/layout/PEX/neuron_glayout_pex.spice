* NGSPICE file created from neuron_glayout_flat.ext - technology: gf180mcuD

.subckt neuron_glayout_flat Vamp_bias VMEM VT VIp VKdn spike VK Vlk VKup VNA VSS VDD
X0 VSS.t169 VSS.t168 VSS.t169 VSS.t95 nfet_03v3 ad=0.14p pd=1.06u as=0 ps=0 w=0.5u l=1u
X1 VSS.t96 VSS.t94 VSS.t96 VSS.t95 nfet_03v3 ad=0.14p pd=1.06u as=0 ps=0 w=0.5u l=1u
X2 VDD.t68 VDD.t66 VDD.t68 VDD.t67 pfet_03v3 ad=0.14p pd=1.06u as=0 ps=0 w=0.5u l=1u
X3 VDD.t89 VDD.t88 VDD.t89 VDD.t7 pfet_03v3 ad=0.14p pd=1.06u as=0 ps=0 w=0.5u l=1u
X4 VDD.t59 VDD.t57 VDD.t59 VDD.t58 pfet_03v3 ad=0.14p pd=1.06u as=0 ps=0 w=0.5u l=1u
X5 VDD.t44 VDD.t42 VDD.t44 VDD.t43 pfet_03v3 ad=0.14p pd=1.06u as=0 ps=0 w=0.5u l=1u
X6 VSS.t159 VSS.t158 VSS.t159 VSS.t80 nfet_03v3 ad=0.14p pd=1.06u as=0 ps=0 w=0.5u l=1u
X7 VMEM.t1 spike.t3 a_5154_n131# VSS.t176 nfet_03v3 ad=0.3p pd=2.2u as=0.3p ps=2.2u w=0.5u l=11.36u
X8 VSS.t119 VSS.t118 VSS.t119 VSS.t20 nfet_03v3 ad=0.14p pd=1.06u as=0 ps=0 w=0.5u l=1u
X9 VSS.t75 VSS.t73 VSS.t75 VSS.t74 nfet_03v3 ad=0.14p pd=1.06u as=0 ps=0 w=0.5u l=1u
X10 VDD.t107 VDD.t106 VDD.t107 VDD.t34 pfet_03v3 ad=0.14p pd=1.06u as=0 ps=0 w=0.5u l=1u
X11 VSS.t143 VSS.t142 VSS.t143 VSS.t56 nfet_03v3 ad=0.14p pd=1.06u as=0 ps=0 w=0.5u l=1u
X12 a_2498_n131# VIp.t0 VSS.t9 VSS.t8 nfet_03v3 ad=0.6p pd=3.2u as=0.6p ps=3.2u w=1u l=1u
X13 VDD.t85 VDD.t84 VDD.t85 VDD.t1 pfet_03v3 ad=0.3p pd=2.2u as=0 ps=0 w=0.5u l=1u
X14 VDD.t38 VDD.t36 VDD.t38 VDD.t37 pfet_03v3 ad=0.14p pd=1.06u as=0 ps=0 w=0.5u l=1u
X15 VSS.t167 VSS.t166 VSS.t167 VSS.t92 nfet_03v3 ad=0.14p pd=1.06u as=0 ps=0 w=0.5u l=1u
X16 VSS.t66 VSS.t64 VSS.t66 VSS.t65 nfet_03v3 ad=0.14p pd=1.06u as=0 ps=0 w=0.5u l=1u
X17 VDD.t23 VDD.t21 VDD.t23 VDD.t22 pfet_03v3 ad=0.14p pd=1.06u as=0 ps=0 w=0.5u l=1u
X18 a_5154_n131# VK.t0 VSS.t5 VSS.t4 nfet_03v3 ad=0.6p pd=3.2u as=0.6p ps=3.2u w=1u l=1u
X19 VSS.t51 VSS.t49 VSS.t51 VSS.t50 nfet_03v3 ad=0.14p pd=1.06u as=0 ps=0 w=0.5u l=1u
X20 VDD.t29 VDD.t27 VDD.t29 VDD.t28 pfet_03v3 ad=0.14p pd=1.06u as=0 ps=0 w=0.5u l=1u
X21 a_2746_n131# a_2118_n481# a_2498_n131# VSS.t0 nfet_03v3 ad=0.3p pd=2.2u as=0.3p ps=2.2u w=0.5u l=0.64u
X22 VSS.t18 VSS.t16 VSS.t18 VSS.t17 nfet_03v3 ad=0.14p pd=1.06u as=0 ps=0 w=0.5u l=1u
X23 VDD.t14 VDD.t12 VDD.t14 VDD.t13 pfet_03v3 ad=0.14p pd=1.06u as=0 ps=0 w=0.5u l=1u
X24 VSS.t153 VSS.t152 VSS.t153 VSS.t71 nfet_03v3 ad=0.14p pd=1.06u as=0 ps=0 w=0.5u l=1u
X25 VDD.t83 VDD.t81 VDD.t83 VDD.t82 pfet_03v3 ad=0.6p pd=3.2u as=0 ps=0 w=1u l=1u
X26 VSS.t102 VSS.t100 VSS.t102 VSS.t101 nfet_03v3 ad=0.14p pd=1.06u as=0 ps=0 w=0.5u l=1u
X27 VSS.t117 VSS.t116 VSS.t117 VSS.t17 nfet_03v3 ad=0.14p pd=1.06u as=0 ps=0 w=0.5u l=1u
X28 VDD.t65 VDD.t63 VDD.t65 VDD.t64 pfet_03v3 ad=0.14p pd=1.06u as=0 ps=0 w=0.5u l=1u
X29 VMEM.t3 VSS.t182 cap_mim_2f0_m4m5_noshield c_width=22.18u c_length=22.18u
X30 VSS.t45 VSS.t43 VSS.t45 VSS.t44 nfet_03v3 ad=0.14p pd=1.06u as=0 ps=0 w=0.5u l=1u
X31 VSS.t141 VSS.t140 VSS.t141 VSS.t53 nfet_03v3 ad=0.14p pd=1.06u as=0 ps=0 w=0.5u l=1u
X32 VSS.t36 VSS.t34 VSS.t36 VSS.t35 nfet_03v3 ad=0.14p pd=1.06u as=0 ps=0 w=0.5u l=1u
X33 VDD.t8 VDD.t6 VDD.t8 VDD.t7 pfet_03v3 ad=0.14p pd=1.06u as=0 ps=0 w=0.5u l=1u
X34 VDD.t131 VDD.t130 VDD.t131 VDD.t70 pfet_03v3 ad=0.14p pd=1.06u as=0 ps=0 w=0.5u l=1u
X35 VSS.t12 VSS.t10 VSS.t12 VSS.t11 nfet_03v3 ad=0.3p pd=2.2u as=0 ps=0 w=0.5u l=1u
X36 VDD.t125 VDD.t124 VDD.t125 VDD.t61 pfet_03v3 ad=0.14p pd=1.06u as=0 ps=0 w=0.5u l=1u
X37 VDD.t80 VDD.t78 VDD.t80 VDD.t79 pfet_03v3 ad=0.6p pd=3.2u as=0 ps=0 w=1u l=1u
X38 VDD.t137 a_786_5705# a_786_5705# VDD.t136 pfet_03v3 ad=0.3p pd=2.2u as=0.3p ps=2.2u w=0.5u l=8u
X39 VSS.t151 VSS.t150 VSS.t151 VSS.t68 nfet_03v3 ad=0.14p pd=1.06u as=0 ps=0 w=0.5u l=1u
X40 VSS.t87 VSS.t85 VSS.t87 VSS.t86 nfet_03v3 ad=0.14p pd=1.06u as=0 ps=0 w=0.5u l=1u
X41 VSS.t129 VSS.t128 VSS.t129 VSS.t35 nfet_03v3 ad=0.14p pd=1.06u as=0 ps=0 w=0.5u l=1u
X42 VSS.t72 VSS.t70 VSS.t72 VSS.t71 nfet_03v3 ad=0.14p pd=1.06u as=0 ps=0 w=0.5u l=1u
X43 VDD.t35 VDD.t33 VDD.t35 VDD.t34 pfet_03v3 ad=0.14p pd=1.06u as=0 ps=0 w=0.5u l=1u
X44 VSS.t63 VSS.t61 VSS.t63 VSS.t62 nfet_03v3 ad=0.14p pd=1.06u as=0 ps=0 w=0.5u l=1u
X45 VSS.t24 VSS.t22 VSS.t24 VSS.t23 nfet_03v3 ad=0.14p pd=1.06u as=0 ps=0 w=0.5u l=1u
X46 VDD.t117 VDD.t116 VDD.t117 VDD.t49 pfet_03v3 ad=0.14p pd=1.06u as=0 ps=0 w=0.5u l=1u
X47 VDD.t2 VDD.t0 VDD.t2 VDD.t1 pfet_03v3 ad=0.3p pd=2.2u as=0 ps=0 w=0.5u l=1u
X48 VDD.t121 VDD.t120 VDD.t121 VDD.t55 pfet_03v3 ad=0.14p pd=1.06u as=0 ps=0 w=0.5u l=1u
X49 spike.t2 VSS.t177 cap_mim_2f0_m4m5_noshield c_width=10u c_length=10u
X50 VSS.t165 VSS.t164 VSS.t165 VSS.t89 nfet_03v3 ad=0.14p pd=1.06u as=0 ps=0 w=0.5u l=1u
X51 VSS.t111 VSS.t109 VSS.t111 VSS.t110 nfet_03v3 ad=2.4p pd=9.2u as=0 ps=0 w=4u l=1u
X52 VSS.t139 VSS.t138 VSS.t139 VSS.t50 nfet_03v3 ad=0.14p pd=1.06u as=0 ps=0 w=0.5u l=1u
X53 VDD.t111 VDD.t110 VDD.t111 VDD.t40 pfet_03v3 ad=0.14p pd=1.06u as=0 ps=0 w=0.5u l=1u
X54 VDD.t101 VDD.t100 VDD.t101 VDD.t25 pfet_03v3 ad=0.14p pd=1.06u as=0 ps=0 w=0.5u l=1u
X55 VDD.t105 VDD.t104 VDD.t105 VDD.t31 pfet_03v3 ad=0.14p pd=1.06u as=0 ps=0 w=0.5u l=1u
X56 VDD.t95 VDD.t94 VDD.t95 VDD.t16 pfet_03v3 ad=0.14p pd=1.06u as=0 ps=0 w=0.5u l=1u
X57 VSS.t57 VSS.t55 VSS.t57 VSS.t56 nfet_03v3 ad=0.14p pd=1.06u as=0 ps=0 w=0.5u l=1u
X58 VDD.t141 a_2118_n481# a_2746_n131# VDD.t140 pfet_03v3 ad=0.3p pd=2.2u as=0.3p ps=2.2u w=0.5u l=0.64u
X59 VSS.t123 VSS.t122 VSS.t123 VSS.t26 nfet_03v3 ad=0.14p pd=1.06u as=0 ps=0 w=0.5u l=1u
X60 VSS.t42 VSS.t40 VSS.t42 VSS.t41 nfet_03v3 ad=0.14p pd=1.06u as=0 ps=0 w=0.5u l=1u
X61 VSS.t33 VSS.t31 VSS.t33 VSS.t32 nfet_03v3 ad=0.14p pd=1.06u as=0 ps=0 w=0.5u l=1u
X62 VMEM.t2 Vlk.t0 VSS.t3 VSS.t2 nfet_03v3 ad=0.6p pd=3.2u as=0.6p ps=3.2u w=1u l=1u
X63 VDD.t97 VDD.t96 VDD.t97 VDD.t19 pfet_03v3 ad=0.14p pd=1.06u as=0 ps=0 w=0.5u l=1u
X64 VSS.t163 VSS.t162 VSS.t163 VSS.t86 nfet_03v3 ad=0.14p pd=1.06u as=0 ps=0 w=0.5u l=1u
X65 VDD.t71 VDD.t69 VDD.t71 VDD.t70 pfet_03v3 ad=0.14p pd=1.06u as=0 ps=0 w=0.5u l=1u
X66 VDD.t91 VDD.t90 VDD.t91 VDD.t10 pfet_03v3 ad=0.14p pd=1.06u as=0 ps=0 w=0.5u l=1u
X67 VSS.t137 VSS.t136 VSS.t137 VSS.t47 nfet_03v3 ad=0.14p pd=1.06u as=0 ps=0 w=0.5u l=1u
X68 VDD.t62 VDD.t60 VDD.t62 VDD.t61 pfet_03v3 ad=0.14p pd=1.06u as=0 ps=0 w=0.5u l=1u
X69 VDD.t135 VDD.t134 VDD.t135 VDD.t76 pfet_03v3 ad=0.14p pd=1.06u as=0 ps=0 w=0.5u l=1u
X70 VSS.t127 VSS.t126 VSS.t127 VSS.t32 nfet_03v3 ad=0.14p pd=1.06u as=0 ps=0 w=0.5u l=1u
X71 VSS.t173 VSS.t172 VSS.t173 VSS.t101 nfet_03v3 ad=0.14p pd=1.06u as=0 ps=0 w=0.5u l=1u
X72 a_2118_n481# VT.t0 a_318_n131# VSS.t180 nfet_03v3 ad=2.4p pd=9.2u as=2.4p ps=9.2u w=4u l=2u
X73 VSS.t93 VSS.t91 VSS.t93 VSS.t92 nfet_03v3 ad=0.14p pd=1.06u as=0 ps=0 w=0.5u l=1u
X74 VDD.t119 VDD.t118 VDD.t119 VDD.t52 pfet_03v3 ad=0.14p pd=1.06u as=0 ps=0 w=0.5u l=1u
X75 VSS.t113 VSS.t112 VSS.t113 VSS.t11 nfet_03v3 ad=0.3p pd=2.2u as=0 ps=0 w=0.5u l=1u
X76 VDD.t50 VDD.t48 VDD.t50 VDD.t49 pfet_03v3 ad=0.14p pd=1.06u as=0 ps=0 w=0.5u l=1u
X77 VSS.t78 VSS.t76 VSS.t78 VSS.t77 nfet_03v3 ad=0.14p pd=1.06u as=0 ps=0 w=0.5u l=1u
X78 a_5862_5705# a_2746_n131# spike.t0 VDD.t142 pfet_03v3 ad=0.3p pd=2.2u as=0.3p ps=2.2u w=0.5u l=0.64u
X79 a_318_n131# Vamp_bias.t0 VSS.t179 VSS.t178 nfet_03v3 ad=0.3p pd=2.2u as=0.3p ps=2.2u w=0.5u l=0.64u
X80 VDD.t56 VDD.t54 VDD.t56 VDD.t55 pfet_03v3 ad=0.14p pd=1.06u as=0 ps=0 w=0.5u l=1u
X81 VDD.t87 VDD.t86 VDD.t87 VDD.t4 pfet_03v3 ad=0.14p pd=1.06u as=0 ps=0 w=0.5u l=1u
X82 VSS.t161 VSS.t160 VSS.t161 VSS.t83 nfet_03v3 ad=0.14p pd=1.06u as=0 ps=0 w=0.5u l=1u
X83 VDD.t41 VDD.t39 VDD.t41 VDD.t40 pfet_03v3 ad=0.14p pd=1.06u as=0 ps=0 w=0.5u l=1u
X84 VSS.t135 VSS.t134 VSS.t135 VSS.t44 nfet_03v3 ad=0.14p pd=1.06u as=0 ps=0 w=0.5u l=1u
X85 VDD.t26 VDD.t24 VDD.t26 VDD.t25 pfet_03v3 ad=0.14p pd=1.06u as=0 ps=0 w=0.5u l=1u
X86 VDD.t32 VDD.t30 VDD.t32 VDD.t31 pfet_03v3 ad=0.14p pd=1.06u as=0 ps=0 w=0.5u l=1u
X87 VSS.t21 VSS.t19 VSS.t21 VSS.t20 nfet_03v3 ad=0.14p pd=1.06u as=0 ps=0 w=0.5u l=1u
X88 VDD.t115 VDD.t114 VDD.t115 VDD.t46 pfet_03v3 ad=0.14p pd=1.06u as=0 ps=0 w=0.5u l=1u
X89 VDD.t17 VDD.t15 VDD.t17 VDD.t16 pfet_03v3 ad=0.14p pd=1.06u as=0 ps=0 w=0.5u l=1u
X90 VSS.t15 VSS.t13 VSS.t15 VSS.t14 nfet_03v3 ad=0.14p pd=1.06u as=0 ps=0 w=0.5u l=1u
X91 VDD.t147 VNA.t0 a_7190_5705# VDD.t146 pfet_03v3 ad=0.6p pd=3.2u as=0.6p ps=3.2u w=1u l=1u
X92 VSS.t175 VSS.t174 VSS.t175 VSS.t104 nfet_03v3 ad=0.14p pd=1.06u as=0 ps=0 w=0.5u l=1u
X93 VSS.t171 VSS.t170 VSS.t171 VSS.t98 nfet_03v3 ad=0.14p pd=1.06u as=0 ps=0 w=0.5u l=1u
X94 VSS.t125 VSS.t124 VSS.t125 VSS.t29 nfet_03v3 ad=0.14p pd=1.06u as=0 ps=0 w=0.5u l=1u
X95 VSS.t149 VSS.t148 VSS.t149 VSS.t65 nfet_03v3 ad=0.14p pd=1.06u as=0 ps=0 w=0.5u l=1u
X96 VDD.t20 VDD.t18 VDD.t20 VDD.t19 pfet_03v3 ad=0.14p pd=1.06u as=0 ps=0 w=0.5u l=1u
X97 VSS.t48 VSS.t46 VSS.t48 VSS.t47 nfet_03v3 ad=0.14p pd=1.06u as=0 ps=0 w=0.5u l=1u
X98 VDD.t11 VDD.t9 VDD.t11 VDD.t10 pfet_03v3 ad=0.14p pd=1.06u as=0 ps=0 w=0.5u l=1u
X99 a_7190_5705# a_2746_n131# VMEM.t0 VDD.t143 pfet_03v3 ad=0.3p pd=2.2u as=0.3p ps=2.2u w=0.5u l=0.64u
X100 VDD.t133 VDD.t132 VDD.t133 VDD.t73 pfet_03v3 ad=0.14p pd=1.06u as=0 ps=0 w=0.5u l=1u
X101 VSS.t121 VSS.t120 VSS.t121 VSS.t23 nfet_03v3 ad=0.14p pd=1.06u as=0 ps=0 w=0.5u l=1u
X102 VSS.t99 VSS.t97 VSS.t99 VSS.t98 nfet_03v3 ad=0.14p pd=1.06u as=0 ps=0 w=0.5u l=1u
X103 VDD.t77 VDD.t75 VDD.t77 VDD.t76 pfet_03v3 ad=0.14p pd=1.06u as=0 ps=0 w=0.5u l=1u
X104 VSS.t105 VSS.t103 VSS.t105 VSS.t104 nfet_03v3 ad=0.14p pd=1.06u as=0 ps=0 w=0.5u l=1u
X105 VSS.t90 VSS.t88 VSS.t90 VSS.t89 nfet_03v3 ad=0.14p pd=1.06u as=0 ps=0 w=0.5u l=1u
X106 a_786_5705# VMEM.t4 a_318_n131# VSS.t181 nfet_03v3 ad=2.4p pd=9.2u as=2.4p ps=9.2u w=4u l=2u
X107 VDD.t53 VDD.t51 VDD.t53 VDD.t52 pfet_03v3 ad=0.14p pd=1.06u as=0 ps=0 w=0.5u l=1u
X108 VSS.t81 VSS.t79 VSS.t81 VSS.t80 nfet_03v3 ad=0.14p pd=1.06u as=0 ps=0 w=0.5u l=1u
X109 VSS.t27 VSS.t25 VSS.t27 VSS.t26 nfet_03v3 ad=0.14p pd=1.06u as=0 ps=0 w=0.5u l=1u
X110 VDD.t129 VDD.t128 VDD.t129 VDD.t67 pfet_03v3 ad=0.14p pd=1.06u as=0 ps=0 w=0.5u l=1u
X111 VDD.t123 VDD.t122 VDD.t123 VDD.t58 pfet_03v3 ad=0.14p pd=1.06u as=0 ps=0 w=0.5u l=1u
X112 VDD.t5 VDD.t3 VDD.t5 VDD.t4 pfet_03v3 ad=0.14p pd=1.06u as=0 ps=0 w=0.5u l=1u
X113 VSS.t133 VSS.t132 VSS.t133 VSS.t41 nfet_03v3 ad=0.14p pd=1.06u as=0 ps=0 w=0.5u l=1u
X114 VDD.t113 VDD.t112 VDD.t113 VDD.t43 pfet_03v3 ad=0.14p pd=1.06u as=0 ps=0 w=0.5u l=1u
X115 VSS.t84 VSS.t82 VSS.t84 VSS.t83 nfet_03v3 ad=0.14p pd=1.06u as=0 ps=0 w=0.5u l=1u
X116 VDD.t139 a_786_5705# a_2118_n481# VDD.t138 pfet_03v3 ad=0.3p pd=2.2u as=0.3p ps=2.2u w=0.5u l=8u
X117 VSS.t157 VSS.t156 VSS.t157 VSS.t77 nfet_03v3 ad=0.14p pd=1.06u as=0 ps=0 w=0.5u l=1u
X118 VDD.t47 VDD.t45 VDD.t47 VDD.t46 pfet_03v3 ad=0.14p pd=1.06u as=0 ps=0 w=0.5u l=1u
X119 VDD.t145 VKup.t0 a_5862_5705# VDD.t144 pfet_03v3 ad=0.6p pd=3.2u as=0.6p ps=3.2u w=1u l=1u
X120 VSS.t69 VSS.t67 VSS.t69 VSS.t68 nfet_03v3 ad=0.14p pd=1.06u as=0 ps=0 w=0.5u l=1u
X121 VSS.t60 VSS.t58 VSS.t60 VSS.t59 nfet_03v3 ad=0.14p pd=1.06u as=0 ps=0 w=0.5u l=1u
X122 VSS.t147 VSS.t146 VSS.t147 VSS.t62 nfet_03v3 ad=0.14p pd=1.06u as=0 ps=0 w=0.5u l=1u
X123 VSS.t108 VSS.t106 VSS.t108 VSS.t107 nfet_03v3 ad=2.4p pd=9.2u as=0 ps=0 w=4u l=1u
X124 VDD.t109 VDD.t108 VDD.t109 VDD.t37 pfet_03v3 ad=0.14p pd=1.06u as=0 ps=0 w=0.5u l=1u
X125 a_3826_n131# VKdn.t0 VSS.t7 VSS.t6 nfet_03v3 ad=0.6p pd=3.2u as=0.6p ps=3.2u w=1u l=1u
X126 VDD.t99 VDD.t98 VDD.t99 VDD.t22 pfet_03v3 ad=0.14p pd=1.06u as=0 ps=0 w=0.5u l=1u
X127 VDD.t103 VDD.t102 VDD.t103 VDD.t28 pfet_03v3 ad=0.14p pd=1.06u as=0 ps=0 w=0.5u l=1u
X128 VDD.t74 VDD.t72 VDD.t74 VDD.t73 pfet_03v3 ad=0.14p pd=1.06u as=0 ps=0 w=0.5u l=1u
X129 VSS.t131 VSS.t130 VSS.t131 VSS.t38 nfet_03v3 ad=0.14p pd=1.06u as=0 ps=0 w=0.5u l=1u
X130 VDD.t93 VDD.t92 VDD.t93 VDD.t13 pfet_03v3 ad=0.14p pd=1.06u as=0 ps=0 w=0.5u l=1u
X131 VSS.t155 VSS.t154 VSS.t155 VSS.t74 nfet_03v3 ad=0.14p pd=1.06u as=0 ps=0 w=0.5u l=1u
X132 spike.t1 a_2746_n131# a_3826_n131# VSS.t1 nfet_03v3 ad=0.3p pd=2.2u as=0.3p ps=2.2u w=0.5u l=0.64u
X133 VSS.t54 VSS.t52 VSS.t54 VSS.t53 nfet_03v3 ad=0.14p pd=1.06u as=0 ps=0 w=0.5u l=1u
X134 VSS.t115 VSS.t114 VSS.t115 VSS.t14 nfet_03v3 ad=0.14p pd=1.06u as=0 ps=0 w=0.5u l=1u
X135 VSS.t39 VSS.t37 VSS.t39 VSS.t38 nfet_03v3 ad=0.14p pd=1.06u as=0 ps=0 w=0.5u l=1u
X136 VSS.t30 VSS.t28 VSS.t30 VSS.t29 nfet_03v3 ad=0.14p pd=1.06u as=0 ps=0 w=0.5u l=1u
X137 VDD.t127 VDD.t126 VDD.t127 VDD.t64 pfet_03v3 ad=0.14p pd=1.06u as=0 ps=0 w=0.5u l=1u
X138 VSS.t145 VSS.t144 VSS.t145 VSS.t59 nfet_03v3 ad=0.14p pd=1.06u as=0 ps=0 w=0.5u l=1u
R0 Vlk Vlk.t0 44.2789
R1 VK VK.t0 43.7929
R2 VKdn VKdn.t0 40.9561
R3 VIp VIp.t0 39.9049
R4 Vamp_bias Vamp_bias.t0 40.0446
R5 VT VT.t0 31.5675
R6 VMEM.n3 VMEM.t4 30.0915
R7 VMEM.n1 VMEM.t1 26.6796
R8 VMEM.n0 VMEM.t2 24.9195
R9 VMEM.n2 VMEM.t0 24.78
R10 VMEM.n3 VMEM 16.1087
R11 VMEM VMEM.n2 8.4299
R12 VMEM.n0 VMEM.t3 7.48435
R13 VMEM.n1 VMEM.n0 1.2605
R14 VMEM VMEM.n3 0.8105
R15 VMEM.n2 VMEM.n1 0.3209
R16 spike.n1 spike.t1 26.8236
R17 spike.n0 spike.t0 24.636
R18 spike.n2 spike.t3 24.4481
R19 spike.n2 spike 15.6767
R20 spike.n0 spike.t2 9.72866
R21 spike spike.n1 6.2015
R22 spike.n1 spike.n0 1.6097
R23 spike spike.n2 0.2345
R24 VNA VNA.t0 41.9209
R25 VKup VKup.t0 40.5817
R26 VDD.n814 VDD.n813 177.363
R27 VDD.n951 VDD.n950 177.363
R28 VDD.n815 VDD.n814 177.363
R29 VDD.n950 VDD.n949 177.363
R30 VDD.n435 VDD.n427 138.338
R31 VDD.n1062 VDD.n83 138.338
R32 VDD.n1060 VDD.n83 58.121
R33 VDD.n432 VDD.n427 58.121
R34 VDD.n445 VDD.n227 57.6789
R35 VDD.n465 VDD.n209 57.6789
R36 VDD.n485 VDD.n191 57.6789
R37 VDD.n494 VDD.n493 57.6789
R38 VDD.n505 VDD.n173 57.6789
R39 VDD.n514 VDD.n513 57.6789
R40 VDD.n525 VDD.n155 57.6789
R41 VDD.n534 VDD.n533 57.6789
R42 VDD.n553 VDD.n136 57.6789
R43 VDD.n562 VDD.n561 57.6789
R44 VDD.n574 VDD.n123 57.6789
R45 VDD.n584 VDD.n117 57.6789
R46 VDD.n588 VDD.n587 57.6789
R47 VDD.n596 VDD.n109 57.6789
R48 VDD.n602 VDD.n597 57.6789
R49 VDD.n610 VDD.n103 57.6789
R50 VDD.n612 VDD.n611 57.6789
R51 VDD.n620 VDD.n97 57.6789
R52 VDD.n624 VDD.n623 57.6789
R53 VDD.n632 VDD.n89 57.6789
R54 VDD.n638 VDD.n633 57.6789
R55 VDD.n566 VDD.t40 56.237
R56 VDD.n566 VDD.t37 56.237
R57 VDD.n474 VDD.t143 54.795
R58 VDD.n561 VDD.t43 53.3531
R59 VDD.t34 VDD.n574 53.3531
R60 VDD.n576 VDD.t31 50.4691
R61 VDD.n534 VDD.t49 47.5852
R62 VDD.n553 VDD.t140 47.5852
R63 VDD.n584 VDD.t28 47.5852
R64 VDD.n454 VDD.t146 46.1433
R65 VDD.n588 VDD.t25 44.7013
R66 VDD.n525 VDD.t142 43.2593
R67 VDD.n514 VDD.t55 41.8174
R68 VDD.t22 VDD.n596 41.8174
R69 VDD.t138 VDD.n575 40.3754
R70 VDD.n434 VDD.t82 38.9334
R71 VDD.n505 VDD.t58 38.9334
R72 VDD.n602 VDD.t19 38.9334
R73 VDD.n1061 VDD.t79 38.9334
R74 VDD.n433 VDD.t76 36.0495
R75 VDD.n494 VDD.t61 36.0495
R76 VDD.t16 VDD.n610 36.0495
R77 VDD.t1 VDD.n634 36.0495
R78 VDD.n227 VDD.t73 33.1656
R79 VDD.n485 VDD.t64 33.1656
R80 VDD.n612 VDD.t13 33.1656
R81 VDD.n633 VDD.t4 33.1656
R82 VDD.n453 VDD.t70 30.2817
R83 VDD.n474 VDD.t67 30.2817
R84 VDD.n620 VDD.t10 30.2817
R85 VDD.t7 VDD.n89 30.2817
R86 VDD.n465 VDD.t70 27.3978
R87 VDD.n209 VDD.t67 27.3978
R88 VDD.n623 VDD.t10 27.3978
R89 VDD.n624 VDD.t7 27.3978
R90 VDD.n1055 VDD.t137 25.6603
R91 VDD.n1054 VDD.t139 25.6603
R92 VDD.n454 VDD.t73 24.5138
R93 VDD.n473 VDD.t64 24.5138
R94 VDD.t4 VDD.n632 24.5138
R95 VDD.n1053 VDD.t141 24.3355
R96 VDD.n1052 VDD.t145 22.4442
R97 VDD.n1051 VDD.t147 22.4442
R98 VDD.n238 VDD.t81 21.9175
R99 VDD.n310 VDD.t78 21.9175
R100 VDD.n445 VDD.t76 21.6299
R101 VDD.n191 VDD.t61 21.6299
R102 VDD.n611 VDD.t16 21.6299
R103 VDD.n638 VDD.t1 21.6299
R104 VDD.t82 VDD.n433 18.746
R105 VDD.t19 VDD.n103 18.746
R106 VDD.n634 VDD.t79 18.746
R107 VDD.n576 VDD.t138 17.304
R108 VDD.n173 VDD.t55 15.8621
R109 VDD.n597 VDD.t22 15.8621
R110 VDD.t13 VDD.t136 14.4201
R111 VDD.n435 VDD.n228 14.0005
R112 VDD.n444 VDD.n228 14.0005
R113 VDD.n444 VDD.n221 14.0005
R114 VDD.n455 VDD.n221 14.0005
R115 VDD.n455 VDD.n210 14.0005
R116 VDD.n464 VDD.n210 14.0005
R117 VDD.n464 VDD.n203 14.0005
R118 VDD.n475 VDD.n203 14.0005
R119 VDD.n475 VDD.n192 14.0005
R120 VDD.n484 VDD.n192 14.0005
R121 VDD.n484 VDD.n185 14.0005
R122 VDD.n495 VDD.n185 14.0005
R123 VDD.n495 VDD.n174 14.0005
R124 VDD.n504 VDD.n174 14.0005
R125 VDD.n504 VDD.n167 14.0005
R126 VDD.n515 VDD.n167 14.0005
R127 VDD.n515 VDD.n156 14.0005
R128 VDD.n524 VDD.n156 14.0005
R129 VDD.n524 VDD.n149 14.0005
R130 VDD.n535 VDD.n149 14.0005
R131 VDD.n535 VDD.n137 14.0005
R132 VDD.n552 VDD.n137 14.0005
R133 VDD.n552 VDD.n138 14.0005
R134 VDD.n138 VDD.n129 14.0005
R135 VDD.n563 VDD.n129 14.0005
R136 VDD.n565 VDD.n563 14.0005
R137 VDD.n565 VDD.n564 14.0005
R138 VDD.n564 VDD.n9 14.0005
R139 VDD.n10 VDD.n9 14.0005
R140 VDD.n11 VDD.n10 14.0005
R141 VDD.n115 VDD.n11 14.0005
R142 VDD.n585 VDD.n115 14.0005
R143 VDD.n586 VDD.n585 14.0005
R144 VDD.n586 VDD.n28 14.0005
R145 VDD.n29 VDD.n28 14.0005
R146 VDD.n30 VDD.n29 14.0005
R147 VDD.n598 VDD.n30 14.0005
R148 VDD.n601 VDD.n598 14.0005
R149 VDD.n601 VDD.n599 14.0005
R150 VDD.n599 VDD.n47 14.0005
R151 VDD.n48 VDD.n47 14.0005
R152 VDD.n49 VDD.n48 14.0005
R153 VDD.n95 VDD.n49 14.0005
R154 VDD.n621 VDD.n95 14.0005
R155 VDD.n622 VDD.n621 14.0005
R156 VDD.n622 VDD.n66 14.0005
R157 VDD.n67 VDD.n66 14.0005
R158 VDD.n68 VDD.n67 14.0005
R159 VDD.n635 VDD.n68 14.0005
R160 VDD.n637 VDD.n635 14.0005
R161 VDD.n637 VDD.n82 14.0005
R162 VDD.n1062 VDD.n82 14.0005
R163 VDD.n431 VDD.n226 14.0005
R164 VDD.n446 VDD.n226 14.0005
R165 VDD.n446 VDD.n222 14.0005
R166 VDD.n452 VDD.n222 14.0005
R167 VDD.n452 VDD.n208 14.0005
R168 VDD.n466 VDD.n208 14.0005
R169 VDD.n466 VDD.n204 14.0005
R170 VDD.n472 VDD.n204 14.0005
R171 VDD.n472 VDD.n190 14.0005
R172 VDD.n486 VDD.n190 14.0005
R173 VDD.n486 VDD.n186 14.0005
R174 VDD.n492 VDD.n186 14.0005
R175 VDD.n492 VDD.n172 14.0005
R176 VDD.n506 VDD.n172 14.0005
R177 VDD.n506 VDD.n168 14.0005
R178 VDD.n512 VDD.n168 14.0005
R179 VDD.n512 VDD.n154 14.0005
R180 VDD.n526 VDD.n154 14.0005
R181 VDD.n526 VDD.n150 14.0005
R182 VDD.n532 VDD.n150 14.0005
R183 VDD.n532 VDD.n135 14.0005
R184 VDD.n554 VDD.n135 14.0005
R185 VDD.n554 VDD.n131 14.0005
R186 VDD.n560 VDD.n131 14.0005
R187 VDD.n560 VDD.n128 14.0005
R188 VDD.n567 VDD.n128 14.0005
R189 VDD.n567 VDD.n124 14.0005
R190 VDD.n573 VDD.n124 14.0005
R191 VDD.n573 VDD.n122 14.0005
R192 VDD.n577 VDD.n122 14.0005
R193 VDD.n577 VDD.n118 14.0005
R194 VDD.n583 VDD.n118 14.0005
R195 VDD.n583 VDD.n114 14.0005
R196 VDD.n589 VDD.n114 14.0005
R197 VDD.n589 VDD.n110 14.0005
R198 VDD.n595 VDD.n110 14.0005
R199 VDD.n595 VDD.n108 14.0005
R200 VDD.n603 VDD.n108 14.0005
R201 VDD.n603 VDD.n104 14.0005
R202 VDD.n609 VDD.n104 14.0005
R203 VDD.n609 VDD.n102 14.0005
R204 VDD.n613 VDD.n102 14.0005
R205 VDD.n613 VDD.n98 14.0005
R206 VDD.n619 VDD.n98 14.0005
R207 VDD.n619 VDD.n94 14.0005
R208 VDD.n625 VDD.n94 14.0005
R209 VDD.n625 VDD.n90 14.0005
R210 VDD.n631 VDD.n90 14.0005
R211 VDD.n631 VDD.n88 14.0005
R212 VDD.n639 VDD.n88 14.0005
R213 VDD.n639 VDD.n84 14.0005
R214 VDD.n1059 VDD.n84 14.0005
R215 VDD.n813 VDD.n810 14.0005
R216 VDD.n810 VDD.n647 14.0005
R217 VDD.n648 VDD.n647 14.0005
R218 VDD.n649 VDD.n648 14.0005
R219 VDD.n652 VDD.n649 14.0005
R220 VDD.n653 VDD.n652 14.0005
R221 VDD.n654 VDD.n653 14.0005
R222 VDD.n655 VDD.n654 14.0005
R223 VDD.n658 VDD.n655 14.0005
R224 VDD.n659 VDD.n658 14.0005
R225 VDD.n660 VDD.n659 14.0005
R226 VDD.n661 VDD.n660 14.0005
R227 VDD.n664 VDD.n661 14.0005
R228 VDD.n665 VDD.n664 14.0005
R229 VDD.n666 VDD.n665 14.0005
R230 VDD.n667 VDD.n666 14.0005
R231 VDD.n670 VDD.n667 14.0005
R232 VDD.n671 VDD.n670 14.0005
R233 VDD.n672 VDD.n671 14.0005
R234 VDD.n673 VDD.n672 14.0005
R235 VDD.n676 VDD.n673 14.0005
R236 VDD.n677 VDD.n676 14.0005
R237 VDD.n678 VDD.n677 14.0005
R238 VDD.n679 VDD.n678 14.0005
R239 VDD.n682 VDD.n679 14.0005
R240 VDD.n683 VDD.n682 14.0005
R241 VDD.n684 VDD.n683 14.0005
R242 VDD.n685 VDD.n684 14.0005
R243 VDD.n688 VDD.n685 14.0005
R244 VDD.n689 VDD.n688 14.0005
R245 VDD.n690 VDD.n689 14.0005
R246 VDD.n691 VDD.n690 14.0005
R247 VDD.n694 VDD.n691 14.0005
R248 VDD.n695 VDD.n694 14.0005
R249 VDD.n696 VDD.n695 14.0005
R250 VDD.n697 VDD.n696 14.0005
R251 VDD.n700 VDD.n697 14.0005
R252 VDD.n701 VDD.n700 14.0005
R253 VDD.n702 VDD.n701 14.0005
R254 VDD.n703 VDD.n702 14.0005
R255 VDD.n706 VDD.n703 14.0005
R256 VDD.n707 VDD.n706 14.0005
R257 VDD.n708 VDD.n707 14.0005
R258 VDD.n709 VDD.n708 14.0005
R259 VDD.n712 VDD.n709 14.0005
R260 VDD.n713 VDD.n712 14.0005
R261 VDD.n714 VDD.n713 14.0005
R262 VDD.n715 VDD.n714 14.0005
R263 VDD.n718 VDD.n715 14.0005
R264 VDD.n719 VDD.n718 14.0005
R265 VDD.n720 VDD.n719 14.0005
R266 VDD.n721 VDD.n720 14.0005
R267 VDD.n724 VDD.n721 14.0005
R268 VDD.n725 VDD.n724 14.0005
R269 VDD.n726 VDD.n725 14.0005
R270 VDD.n727 VDD.n726 14.0005
R271 VDD.n730 VDD.n727 14.0005
R272 VDD.n731 VDD.n730 14.0005
R273 VDD.n732 VDD.n731 14.0005
R274 VDD.n733 VDD.n732 14.0005
R275 VDD.n736 VDD.n733 14.0005
R276 VDD.n737 VDD.n736 14.0005
R277 VDD.n738 VDD.n737 14.0005
R278 VDD.n739 VDD.n738 14.0005
R279 VDD.n742 VDD.n739 14.0005
R280 VDD.n951 VDD.n742 14.0005
R281 VDD.n815 VDD.n807 14.0005
R282 VDD.n821 VDD.n807 14.0005
R283 VDD.n822 VDD.n821 14.0005
R284 VDD.n823 VDD.n822 14.0005
R285 VDD.n823 VDD.n803 14.0005
R286 VDD.n829 VDD.n803 14.0005
R287 VDD.n830 VDD.n829 14.0005
R288 VDD.n831 VDD.n830 14.0005
R289 VDD.n831 VDD.n799 14.0005
R290 VDD.n837 VDD.n799 14.0005
R291 VDD.n838 VDD.n837 14.0005
R292 VDD.n839 VDD.n838 14.0005
R293 VDD.n839 VDD.n795 14.0005
R294 VDD.n845 VDD.n795 14.0005
R295 VDD.n846 VDD.n845 14.0005
R296 VDD.n847 VDD.n846 14.0005
R297 VDD.n847 VDD.n791 14.0005
R298 VDD.n853 VDD.n791 14.0005
R299 VDD.n854 VDD.n853 14.0005
R300 VDD.n855 VDD.n854 14.0005
R301 VDD.n855 VDD.n787 14.0005
R302 VDD.n861 VDD.n787 14.0005
R303 VDD.n862 VDD.n861 14.0005
R304 VDD.n863 VDD.n862 14.0005
R305 VDD.n863 VDD.n783 14.0005
R306 VDD.n869 VDD.n783 14.0005
R307 VDD.n870 VDD.n869 14.0005
R308 VDD.n871 VDD.n870 14.0005
R309 VDD.n871 VDD.n779 14.0005
R310 VDD.n877 VDD.n779 14.0005
R311 VDD.n878 VDD.n877 14.0005
R312 VDD.n879 VDD.n878 14.0005
R313 VDD.n879 VDD.n775 14.0005
R314 VDD.n885 VDD.n775 14.0005
R315 VDD.n886 VDD.n885 14.0005
R316 VDD.n887 VDD.n886 14.0005
R317 VDD.n887 VDD.n771 14.0005
R318 VDD.n893 VDD.n771 14.0005
R319 VDD.n894 VDD.n893 14.0005
R320 VDD.n895 VDD.n894 14.0005
R321 VDD.n895 VDD.n767 14.0005
R322 VDD.n901 VDD.n767 14.0005
R323 VDD.n902 VDD.n901 14.0005
R324 VDD.n903 VDD.n902 14.0005
R325 VDD.n903 VDD.n763 14.0005
R326 VDD.n909 VDD.n763 14.0005
R327 VDD.n910 VDD.n909 14.0005
R328 VDD.n911 VDD.n910 14.0005
R329 VDD.n911 VDD.n759 14.0005
R330 VDD.n917 VDD.n759 14.0005
R331 VDD.n918 VDD.n917 14.0005
R332 VDD.n919 VDD.n918 14.0005
R333 VDD.n919 VDD.n755 14.0005
R334 VDD.n925 VDD.n755 14.0005
R335 VDD.n926 VDD.n925 14.0005
R336 VDD.n927 VDD.n926 14.0005
R337 VDD.n927 VDD.n751 14.0005
R338 VDD.n933 VDD.n751 14.0005
R339 VDD.n934 VDD.n933 14.0005
R340 VDD.n935 VDD.n934 14.0005
R341 VDD.n935 VDD.n747 14.0005
R342 VDD.n941 VDD.n747 14.0005
R343 VDD.n942 VDD.n941 14.0005
R344 VDD.n943 VDD.n942 14.0005
R345 VDD.n943 VDD.n743 14.0005
R346 VDD.n949 VDD.n743 14.0005
R347 VDD.t144 VDD.t58 12.9781
R348 VDD.n513 VDD.t52 12.9781
R349 VDD.t25 VDD.n109 12.9781
R350 VDD.n1051 VDD.n1050 12.8561
R351 VDD.n77 VDD.n76 12.5005
R352 VDD.n325 VDD.n324 12.5005
R353 VDD.n327 VDD.n326 12.5005
R354 VDD.n329 VDD.n328 12.5005
R355 VDD.n331 VDD.n330 12.5005
R356 VDD.n333 VDD.n332 12.5005
R357 VDD.n334 VDD.n302 12.5005
R358 VDD.n337 VDD.n336 12.5005
R359 VDD.n304 VDD.n301 12.5005
R360 VDD.n293 VDD.n292 12.5005
R361 VDD.n343 VDD.n342 12.5005
R362 VDD.n345 VDD.n291 12.5005
R363 VDD.n347 VDD.n346 12.5005
R364 VDD.n349 VDD.n348 12.5005
R365 VDD.n351 VDD.n350 12.5005
R366 VDD.n353 VDD.n352 12.5005
R367 VDD.n355 VDD.n354 12.5005
R368 VDD.n357 VDD.n356 12.5005
R369 VDD.n359 VDD.n358 12.5005
R370 VDD.n361 VDD.n360 12.5005
R371 VDD.n363 VDD.n362 12.5005
R372 VDD.n365 VDD.n364 12.5005
R373 VDD.n367 VDD.n366 12.5005
R374 VDD.n369 VDD.n368 12.5005
R375 VDD.n370 VDD.n277 12.5005
R376 VDD.n373 VDD.n372 12.5005
R377 VDD.n375 VDD.n374 12.5005
R378 VDD.n377 VDD.n376 12.5005
R379 VDD.n379 VDD.n378 12.5005
R380 VDD.n381 VDD.n380 12.5005
R381 VDD.n383 VDD.n382 12.5005
R382 VDD.n385 VDD.n384 12.5005
R383 VDD.n387 VDD.n386 12.5005
R384 VDD.n389 VDD.n388 12.5005
R385 VDD.n391 VDD.n390 12.5005
R386 VDD.n393 VDD.n392 12.5005
R387 VDD.n395 VDD.n394 12.5005
R388 VDD.n397 VDD.n396 12.5005
R389 VDD.n399 VDD.n398 12.5005
R390 VDD.n401 VDD.n400 12.5005
R391 VDD.n403 VDD.n402 12.5005
R392 VDD.n405 VDD.n404 12.5005
R393 VDD.n407 VDD.n406 12.5005
R394 VDD.n409 VDD.n408 12.5005
R395 VDD.n411 VDD.n410 12.5005
R396 VDD.n413 VDD.n412 12.5005
R397 VDD.n415 VDD.n414 12.5005
R398 VDD.n416 VDD.n241 12.5005
R399 VDD.n419 VDD.n418 12.5005
R400 VDD.n242 VDD.n240 12.5005
R401 VDD.n1068 VDD.n75 12.5005
R402 VDD.n1069 VDD.n73 12.5005
R403 VDD.n72 VDD.n64 12.5005
R404 VDD.n1073 VDD.n63 12.5005
R405 VDD.n62 VDD.n59 12.5005
R406 VDD.n60 VDD.n57 12.5005
R407 VDD.n1078 VDD.n56 12.5005
R408 VDD.n1079 VDD.n54 12.5005
R409 VDD.n53 VDD.n45 12.5005
R410 VDD.n1083 VDD.n44 12.5005
R411 VDD.n43 VDD.n40 12.5005
R412 VDD.n41 VDD.n38 12.5005
R413 VDD.n1088 VDD.n37 12.5005
R414 VDD.n1089 VDD.n35 12.5005
R415 VDD.n34 VDD.n26 12.5005
R416 VDD.n1093 VDD.n25 12.5005
R417 VDD.n24 VDD.n21 12.5005
R418 VDD.n22 VDD.n18 12.5005
R419 VDD.n1098 VDD.n17 12.5005
R420 VDD.n1099 VDD.n15 12.5005
R421 VDD.n14 VDD.n7 12.5005
R422 VDD.n1104 VDD.n1103 12.5005
R423 VDD.n1105 VDD.n3 12.5005
R424 VDD VDD.n1107 12.5005
R425 VDD.n542 VDD.n0 12.5005
R426 VDD.n545 VDD.n543 12.5005
R427 VDD.n540 VDD.n143 12.5005
R428 VDD.n550 VDD.n142 12.5005
R429 VDD.n146 VDD.n141 12.5005
R430 VDD.n537 VDD.n147 12.5005
R431 VDD.n160 VDD.n144 12.5005
R432 VDD.n522 VDD.n161 12.5005
R433 VDD.n164 VDD.n158 12.5005
R434 VDD.n517 VDD.n165 12.5005
R435 VDD.n178 VDD.n162 12.5005
R436 VDD.n502 VDD.n179 12.5005
R437 VDD.n182 VDD.n176 12.5005
R438 VDD.n497 VDD.n183 12.5005
R439 VDD.n196 VDD.n180 12.5005
R440 VDD.n482 VDD.n197 12.5005
R441 VDD.n200 VDD.n194 12.5005
R442 VDD.n477 VDD.n201 12.5005
R443 VDD.n214 VDD.n198 12.5005
R444 VDD.n462 VDD.n215 12.5005
R445 VDD.n218 VDD.n212 12.5005
R446 VDD.n457 VDD.n219 12.5005
R447 VDD.n232 VDD.n216 12.5005
R448 VDD.n442 VDD.n233 12.5005
R449 VDD.t146 VDD.n453 11.5362
R450 VDD.t2 VDD.n1065 11.4188
R451 VDD.t77 VDD.n439 11.4188
R452 VDD.n322 VDD.t85 11.4188
R453 VDD.n422 VDD.t135 11.4188
R454 VDD.n155 VDD.t49 10.0942
R455 VDD.n587 VDD.t28 10.0942
R456 VDD.t136 VDD.n97 10.0942
R457 VDD.n1056 VDD.n1055 9.9527
R458 VDD.n219 VDD.n218 9.86111
R459 VDD.n215 VDD.n214 9.86111
R460 VDD.n201 VDD.n200 9.86111
R461 VDD.n197 VDD.n196 9.86111
R462 VDD.n183 VDD.n182 9.86111
R463 VDD.n44 VDD.n43 9.86111
R464 VDD.n54 VDD.n53 9.86111
R465 VDD.n60 VDD.n56 9.86111
R466 VDD.n63 VDD.n62 9.86111
R467 VDD.n73 VDD.n72 9.86111
R468 VDD.n416 VDD.n415 9.86111
R469 VDD.n412 VDD.n411 9.86111
R470 VDD.n408 VDD.n407 9.86111
R471 VDD.n404 VDD.n403 9.86111
R472 VDD.n400 VDD.n399 9.86111
R473 VDD.n346 VDD.n345 9.86111
R474 VDD.n343 VDD.n292 9.86111
R475 VDD.n336 VDD.n304 9.86111
R476 VDD.n334 VDD.n333 9.86111
R477 VDD.n330 VDD.n329 9.86111
R478 VDD.n179 VDD.n178 9.55788
R479 VDD.n41 VDD.n37 9.55788
R480 VDD.n396 VDD.n395 9.55788
R481 VDD.n350 VDD.n349 9.55788
R482 VDD.n165 VDD.n164 9.25465
R483 VDD.n35 VDD.n34 9.25465
R484 VDD.n392 VDD.n391 9.25465
R485 VDD.n354 VDD.n353 9.25465
R486 VDD.n161 VDD.n160 8.95142
R487 VDD.n25 VDD.n24 8.95142
R488 VDD.n388 VDD.n387 8.95142
R489 VDD.n358 VDD.n357 8.95142
R490 VDD.n147 VDD.n146 8.64819
R491 VDD.n22 VDD.n17 8.64819
R492 VDD.n384 VDD.n383 8.64819
R493 VDD.n362 VDD.n361 8.64819
R494 VDD.n233 VDD.n232 8.45727
R495 VDD.n76 VDD.n75 8.45727
R496 VDD.n418 VDD.n242 8.45727
R497 VDD.n326 VDD.n325 8.45727
R498 VDD.n540 VDD.n142 8.34496
R499 VDD.n15 VDD.n14 8.34496
R500 VDD.n380 VDD.n379 8.34496
R501 VDD.n366 VDD.n365 8.34496
R502 VDD.n543 VDD.n542 8.04173
R503 VDD.n1105 VDD.n1104 8.04173
R504 VDD.n376 VDD.n375 8.04173
R505 VDD.n370 VDD.n369 8.04173
R506 VDD.n1107 VDD.n4 7.59812
R507 VDD.n1107 VDD.n1106 7.59812
R508 VDD.n372 VDD.n264 7.59812
R509 VDD.n372 VDD.n371 7.59812
R510 VDD.n233 VDD.t75 7.5925
R511 VDD.n76 VDD.t0 7.5925
R512 VDD.n242 VDD.t134 7.5925
R513 VDD.n325 VDD.t84 7.5925
R514 VDD.n1067 VDD.n1066 7.53568
R515 VDD.n1075 VDD.n1074 7.53568
R516 VDD.n58 VDD.n51 7.53568
R517 VDD.n1087 VDD.n1086 7.53568
R518 VDD.n1095 VDD.n1094 7.53568
R519 VDD.n20 VDD.n13 7.53568
R520 VDD VDD.n2 7.53568
R521 VDD.n549 VDD.n548 7.53568
R522 VDD.n521 VDD.n520 7.53568
R523 VDD.n501 VDD.n500 7.53568
R524 VDD.n481 VDD.n480 7.53568
R525 VDD.n461 VDD.n460 7.53568
R526 VDD.n441 VDD.n440 7.53568
R527 VDD.n321 VDD.n309 7.53568
R528 VDD.n319 VDD.n306 7.53568
R529 VDD.n341 VDD.n340 7.53568
R530 VDD.n299 VDD.n288 7.53568
R531 VDD.n297 VDD.n284 7.53568
R532 VDD.n295 VDD.n280 7.53568
R533 VDD.n373 VDD.n276 7.53568
R534 VDD.n274 VDD.n261 7.53568
R535 VDD.n272 VDD.n257 7.53568
R536 VDD.n270 VDD.n253 7.53568
R537 VDD.n268 VDD.n249 7.53568
R538 VDD.n266 VDD.n245 7.53568
R539 VDD.n421 VDD.n420 7.53568
R540 VDD.n78 VDD.n70 7.49884
R541 VDD.n1077 VDD.n1076 7.49884
R542 VDD.n1085 VDD.n1084 7.49884
R543 VDD.n39 VDD.n32 7.49884
R544 VDD.n1097 VDD.n1096 7.49884
R545 VDD.n19 VDD.n6 7.49884
R546 VDD.n547 VDD.n546 7.49884
R547 VDD.n539 VDD.n538 7.49884
R548 VDD.n519 VDD.n518 7.49884
R549 VDD.n499 VDD.n498 7.49884
R550 VDD.n479 VDD.n478 7.49884
R551 VDD.n459 VDD.n458 7.49884
R552 VDD.n320 VDD.n307 7.49884
R553 VDD.n339 VDD.n338 7.49884
R554 VDD.n300 VDD.n290 7.49884
R555 VDD.n298 VDD.n286 7.49884
R556 VDD.n296 VDD.n282 7.49884
R557 VDD.n294 VDD.n279 7.49884
R558 VDD.n275 VDD.n263 7.49884
R559 VDD.n273 VDD.n259 7.49884
R560 VDD.n271 VDD.n255 7.49884
R561 VDD.n269 VDD.n251 7.49884
R562 VDD.n267 VDD.n247 7.49884
R563 VDD.n265 VDD.n244 7.49884
R564 VDD.n533 VDD.t46 7.21031
R565 VDD.t31 VDD.n117 7.21031
R566 VDD.n236 VDD.t83 7.1605
R567 VDD.n424 VDD.t83 7.1605
R568 VDD.t80 VDD.n316 7.1605
R569 VDD.n317 VDD.t80 7.1605
R570 VDD.n543 VDD.n541 7.01412
R571 VDD.n1104 VDD.n5 7.01412
R572 VDD.n376 VDD.n262 7.01412
R573 VDD.n369 VDD.n278 7.01412
R574 VDD.n953 VDD.n741 6.49189
R575 VDD.n947 VDD.n741 6.49189
R576 VDD.n817 VDD.n809 6.49189
R577 VDD.n811 VDD.n809 6.49189
R578 VDD.n145 VDD.n142 6.43012
R579 VDD.n16 VDD.n15 6.43012
R580 VDD.n380 VDD.n260 6.43012
R581 VDD.n365 VDD.n281 6.43012
R582 VDD.n436 VDD.n435 6.3005
R583 VDD.n435 VDD.n434 6.3005
R584 VDD.n229 VDD.n228 6.3005
R585 VDD.n433 VDD.n228 6.3005
R586 VDD.n444 VDD.n443 6.3005
R587 VDD.n445 VDD.n444 6.3005
R588 VDD.n221 VDD.n220 6.3005
R589 VDD.n227 VDD.n221 6.3005
R590 VDD.n456 VDD.n455 6.3005
R591 VDD.n455 VDD.n454 6.3005
R592 VDD.n211 VDD.n210 6.3005
R593 VDD.n453 VDD.n210 6.3005
R594 VDD.n464 VDD.n463 6.3005
R595 VDD.n465 VDD.n464 6.3005
R596 VDD.n203 VDD.n202 6.3005
R597 VDD.n209 VDD.n203 6.3005
R598 VDD.n476 VDD.n475 6.3005
R599 VDD.n475 VDD.n474 6.3005
R600 VDD.n193 VDD.n192 6.3005
R601 VDD.n473 VDD.n192 6.3005
R602 VDD.n484 VDD.n483 6.3005
R603 VDD.n485 VDD.n484 6.3005
R604 VDD.n185 VDD.n184 6.3005
R605 VDD.n191 VDD.n185 6.3005
R606 VDD.n496 VDD.n495 6.3005
R607 VDD.n495 VDD.n494 6.3005
R608 VDD.n175 VDD.n174 6.3005
R609 VDD.n493 VDD.n174 6.3005
R610 VDD.n504 VDD.n503 6.3005
R611 VDD.n505 VDD.n504 6.3005
R612 VDD.n167 VDD.n166 6.3005
R613 VDD.n173 VDD.n167 6.3005
R614 VDD.n516 VDD.n515 6.3005
R615 VDD.n515 VDD.n514 6.3005
R616 VDD.n157 VDD.n156 6.3005
R617 VDD.n513 VDD.n156 6.3005
R618 VDD.n524 VDD.n523 6.3005
R619 VDD.n525 VDD.n524 6.3005
R620 VDD.n149 VDD.n148 6.3005
R621 VDD.n155 VDD.n149 6.3005
R622 VDD.n536 VDD.n535 6.3005
R623 VDD.n535 VDD.n534 6.3005
R624 VDD.n139 VDD.n137 6.3005
R625 VDD.n533 VDD.n137 6.3005
R626 VDD.n552 VDD.n551 6.3005
R627 VDD.n553 VDD.n552 6.3005
R628 VDD.n140 VDD.n138 6.3005
R629 VDD.n138 VDD.n136 6.3005
R630 VDD.n544 VDD.n129 6.3005
R631 VDD.n561 VDD.n129 6.3005
R632 VDD.n563 VDD.n130 6.3005
R633 VDD.n563 VDD.n562 6.3005
R634 VDD.n565 VDD.n1 6.3005
R635 VDD.n566 VDD.n565 6.3005
R636 VDD.n564 VDD.n8 6.3005
R637 VDD.n564 VDD.n123 6.3005
R638 VDD.n1102 VDD.n9 6.3005
R639 VDD.n574 VDD.n9 6.3005
R640 VDD.n1101 VDD.n10 6.3005
R641 VDD.n575 VDD.n10 6.3005
R642 VDD.n1100 VDD.n11 6.3005
R643 VDD.n576 VDD.n11 6.3005
R644 VDD.n115 VDD.n12 6.3005
R645 VDD.n117 VDD.n115 6.3005
R646 VDD.n585 VDD.n116 6.3005
R647 VDD.n585 VDD.n584 6.3005
R648 VDD.n586 VDD.n27 6.3005
R649 VDD.n587 VDD.n586 6.3005
R650 VDD.n1092 VDD.n28 6.3005
R651 VDD.n588 VDD.n28 6.3005
R652 VDD.n1091 VDD.n29 6.3005
R653 VDD.n109 VDD.n29 6.3005
R654 VDD.n1090 VDD.n30 6.3005
R655 VDD.n596 VDD.n30 6.3005
R656 VDD.n598 VDD.n31 6.3005
R657 VDD.n598 VDD.n597 6.3005
R658 VDD.n601 VDD.n600 6.3005
R659 VDD.n602 VDD.n601 6.3005
R660 VDD.n599 VDD.n46 6.3005
R661 VDD.n599 VDD.n103 6.3005
R662 VDD.n1082 VDD.n47 6.3005
R663 VDD.n610 VDD.n47 6.3005
R664 VDD.n1081 VDD.n48 6.3005
R665 VDD.n611 VDD.n48 6.3005
R666 VDD.n1080 VDD.n49 6.3005
R667 VDD.n612 VDD.n49 6.3005
R668 VDD.n95 VDD.n50 6.3005
R669 VDD.n97 VDD.n95 6.3005
R670 VDD.n621 VDD.n96 6.3005
R671 VDD.n621 VDD.n620 6.3005
R672 VDD.n622 VDD.n65 6.3005
R673 VDD.n623 VDD.n622 6.3005
R674 VDD.n1072 VDD.n66 6.3005
R675 VDD.n624 VDD.n66 6.3005
R676 VDD.n1071 VDD.n67 6.3005
R677 VDD.n89 VDD.n67 6.3005
R678 VDD.n1070 VDD.n68 6.3005
R679 VDD.n632 VDD.n68 6.3005
R680 VDD.n635 VDD.n69 6.3005
R681 VDD.n635 VDD.n633 6.3005
R682 VDD.n637 VDD.n636 6.3005
R683 VDD.n638 VDD.n637 6.3005
R684 VDD.n82 VDD.n81 6.3005
R685 VDD.n634 VDD.n82 6.3005
R686 VDD.n1063 VDD.n1062 6.3005
R687 VDD.n1062 VDD.n1061 6.3005
R688 VDD.n1059 VDD.n1058 6.3005
R689 VDD.n85 VDD.n84 6.3005
R690 VDD.n634 VDD.n84 6.3005
R691 VDD.n640 VDD.n639 6.3005
R692 VDD.n639 VDD.n638 6.3005
R693 VDD.n88 VDD.n87 6.3005
R694 VDD.n633 VDD.n88 6.3005
R695 VDD.n631 VDD.n630 6.3005
R696 VDD.n632 VDD.n631 6.3005
R697 VDD.n91 VDD.n90 6.3005
R698 VDD.n90 VDD.n89 6.3005
R699 VDD.n626 VDD.n625 6.3005
R700 VDD.n625 VDD.n624 6.3005
R701 VDD.n94 VDD.n93 6.3005
R702 VDD.n623 VDD.n94 6.3005
R703 VDD.n619 VDD.n618 6.3005
R704 VDD.n620 VDD.n619 6.3005
R705 VDD.n99 VDD.n98 6.3005
R706 VDD.n98 VDD.n97 6.3005
R707 VDD.n614 VDD.n613 6.3005
R708 VDD.n613 VDD.n612 6.3005
R709 VDD.n102 VDD.n101 6.3005
R710 VDD.n611 VDD.n102 6.3005
R711 VDD.n609 VDD.n608 6.3005
R712 VDD.n610 VDD.n609 6.3005
R713 VDD.n105 VDD.n104 6.3005
R714 VDD.n104 VDD.n103 6.3005
R715 VDD.n604 VDD.n603 6.3005
R716 VDD.n603 VDD.n602 6.3005
R717 VDD.n108 VDD.n107 6.3005
R718 VDD.n597 VDD.n108 6.3005
R719 VDD.n595 VDD.n594 6.3005
R720 VDD.n596 VDD.n595 6.3005
R721 VDD.n111 VDD.n110 6.3005
R722 VDD.n110 VDD.n109 6.3005
R723 VDD.n590 VDD.n589 6.3005
R724 VDD.n589 VDD.n588 6.3005
R725 VDD.n114 VDD.n113 6.3005
R726 VDD.n587 VDD.n114 6.3005
R727 VDD.n583 VDD.n582 6.3005
R728 VDD.n584 VDD.n583 6.3005
R729 VDD.n119 VDD.n118 6.3005
R730 VDD.n118 VDD.n117 6.3005
R731 VDD.n578 VDD.n577 6.3005
R732 VDD.n577 VDD.n576 6.3005
R733 VDD.n122 VDD.n121 6.3005
R734 VDD.n575 VDD.n122 6.3005
R735 VDD.n573 VDD.n572 6.3005
R736 VDD.n574 VDD.n573 6.3005
R737 VDD.n125 VDD.n124 6.3005
R738 VDD.n124 VDD.n123 6.3005
R739 VDD.n568 VDD.n567 6.3005
R740 VDD.n567 VDD.n566 6.3005
R741 VDD.n128 VDD.n127 6.3005
R742 VDD.n562 VDD.n128 6.3005
R743 VDD.n560 VDD.n559 6.3005
R744 VDD.n561 VDD.n560 6.3005
R745 VDD.n132 VDD.n131 6.3005
R746 VDD.n136 VDD.n131 6.3005
R747 VDD.n555 VDD.n554 6.3005
R748 VDD.n554 VDD.n553 6.3005
R749 VDD.n135 VDD.n134 6.3005
R750 VDD.n533 VDD.n135 6.3005
R751 VDD.n532 VDD.n531 6.3005
R752 VDD.n534 VDD.n532 6.3005
R753 VDD.n151 VDD.n150 6.3005
R754 VDD.n155 VDD.n150 6.3005
R755 VDD.n527 VDD.n526 6.3005
R756 VDD.n526 VDD.n525 6.3005
R757 VDD.n154 VDD.n153 6.3005
R758 VDD.n513 VDD.n154 6.3005
R759 VDD.n512 VDD.n511 6.3005
R760 VDD.n514 VDD.n512 6.3005
R761 VDD.n169 VDD.n168 6.3005
R762 VDD.n173 VDD.n168 6.3005
R763 VDD.n507 VDD.n506 6.3005
R764 VDD.n506 VDD.n505 6.3005
R765 VDD.n172 VDD.n171 6.3005
R766 VDD.n493 VDD.n172 6.3005
R767 VDD.n492 VDD.n491 6.3005
R768 VDD.n494 VDD.n492 6.3005
R769 VDD.n187 VDD.n186 6.3005
R770 VDD.n191 VDD.n186 6.3005
R771 VDD.n487 VDD.n486 6.3005
R772 VDD.n486 VDD.n485 6.3005
R773 VDD.n190 VDD.n189 6.3005
R774 VDD.n473 VDD.n190 6.3005
R775 VDD.n472 VDD.n471 6.3005
R776 VDD.n474 VDD.n472 6.3005
R777 VDD.n205 VDD.n204 6.3005
R778 VDD.n209 VDD.n204 6.3005
R779 VDD.n467 VDD.n466 6.3005
R780 VDD.n466 VDD.n465 6.3005
R781 VDD.n208 VDD.n207 6.3005
R782 VDD.n453 VDD.n208 6.3005
R783 VDD.n452 VDD.n451 6.3005
R784 VDD.n454 VDD.n452 6.3005
R785 VDD.n223 VDD.n222 6.3005
R786 VDD.n227 VDD.n222 6.3005
R787 VDD.n447 VDD.n446 6.3005
R788 VDD.n446 VDD.n445 6.3005
R789 VDD.n226 VDD.n225 6.3005
R790 VDD.n433 VDD.n226 6.3005
R791 VDD.n431 VDD.n430 6.3005
R792 VDD.n952 VDD.n951 6.3005
R793 VDD.n742 VDD.n740 6.3005
R794 VDD.n956 VDD.n739 6.3005
R795 VDD.n957 VDD.n738 6.3005
R796 VDD.n958 VDD.n737 6.3005
R797 VDD.n736 VDD.n734 6.3005
R798 VDD.n962 VDD.n733 6.3005
R799 VDD.n963 VDD.n732 6.3005
R800 VDD.n964 VDD.n731 6.3005
R801 VDD.n730 VDD.n728 6.3005
R802 VDD.n968 VDD.n727 6.3005
R803 VDD.n969 VDD.n726 6.3005
R804 VDD.n970 VDD.n725 6.3005
R805 VDD.n724 VDD.n722 6.3005
R806 VDD.n974 VDD.n721 6.3005
R807 VDD.n975 VDD.n720 6.3005
R808 VDD.n976 VDD.n719 6.3005
R809 VDD.n718 VDD.n716 6.3005
R810 VDD.n980 VDD.n715 6.3005
R811 VDD.n981 VDD.n714 6.3005
R812 VDD.n982 VDD.n713 6.3005
R813 VDD.n712 VDD.n710 6.3005
R814 VDD.n986 VDD.n709 6.3005
R815 VDD.n987 VDD.n708 6.3005
R816 VDD.n988 VDD.n707 6.3005
R817 VDD.n706 VDD.n704 6.3005
R818 VDD.n992 VDD.n703 6.3005
R819 VDD.n993 VDD.n702 6.3005
R820 VDD.n994 VDD.n701 6.3005
R821 VDD.n700 VDD.n698 6.3005
R822 VDD.n998 VDD.n697 6.3005
R823 VDD.n999 VDD.n696 6.3005
R824 VDD.n1000 VDD.n695 6.3005
R825 VDD.n694 VDD.n692 6.3005
R826 VDD.n1004 VDD.n691 6.3005
R827 VDD.n1005 VDD.n690 6.3005
R828 VDD.n1006 VDD.n689 6.3005
R829 VDD.n688 VDD.n686 6.3005
R830 VDD.n1010 VDD.n685 6.3005
R831 VDD.n1011 VDD.n684 6.3005
R832 VDD.n1012 VDD.n683 6.3005
R833 VDD.n682 VDD.n680 6.3005
R834 VDD.n1016 VDD.n679 6.3005
R835 VDD.n1017 VDD.n678 6.3005
R836 VDD.n1018 VDD.n677 6.3005
R837 VDD.n676 VDD.n674 6.3005
R838 VDD.n1022 VDD.n673 6.3005
R839 VDD.n1023 VDD.n672 6.3005
R840 VDD.n1024 VDD.n671 6.3005
R841 VDD.n670 VDD.n668 6.3005
R842 VDD.n1028 VDD.n667 6.3005
R843 VDD.n1029 VDD.n666 6.3005
R844 VDD.n1030 VDD.n665 6.3005
R845 VDD.n664 VDD.n662 6.3005
R846 VDD.n1034 VDD.n661 6.3005
R847 VDD.n1035 VDD.n660 6.3005
R848 VDD.n1036 VDD.n659 6.3005
R849 VDD.n658 VDD.n656 6.3005
R850 VDD.n1040 VDD.n655 6.3005
R851 VDD.n1041 VDD.n654 6.3005
R852 VDD.n1042 VDD.n653 6.3005
R853 VDD.n652 VDD.n650 6.3005
R854 VDD.n1046 VDD.n649 6.3005
R855 VDD.n1047 VDD.n648 6.3005
R856 VDD.n1048 VDD.n647 6.3005
R857 VDD.n810 VDD.n646 6.3005
R858 VDD.n813 VDD.n812 6.3005
R859 VDD.n949 VDD.n948 6.3005
R860 VDD.n744 VDD.n743 6.3005
R861 VDD.n944 VDD.n943 6.3005
R862 VDD.n942 VDD.n746 6.3005
R863 VDD.n941 VDD.n940 6.3005
R864 VDD.n748 VDD.n747 6.3005
R865 VDD.n936 VDD.n935 6.3005
R866 VDD.n934 VDD.n750 6.3005
R867 VDD.n933 VDD.n932 6.3005
R868 VDD.n752 VDD.n751 6.3005
R869 VDD.n928 VDD.n927 6.3005
R870 VDD.n926 VDD.n754 6.3005
R871 VDD.n925 VDD.n924 6.3005
R872 VDD.n756 VDD.n755 6.3005
R873 VDD.n920 VDD.n919 6.3005
R874 VDD.n918 VDD.n758 6.3005
R875 VDD.n917 VDD.n916 6.3005
R876 VDD.n760 VDD.n759 6.3005
R877 VDD.n912 VDD.n911 6.3005
R878 VDD.n910 VDD.n762 6.3005
R879 VDD.n909 VDD.n908 6.3005
R880 VDD.n764 VDD.n763 6.3005
R881 VDD.n904 VDD.n903 6.3005
R882 VDD.n902 VDD.n766 6.3005
R883 VDD.n901 VDD.n900 6.3005
R884 VDD.n768 VDD.n767 6.3005
R885 VDD.n896 VDD.n895 6.3005
R886 VDD.n894 VDD.n770 6.3005
R887 VDD.n893 VDD.n892 6.3005
R888 VDD.n772 VDD.n771 6.3005
R889 VDD.n888 VDD.n887 6.3005
R890 VDD.n886 VDD.n774 6.3005
R891 VDD.n885 VDD.n884 6.3005
R892 VDD.n776 VDD.n775 6.3005
R893 VDD.n880 VDD.n879 6.3005
R894 VDD.n878 VDD.n778 6.3005
R895 VDD.n877 VDD.n876 6.3005
R896 VDD.n780 VDD.n779 6.3005
R897 VDD.n872 VDD.n871 6.3005
R898 VDD.n870 VDD.n782 6.3005
R899 VDD.n869 VDD.n868 6.3005
R900 VDD.n784 VDD.n783 6.3005
R901 VDD.n864 VDD.n863 6.3005
R902 VDD.n862 VDD.n786 6.3005
R903 VDD.n861 VDD.n860 6.3005
R904 VDD.n788 VDD.n787 6.3005
R905 VDD.n856 VDD.n855 6.3005
R906 VDD.n854 VDD.n790 6.3005
R907 VDD.n853 VDD.n852 6.3005
R908 VDD.n792 VDD.n791 6.3005
R909 VDD.n848 VDD.n847 6.3005
R910 VDD.n846 VDD.n794 6.3005
R911 VDD.n845 VDD.n844 6.3005
R912 VDD.n796 VDD.n795 6.3005
R913 VDD.n840 VDD.n839 6.3005
R914 VDD.n838 VDD.n798 6.3005
R915 VDD.n837 VDD.n836 6.3005
R916 VDD.n800 VDD.n799 6.3005
R917 VDD.n832 VDD.n831 6.3005
R918 VDD.n830 VDD.n802 6.3005
R919 VDD.n829 VDD.n828 6.3005
R920 VDD.n804 VDD.n803 6.3005
R921 VDD.n824 VDD.n823 6.3005
R922 VDD.n822 VDD.n806 6.3005
R923 VDD.n821 VDD.n820 6.3005
R924 VDD.n808 VDD.n807 6.3005
R925 VDD.n816 VDD.n815 6.3005
R926 VDD.n429 VDD.n428 6.05214
R927 VDD.n643 VDD.n80 6.02514
R928 VDD.n428 VDD.n426 6.02514
R929 VDD.n1056 VDD.n643 5.87394
R930 VDD.n159 VDD.n147 5.84612
R931 VDD.n23 VDD.n22 5.84612
R932 VDD.n384 VDD.n258 5.84612
R933 VDD.n361 VDD.n283 5.84612
R934 VDD.n493 VDD.t144 5.76834
R935 VDD.n163 VDD.n161 5.26212
R936 VDD.n33 VDD.n25 5.26212
R937 VDD.n388 VDD.n256 5.26212
R938 VDD.n357 VDD.n285 5.26212
R939 VDD.n425 VDD.n424 4.90354
R940 VDD.n316 VDD.n314 4.90354
R941 VDD.n236 VDD.n235 4.74702
R942 VDD.n317 VDD.n312 4.74702
R943 VDD.n177 VDD.n165 4.67812
R944 VDD.n36 VDD.n35 4.67812
R945 VDD.n392 VDD.n254 4.67812
R946 VDD.n353 VDD.n287 4.67812
R947 VDD.n818 VDD.n808 4.5005
R948 VDD.n820 VDD.n819 4.5005
R949 VDD.n806 VDD.n805 4.5005
R950 VDD.n825 VDD.n824 4.5005
R951 VDD.n826 VDD.n804 4.5005
R952 VDD.n828 VDD.n827 4.5005
R953 VDD.n802 VDD.n801 4.5005
R954 VDD.n833 VDD.n832 4.5005
R955 VDD.n834 VDD.n800 4.5005
R956 VDD.n836 VDD.n835 4.5005
R957 VDD.n798 VDD.n797 4.5005
R958 VDD.n841 VDD.n840 4.5005
R959 VDD.n842 VDD.n796 4.5005
R960 VDD.n844 VDD.n843 4.5005
R961 VDD.n794 VDD.n793 4.5005
R962 VDD.n849 VDD.n848 4.5005
R963 VDD.n850 VDD.n792 4.5005
R964 VDD.n852 VDD.n851 4.5005
R965 VDD.n790 VDD.n789 4.5005
R966 VDD.n857 VDD.n856 4.5005
R967 VDD.n858 VDD.n788 4.5005
R968 VDD.n860 VDD.n859 4.5005
R969 VDD.n786 VDD.n785 4.5005
R970 VDD.n865 VDD.n864 4.5005
R971 VDD.n866 VDD.n784 4.5005
R972 VDD.n868 VDD.n867 4.5005
R973 VDD.n782 VDD.n781 4.5005
R974 VDD.n873 VDD.n872 4.5005
R975 VDD.n874 VDD.n780 4.5005
R976 VDD.n876 VDD.n875 4.5005
R977 VDD.n778 VDD.n777 4.5005
R978 VDD.n881 VDD.n880 4.5005
R979 VDD.n882 VDD.n776 4.5005
R980 VDD.n884 VDD.n883 4.5005
R981 VDD.n774 VDD.n773 4.5005
R982 VDD.n889 VDD.n888 4.5005
R983 VDD.n890 VDD.n772 4.5005
R984 VDD.n892 VDD.n891 4.5005
R985 VDD.n770 VDD.n769 4.5005
R986 VDD.n897 VDD.n896 4.5005
R987 VDD.n898 VDD.n768 4.5005
R988 VDD.n900 VDD.n899 4.5005
R989 VDD.n766 VDD.n765 4.5005
R990 VDD.n905 VDD.n904 4.5005
R991 VDD.n906 VDD.n764 4.5005
R992 VDD.n908 VDD.n907 4.5005
R993 VDD.n762 VDD.n761 4.5005
R994 VDD.n913 VDD.n912 4.5005
R995 VDD.n914 VDD.n760 4.5005
R996 VDD.n916 VDD.n915 4.5005
R997 VDD.n758 VDD.n757 4.5005
R998 VDD.n921 VDD.n920 4.5005
R999 VDD.n922 VDD.n756 4.5005
R1000 VDD.n924 VDD.n923 4.5005
R1001 VDD.n754 VDD.n753 4.5005
R1002 VDD.n929 VDD.n928 4.5005
R1003 VDD.n930 VDD.n752 4.5005
R1004 VDD.n932 VDD.n931 4.5005
R1005 VDD.n750 VDD.n749 4.5005
R1006 VDD.n937 VDD.n936 4.5005
R1007 VDD.n938 VDD.n748 4.5005
R1008 VDD.n940 VDD.n939 4.5005
R1009 VDD.n746 VDD.n745 4.5005
R1010 VDD.n945 VDD.n944 4.5005
R1011 VDD.n946 VDD.n744 4.5005
R1012 VDD.n948 VDD.n947 4.5005
R1013 VDD.n817 VDD.n816 4.5005
R1014 VDD.n646 VDD.n644 4.5005
R1015 VDD.n1049 VDD.n1048 4.5005
R1016 VDD.n1047 VDD.n645 4.5005
R1017 VDD.n1046 VDD.n1045 4.5005
R1018 VDD.n1044 VDD.n650 4.5005
R1019 VDD.n1043 VDD.n1042 4.5005
R1020 VDD.n1041 VDD.n651 4.5005
R1021 VDD.n1040 VDD.n1039 4.5005
R1022 VDD.n1038 VDD.n656 4.5005
R1023 VDD.n1037 VDD.n1036 4.5005
R1024 VDD.n1035 VDD.n657 4.5005
R1025 VDD.n1034 VDD.n1033 4.5005
R1026 VDD.n1032 VDD.n662 4.5005
R1027 VDD.n1031 VDD.n1030 4.5005
R1028 VDD.n1029 VDD.n663 4.5005
R1029 VDD.n1028 VDD.n1027 4.5005
R1030 VDD.n1026 VDD.n668 4.5005
R1031 VDD.n1025 VDD.n1024 4.5005
R1032 VDD.n1023 VDD.n669 4.5005
R1033 VDD.n1022 VDD.n1021 4.5005
R1034 VDD.n1020 VDD.n674 4.5005
R1035 VDD.n1019 VDD.n1018 4.5005
R1036 VDD.n1017 VDD.n675 4.5005
R1037 VDD.n1016 VDD.n1015 4.5005
R1038 VDD.n1014 VDD.n680 4.5005
R1039 VDD.n1013 VDD.n1012 4.5005
R1040 VDD.n1011 VDD.n681 4.5005
R1041 VDD.n1010 VDD.n1009 4.5005
R1042 VDD.n1008 VDD.n686 4.5005
R1043 VDD.n1007 VDD.n1006 4.5005
R1044 VDD.n1005 VDD.n687 4.5005
R1045 VDD.n1004 VDD.n1003 4.5005
R1046 VDD.n1002 VDD.n692 4.5005
R1047 VDD.n1001 VDD.n1000 4.5005
R1048 VDD.n999 VDD.n693 4.5005
R1049 VDD.n998 VDD.n997 4.5005
R1050 VDD.n996 VDD.n698 4.5005
R1051 VDD.n995 VDD.n994 4.5005
R1052 VDD.n993 VDD.n699 4.5005
R1053 VDD.n992 VDD.n991 4.5005
R1054 VDD.n990 VDD.n704 4.5005
R1055 VDD.n989 VDD.n988 4.5005
R1056 VDD.n987 VDD.n705 4.5005
R1057 VDD.n986 VDD.n985 4.5005
R1058 VDD.n984 VDD.n710 4.5005
R1059 VDD.n983 VDD.n982 4.5005
R1060 VDD.n981 VDD.n711 4.5005
R1061 VDD.n980 VDD.n979 4.5005
R1062 VDD.n978 VDD.n716 4.5005
R1063 VDD.n977 VDD.n976 4.5005
R1064 VDD.n975 VDD.n717 4.5005
R1065 VDD.n974 VDD.n973 4.5005
R1066 VDD.n972 VDD.n722 4.5005
R1067 VDD.n971 VDD.n970 4.5005
R1068 VDD.n969 VDD.n723 4.5005
R1069 VDD.n968 VDD.n967 4.5005
R1070 VDD.n966 VDD.n728 4.5005
R1071 VDD.n965 VDD.n964 4.5005
R1072 VDD.n963 VDD.n729 4.5005
R1073 VDD.n962 VDD.n961 4.5005
R1074 VDD.n960 VDD.n734 4.5005
R1075 VDD.n959 VDD.n958 4.5005
R1076 VDD.n957 VDD.n735 4.5005
R1077 VDD.n956 VDD.n955 4.5005
R1078 VDD.n954 VDD.n740 4.5005
R1079 VDD.n953 VDD.n952 4.5005
R1080 VDD.n812 VDD.n811 4.5005
R1081 VDD.n225 VDD.n224 4.5005
R1082 VDD.n448 VDD.n447 4.5005
R1083 VDD.n449 VDD.n223 4.5005
R1084 VDD.n451 VDD.n450 4.5005
R1085 VDD.n207 VDD.n206 4.5005
R1086 VDD.n468 VDD.n467 4.5005
R1087 VDD.n469 VDD.n205 4.5005
R1088 VDD.n471 VDD.n470 4.5005
R1089 VDD.n189 VDD.n188 4.5005
R1090 VDD.n488 VDD.n487 4.5005
R1091 VDD.n489 VDD.n187 4.5005
R1092 VDD.n491 VDD.n490 4.5005
R1093 VDD.n171 VDD.n170 4.5005
R1094 VDD.n508 VDD.n507 4.5005
R1095 VDD.n509 VDD.n169 4.5005
R1096 VDD.n511 VDD.n510 4.5005
R1097 VDD.n153 VDD.n152 4.5005
R1098 VDD.n528 VDD.n527 4.5005
R1099 VDD.n529 VDD.n151 4.5005
R1100 VDD.n531 VDD.n530 4.5005
R1101 VDD.n134 VDD.n133 4.5005
R1102 VDD.n556 VDD.n555 4.5005
R1103 VDD.n557 VDD.n132 4.5005
R1104 VDD.n559 VDD.n558 4.5005
R1105 VDD.n127 VDD.n126 4.5005
R1106 VDD.n569 VDD.n568 4.5005
R1107 VDD.n570 VDD.n125 4.5005
R1108 VDD.n572 VDD.n571 4.5005
R1109 VDD.n121 VDD.n120 4.5005
R1110 VDD.n579 VDD.n578 4.5005
R1111 VDD.n580 VDD.n119 4.5005
R1112 VDD.n582 VDD.n581 4.5005
R1113 VDD.n113 VDD.n112 4.5005
R1114 VDD.n591 VDD.n590 4.5005
R1115 VDD.n592 VDD.n111 4.5005
R1116 VDD.n594 VDD.n593 4.5005
R1117 VDD.n107 VDD.n106 4.5005
R1118 VDD.n605 VDD.n604 4.5005
R1119 VDD.n606 VDD.n105 4.5005
R1120 VDD.n608 VDD.n607 4.5005
R1121 VDD.n101 VDD.n100 4.5005
R1122 VDD.n615 VDD.n614 4.5005
R1123 VDD.n616 VDD.n99 4.5005
R1124 VDD.n618 VDD.n617 4.5005
R1125 VDD.n93 VDD.n92 4.5005
R1126 VDD.n627 VDD.n626 4.5005
R1127 VDD.n628 VDD.n91 4.5005
R1128 VDD.n630 VDD.n629 4.5005
R1129 VDD.n87 VDD.n86 4.5005
R1130 VDD.n641 VDD.n640 4.5005
R1131 VDD.n642 VDD.n85 4.5005
R1132 VDD.n1058 VDD.n1057 4.5005
R1133 VDD.n430 VDD.n429 4.5005
R1134 VDD.n424 VDD.n423 4.5005
R1135 VDD.n318 VDD.n317 4.5005
R1136 VDD.n316 VDD.n315 4.5005
R1137 VDD.n237 VDD.n236 4.5005
R1138 VDD.n437 VDD.n436 4.5005
R1139 VDD.n438 VDD.n229 4.5005
R1140 VDD.n443 VDD.n442 4.5005
R1141 VDD.n220 VDD.n216 4.5005
R1142 VDD.n457 VDD.n456 4.5005
R1143 VDD.n212 VDD.n211 4.5005
R1144 VDD.n463 VDD.n462 4.5005
R1145 VDD.n202 VDD.n198 4.5005
R1146 VDD.n477 VDD.n476 4.5005
R1147 VDD.n194 VDD.n193 4.5005
R1148 VDD.n483 VDD.n482 4.5005
R1149 VDD.n184 VDD.n180 4.5005
R1150 VDD.n497 VDD.n496 4.5005
R1151 VDD.n176 VDD.n175 4.5005
R1152 VDD.n503 VDD.n502 4.5005
R1153 VDD.n166 VDD.n162 4.5005
R1154 VDD.n517 VDD.n516 4.5005
R1155 VDD.n158 VDD.n157 4.5005
R1156 VDD.n523 VDD.n522 4.5005
R1157 VDD.n148 VDD.n144 4.5005
R1158 VDD.n537 VDD.n536 4.5005
R1159 VDD.n141 VDD.n139 4.5005
R1160 VDD.n551 VDD.n550 4.5005
R1161 VDD.n143 VDD.n140 4.5005
R1162 VDD.n545 VDD.n544 4.5005
R1163 VDD.n130 VDD.n0 4.5005
R1164 VDD VDD.n1 4.5005
R1165 VDD.n8 VDD.n3 4.5005
R1166 VDD.n1103 VDD.n1102 4.5005
R1167 VDD.n1101 VDD.n7 4.5005
R1168 VDD.n1100 VDD.n1099 4.5005
R1169 VDD.n1098 VDD.n12 4.5005
R1170 VDD.n116 VDD.n18 4.5005
R1171 VDD.n27 VDD.n21 4.5005
R1172 VDD.n1093 VDD.n1092 4.5005
R1173 VDD.n1091 VDD.n26 4.5005
R1174 VDD.n1090 VDD.n1089 4.5005
R1175 VDD.n1088 VDD.n31 4.5005
R1176 VDD.n600 VDD.n38 4.5005
R1177 VDD.n46 VDD.n40 4.5005
R1178 VDD.n1083 VDD.n1082 4.5005
R1179 VDD.n1081 VDD.n45 4.5005
R1180 VDD.n1080 VDD.n1079 4.5005
R1181 VDD.n1078 VDD.n50 4.5005
R1182 VDD.n96 VDD.n57 4.5005
R1183 VDD.n65 VDD.n59 4.5005
R1184 VDD.n1073 VDD.n1072 4.5005
R1185 VDD.n1071 VDD.n64 4.5005
R1186 VDD.n1070 VDD.n1069 4.5005
R1187 VDD.n1068 VDD.n69 4.5005
R1188 VDD.n636 VDD.n77 4.5005
R1189 VDD.n81 VDD.n79 4.5005
R1190 VDD.n1064 VDD.n1063 4.5005
R1191 VDD.n136 VDD.t43 4.32638
R1192 VDD.n575 VDD.t34 4.32638
R1193 VDD.n181 VDD.n179 4.09412
R1194 VDD.n42 VDD.n41 4.09412
R1195 VDD.n396 VDD.n252 4.09412
R1196 VDD.n349 VDD.n289 4.09412
R1197 VDD.n1066 VDD.t5 3.9205
R1198 VDD.n1066 VDD.t2 3.9205
R1199 VDD.n78 VDD.t8 3.9205
R1200 VDD.t5 VDD.n78 3.9205
R1201 VDD.t11 VDD.n1075 3.9205
R1202 VDD.n1075 VDD.t8 3.9205
R1203 VDD.n1076 VDD.t14 3.9205
R1204 VDD.n1076 VDD.t11 3.9205
R1205 VDD.n58 VDD.t17 3.9205
R1206 VDD.t14 VDD.n58 3.9205
R1207 VDD.t20 VDD.n1085 3.9205
R1208 VDD.n1085 VDD.t17 3.9205
R1209 VDD.n1086 VDD.t23 3.9205
R1210 VDD.n1086 VDD.t20 3.9205
R1211 VDD.n39 VDD.t26 3.9205
R1212 VDD.t23 VDD.n39 3.9205
R1213 VDD.t29 VDD.n1095 3.9205
R1214 VDD.n1095 VDD.t26 3.9205
R1215 VDD.n1096 VDD.t32 3.9205
R1216 VDD.n1096 VDD.t29 3.9205
R1217 VDD.n20 VDD.t35 3.9205
R1218 VDD.t32 VDD.n20 3.9205
R1219 VDD.n19 VDD.t38 3.9205
R1220 VDD.t35 VDD.n19 3.9205
R1221 VDD.t41 VDD.n2 3.9205
R1222 VDD.t38 VDD.n2 3.9205
R1223 VDD.t44 VDD.n547 3.9205
R1224 VDD.n547 VDD.t41 3.9205
R1225 VDD.n548 VDD.t47 3.9205
R1226 VDD.n548 VDD.t44 3.9205
R1227 VDD.n539 VDD.t50 3.9205
R1228 VDD.t47 VDD.n539 3.9205
R1229 VDD.n520 VDD.t53 3.9205
R1230 VDD.n520 VDD.t50 3.9205
R1231 VDD.n519 VDD.t56 3.9205
R1232 VDD.t53 VDD.n519 3.9205
R1233 VDD.n500 VDD.t59 3.9205
R1234 VDD.n500 VDD.t56 3.9205
R1235 VDD.n499 VDD.t62 3.9205
R1236 VDD.t59 VDD.n499 3.9205
R1237 VDD.n480 VDD.t65 3.9205
R1238 VDD.n480 VDD.t62 3.9205
R1239 VDD.n479 VDD.t68 3.9205
R1240 VDD.t65 VDD.n479 3.9205
R1241 VDD.n460 VDD.t71 3.9205
R1242 VDD.n460 VDD.t68 3.9205
R1243 VDD.n459 VDD.t74 3.9205
R1244 VDD.t71 VDD.n459 3.9205
R1245 VDD.n440 VDD.t77 3.9205
R1246 VDD.n440 VDD.t74 3.9205
R1247 VDD.n321 VDD.t87 3.9205
R1248 VDD.t85 VDD.n321 3.9205
R1249 VDD.n320 VDD.t89 3.9205
R1250 VDD.t87 VDD.n320 3.9205
R1251 VDD.n319 VDD.t91 3.9205
R1252 VDD.t89 VDD.n319 3.9205
R1253 VDD.t93 VDD.n339 3.9205
R1254 VDD.n339 VDD.t91 3.9205
R1255 VDD.n340 VDD.t95 3.9205
R1256 VDD.n340 VDD.t93 3.9205
R1257 VDD.n300 VDD.t97 3.9205
R1258 VDD.t95 VDD.n300 3.9205
R1259 VDD.n299 VDD.t99 3.9205
R1260 VDD.t97 VDD.n299 3.9205
R1261 VDD.n298 VDD.t101 3.9205
R1262 VDD.t99 VDD.n298 3.9205
R1263 VDD.n297 VDD.t103 3.9205
R1264 VDD.t101 VDD.n297 3.9205
R1265 VDD.n296 VDD.t105 3.9205
R1266 VDD.t103 VDD.n296 3.9205
R1267 VDD.n295 VDD.t107 3.9205
R1268 VDD.t105 VDD.n295 3.9205
R1269 VDD.n294 VDD.t109 3.9205
R1270 VDD.t107 VDD.n294 3.9205
R1271 VDD.n276 VDD.t111 3.9205
R1272 VDD.t109 VDD.n276 3.9205
R1273 VDD.n275 VDD.t113 3.9205
R1274 VDD.t111 VDD.n275 3.9205
R1275 VDD.n274 VDD.t115 3.9205
R1276 VDD.t113 VDD.n274 3.9205
R1277 VDD.n273 VDD.t117 3.9205
R1278 VDD.t115 VDD.n273 3.9205
R1279 VDD.n272 VDD.t119 3.9205
R1280 VDD.t117 VDD.n272 3.9205
R1281 VDD.n271 VDD.t121 3.9205
R1282 VDD.t119 VDD.n271 3.9205
R1283 VDD.n270 VDD.t123 3.9205
R1284 VDD.t121 VDD.n270 3.9205
R1285 VDD.n269 VDD.t125 3.9205
R1286 VDD.t123 VDD.n269 3.9205
R1287 VDD.n268 VDD.t127 3.9205
R1288 VDD.t125 VDD.n268 3.9205
R1289 VDD.n267 VDD.t129 3.9205
R1290 VDD.t127 VDD.n267 3.9205
R1291 VDD.n266 VDD.t131 3.9205
R1292 VDD.t129 VDD.n266 3.9205
R1293 VDD.n265 VDD.t133 3.9205
R1294 VDD.t131 VDD.n265 3.9205
R1295 VDD.t135 VDD.n421 3.9205
R1296 VDD.n421 VDD.t133 3.9205
R1297 VDD.n195 VDD.n183 3.51012
R1298 VDD.n52 VDD.n44 3.51012
R1299 VDD.n400 VDD.n250 3.51012
R1300 VDD.n345 VDD.n344 3.51012
R1301 VDD.n1060 VDD.n1059 3.49505
R1302 VDD.n432 VDD.n431 3.49505
R1303 VDD.n232 VDD.n231 3.22935
R1304 VDD.n199 VDD.n197 3.22935
R1305 VDD.n55 VDD.n54 3.22935
R1306 VDD.n75 VDD.n74 3.22935
R1307 VDD.n418 VDD.n417 3.22935
R1308 VDD.n404 VDD.n248 3.22935
R1309 VDD.n303 VDD.n292 3.22935
R1310 VDD.n326 VDD.n308 3.22935
R1311 VDD.n218 VDD.n217 2.94858
R1312 VDD.n213 VDD.n201 2.94858
R1313 VDD.n61 VDD.n60 2.94858
R1314 VDD.n72 VDD.n71 2.94858
R1315 VDD.n415 VDD.n243 2.94858
R1316 VDD.n408 VDD.n246 2.94858
R1317 VDD.n336 VDD.n335 2.94858
R1318 VDD.n330 VDD.n305 2.94858
R1319 VDD.t143 VDD.n473 2.88442
R1320 VDD.t46 VDD.t140 2.88442
R1321 VDD.n217 VDD.n215 2.66781
R1322 VDD.n214 VDD.n213 2.66781
R1323 VDD.n62 VDD.n61 2.66781
R1324 VDD.n71 VDD.n63 2.66781
R1325 VDD.n412 VDD.n243 2.66781
R1326 VDD.n411 VDD.n246 2.66781
R1327 VDD.n335 VDD.n334 2.66781
R1328 VDD.n333 VDD.n305 2.66781
R1329 VDD.n434 VDD.n432 2.64783
R1330 VDD.n1061 VDD.n1060 2.64783
R1331 VDD.n231 VDD.n219 2.38704
R1332 VDD.n200 VDD.n199 2.38704
R1333 VDD.n56 VDD.n55 2.38704
R1334 VDD.n74 VDD.n73 2.38704
R1335 VDD.n417 VDD.n416 2.38704
R1336 VDD.n407 VDD.n248 2.38704
R1337 VDD.n304 VDD.n303 2.38704
R1338 VDD.n329 VDD.n308 2.38704
R1339 VDD.n196 VDD.n195 2.10627
R1340 VDD.n53 VDD.n52 2.10627
R1341 VDD.n403 VDD.n250 2.10627
R1342 VDD.n344 VDD.n343 2.10627
R1343 VDD.n1054 VDD.n1053 1.8905
R1344 VDD.n1055 VDD.n1054 1.8905
R1345 VDD.n231 VDD.t72 1.8255
R1346 VDD.n217 VDD.t69 1.8255
R1347 VDD.n213 VDD.t66 1.8255
R1348 VDD.n199 VDD.t63 1.8255
R1349 VDD.n195 VDD.t60 1.8255
R1350 VDD.n181 VDD.t57 1.8255
R1351 VDD.n182 VDD.n181 1.8255
R1352 VDD.n177 VDD.t54 1.8255
R1353 VDD.n163 VDD.t51 1.8255
R1354 VDD.n159 VDD.t48 1.8255
R1355 VDD.n145 VDD.t45 1.8255
R1356 VDD.n541 VDD.t42 1.8255
R1357 VDD.n4 VDD.t39 1.8255
R1358 VDD.n1106 VDD.t36 1.8255
R1359 VDD.n5 VDD.t33 1.8255
R1360 VDD.n16 VDD.t30 1.8255
R1361 VDD.n23 VDD.t27 1.8255
R1362 VDD.n33 VDD.t24 1.8255
R1363 VDD.n36 VDD.t21 1.8255
R1364 VDD.n42 VDD.t18 1.8255
R1365 VDD.n43 VDD.n42 1.8255
R1366 VDD.n52 VDD.t15 1.8255
R1367 VDD.n55 VDD.t12 1.8255
R1368 VDD.n61 VDD.t9 1.8255
R1369 VDD.n71 VDD.t6 1.8255
R1370 VDD.n74 VDD.t3 1.8255
R1371 VDD.n417 VDD.t132 1.8255
R1372 VDD.n243 VDD.t130 1.8255
R1373 VDD.n246 VDD.t128 1.8255
R1374 VDD.n248 VDD.t126 1.8255
R1375 VDD.n250 VDD.t124 1.8255
R1376 VDD.n252 VDD.t122 1.8255
R1377 VDD.n399 VDD.n252 1.8255
R1378 VDD.n254 VDD.t120 1.8255
R1379 VDD.n256 VDD.t118 1.8255
R1380 VDD.n258 VDD.t116 1.8255
R1381 VDD.n260 VDD.t114 1.8255
R1382 VDD.n262 VDD.t112 1.8255
R1383 VDD.n264 VDD.t110 1.8255
R1384 VDD.n371 VDD.t108 1.8255
R1385 VDD.n278 VDD.t106 1.8255
R1386 VDD.n281 VDD.t104 1.8255
R1387 VDD.n283 VDD.t102 1.8255
R1388 VDD.n285 VDD.t100 1.8255
R1389 VDD.n287 VDD.t98 1.8255
R1390 VDD.n289 VDD.t96 1.8255
R1391 VDD.n346 VDD.n289 1.8255
R1392 VDD.n344 VDD.t94 1.8255
R1393 VDD.n303 VDD.t92 1.8255
R1394 VDD.n335 VDD.t90 1.8255
R1395 VDD.n305 VDD.t88 1.8255
R1396 VDD.n308 VDD.t86 1.8255
R1397 VDD.n178 VDD.n177 1.54473
R1398 VDD.n37 VDD.n36 1.54473
R1399 VDD.n395 VDD.n254 1.54473
R1400 VDD.n350 VDD.n287 1.54473
R1401 VDD.t52 VDD.t142 1.44246
R1402 VDD.n562 VDD.t40 1.44246
R1403 VDD.t37 VDD.n123 1.44246
R1404 VDD.n164 VDD.n163 1.26396
R1405 VDD.n34 VDD.n33 1.26396
R1406 VDD.n391 VDD.n256 1.26396
R1407 VDD.n354 VDD.n285 1.26396
R1408 VDD.n1052 VDD.n1051 1.1957
R1409 VDD.n1053 VDD.n1052 1.1309
R1410 VDD.n160 VDD.n159 0.983192
R1411 VDD.n24 VDD.n23 0.983192
R1412 VDD.n387 VDD.n258 0.983192
R1413 VDD.n358 VDD.n283 0.983192
R1414 VDD.n146 VDD.n145 0.702423
R1415 VDD.n17 VDD.n16 0.702423
R1416 VDD.n383 VDD.n260 0.702423
R1417 VDD.n362 VDD.n281 0.702423
R1418 VDD.n541 VDD.n540 0.421654
R1419 VDD.n14 VDD.n5 0.421654
R1420 VDD.n379 VDD.n262 0.421654
R1421 VDD.n366 VDD.n278 0.421654
R1422 VDD.n423 VDD.n422 0.290664
R1423 VDD.n322 VDD.n318 0.290664
R1424 VDD.n643 VDD.n83 0.2525
R1425 VDD.n428 VDD.n427 0.2525
R1426 VDD.n312 VDD.n80 0.216026
R1427 VDD.n425 VDD.n234 0.201224
R1428 VDD.n1057 VDD.n1056 0.1787
R1429 VDD.n950 VDD.n741 0.1755
R1430 VDD.n814 VDD.n809 0.1755
R1431 VDD.n430 VDD.n225 0.1445
R1432 VDD.n447 VDD.n225 0.1445
R1433 VDD.n447 VDD.n223 0.1445
R1434 VDD.n451 VDD.n223 0.1445
R1435 VDD.n451 VDD.n207 0.1445
R1436 VDD.n467 VDD.n207 0.1445
R1437 VDD.n467 VDD.n205 0.1445
R1438 VDD.n471 VDD.n205 0.1445
R1439 VDD.n471 VDD.n189 0.1445
R1440 VDD.n487 VDD.n189 0.1445
R1441 VDD.n487 VDD.n187 0.1445
R1442 VDD.n491 VDD.n187 0.1445
R1443 VDD.n491 VDD.n171 0.1445
R1444 VDD.n507 VDD.n171 0.1445
R1445 VDD.n507 VDD.n169 0.1445
R1446 VDD.n511 VDD.n169 0.1445
R1447 VDD.n511 VDD.n153 0.1445
R1448 VDD.n527 VDD.n153 0.1445
R1449 VDD.n527 VDD.n151 0.1445
R1450 VDD.n531 VDD.n151 0.1445
R1451 VDD.n531 VDD.n134 0.1445
R1452 VDD.n555 VDD.n134 0.1445
R1453 VDD.n555 VDD.n132 0.1445
R1454 VDD.n559 VDD.n132 0.1445
R1455 VDD.n559 VDD.n127 0.1445
R1456 VDD.n568 VDD.n127 0.1445
R1457 VDD.n568 VDD.n125 0.1445
R1458 VDD.n572 VDD.n125 0.1445
R1459 VDD.n572 VDD.n121 0.1445
R1460 VDD.n578 VDD.n121 0.1445
R1461 VDD.n578 VDD.n119 0.1445
R1462 VDD.n582 VDD.n119 0.1445
R1463 VDD.n582 VDD.n113 0.1445
R1464 VDD.n590 VDD.n113 0.1445
R1465 VDD.n590 VDD.n111 0.1445
R1466 VDD.n594 VDD.n111 0.1445
R1467 VDD.n594 VDD.n107 0.1445
R1468 VDD.n604 VDD.n107 0.1445
R1469 VDD.n604 VDD.n105 0.1445
R1470 VDD.n608 VDD.n105 0.1445
R1471 VDD.n608 VDD.n101 0.1445
R1472 VDD.n614 VDD.n101 0.1445
R1473 VDD.n614 VDD.n99 0.1445
R1474 VDD.n618 VDD.n99 0.1445
R1475 VDD.n618 VDD.n93 0.1445
R1476 VDD.n626 VDD.n93 0.1445
R1477 VDD.n626 VDD.n91 0.1445
R1478 VDD.n630 VDD.n91 0.1445
R1479 VDD.n630 VDD.n87 0.1445
R1480 VDD.n640 VDD.n87 0.1445
R1481 VDD.n640 VDD.n85 0.1445
R1482 VDD.n1058 VDD.n85 0.1445
R1483 VDD.n436 VDD.n229 0.1445
R1484 VDD.n443 VDD.n229 0.1445
R1485 VDD.n443 VDD.n220 0.1445
R1486 VDD.n456 VDD.n220 0.1445
R1487 VDD.n456 VDD.n211 0.1445
R1488 VDD.n463 VDD.n211 0.1445
R1489 VDD.n463 VDD.n202 0.1445
R1490 VDD.n476 VDD.n202 0.1445
R1491 VDD.n476 VDD.n193 0.1445
R1492 VDD.n483 VDD.n193 0.1445
R1493 VDD.n483 VDD.n184 0.1445
R1494 VDD.n496 VDD.n184 0.1445
R1495 VDD.n496 VDD.n175 0.1445
R1496 VDD.n503 VDD.n175 0.1445
R1497 VDD.n503 VDD.n166 0.1445
R1498 VDD.n516 VDD.n166 0.1445
R1499 VDD.n516 VDD.n157 0.1445
R1500 VDD.n523 VDD.n157 0.1445
R1501 VDD.n523 VDD.n148 0.1445
R1502 VDD.n536 VDD.n148 0.1445
R1503 VDD.n536 VDD.n139 0.1445
R1504 VDD.n551 VDD.n139 0.1445
R1505 VDD.n551 VDD.n140 0.1445
R1506 VDD.n544 VDD.n140 0.1445
R1507 VDD.n544 VDD.n130 0.1445
R1508 VDD.n130 VDD.n1 0.1445
R1509 VDD.n8 VDD.n1 0.1445
R1510 VDD.n1102 VDD.n8 0.1445
R1511 VDD.n1102 VDD.n1101 0.1445
R1512 VDD.n1101 VDD.n1100 0.1445
R1513 VDD.n1100 VDD.n12 0.1445
R1514 VDD.n116 VDD.n12 0.1445
R1515 VDD.n116 VDD.n27 0.1445
R1516 VDD.n1092 VDD.n27 0.1445
R1517 VDD.n1092 VDD.n1091 0.1445
R1518 VDD.n1091 VDD.n1090 0.1445
R1519 VDD.n1090 VDD.n31 0.1445
R1520 VDD.n600 VDD.n31 0.1445
R1521 VDD.n600 VDD.n46 0.1445
R1522 VDD.n1082 VDD.n46 0.1445
R1523 VDD.n1082 VDD.n1081 0.1445
R1524 VDD.n1081 VDD.n1080 0.1445
R1525 VDD.n1080 VDD.n50 0.1445
R1526 VDD.n96 VDD.n50 0.1445
R1527 VDD.n96 VDD.n65 0.1445
R1528 VDD.n1072 VDD.n65 0.1445
R1529 VDD.n1072 VDD.n1071 0.1445
R1530 VDD.n1071 VDD.n1070 0.1445
R1531 VDD.n1070 VDD.n69 0.1445
R1532 VDD.n636 VDD.n69 0.1445
R1533 VDD.n636 VDD.n81 0.1445
R1534 VDD.n1063 VDD.n81 0.1445
R1535 VDD.n816 VDD.n808 0.1445
R1536 VDD.n820 VDD.n808 0.1445
R1537 VDD.n820 VDD.n806 0.1445
R1538 VDD.n824 VDD.n806 0.1445
R1539 VDD.n824 VDD.n804 0.1445
R1540 VDD.n828 VDD.n804 0.1445
R1541 VDD.n828 VDD.n802 0.1445
R1542 VDD.n832 VDD.n802 0.1445
R1543 VDD.n832 VDD.n800 0.1445
R1544 VDD.n836 VDD.n800 0.1445
R1545 VDD.n836 VDD.n798 0.1445
R1546 VDD.n840 VDD.n798 0.1445
R1547 VDD.n840 VDD.n796 0.1445
R1548 VDD.n844 VDD.n796 0.1445
R1549 VDD.n844 VDD.n794 0.1445
R1550 VDD.n848 VDD.n794 0.1445
R1551 VDD.n848 VDD.n792 0.1445
R1552 VDD.n852 VDD.n792 0.1445
R1553 VDD.n852 VDD.n790 0.1445
R1554 VDD.n856 VDD.n790 0.1445
R1555 VDD.n856 VDD.n788 0.1445
R1556 VDD.n860 VDD.n788 0.1445
R1557 VDD.n860 VDD.n786 0.1445
R1558 VDD.n864 VDD.n786 0.1445
R1559 VDD.n864 VDD.n784 0.1445
R1560 VDD.n868 VDD.n784 0.1445
R1561 VDD.n868 VDD.n782 0.1445
R1562 VDD.n872 VDD.n782 0.1445
R1563 VDD.n872 VDD.n780 0.1445
R1564 VDD.n876 VDD.n780 0.1445
R1565 VDD.n876 VDD.n778 0.1445
R1566 VDD.n880 VDD.n778 0.1445
R1567 VDD.n880 VDD.n776 0.1445
R1568 VDD.n884 VDD.n776 0.1445
R1569 VDD.n884 VDD.n774 0.1445
R1570 VDD.n888 VDD.n774 0.1445
R1571 VDD.n888 VDD.n772 0.1445
R1572 VDD.n892 VDD.n772 0.1445
R1573 VDD.n892 VDD.n770 0.1445
R1574 VDD.n896 VDD.n770 0.1445
R1575 VDD.n896 VDD.n768 0.1445
R1576 VDD.n900 VDD.n768 0.1445
R1577 VDD.n900 VDD.n766 0.1445
R1578 VDD.n904 VDD.n766 0.1445
R1579 VDD.n904 VDD.n764 0.1445
R1580 VDD.n908 VDD.n764 0.1445
R1581 VDD.n908 VDD.n762 0.1445
R1582 VDD.n912 VDD.n762 0.1445
R1583 VDD.n912 VDD.n760 0.1445
R1584 VDD.n916 VDD.n760 0.1445
R1585 VDD.n916 VDD.n758 0.1445
R1586 VDD.n920 VDD.n758 0.1445
R1587 VDD.n920 VDD.n756 0.1445
R1588 VDD.n924 VDD.n756 0.1445
R1589 VDD.n924 VDD.n754 0.1445
R1590 VDD.n928 VDD.n754 0.1445
R1591 VDD.n928 VDD.n752 0.1445
R1592 VDD.n932 VDD.n752 0.1445
R1593 VDD.n932 VDD.n750 0.1445
R1594 VDD.n936 VDD.n750 0.1445
R1595 VDD.n936 VDD.n748 0.1445
R1596 VDD.n940 VDD.n748 0.1445
R1597 VDD.n940 VDD.n746 0.1445
R1598 VDD.n944 VDD.n746 0.1445
R1599 VDD.n944 VDD.n744 0.1445
R1600 VDD.n948 VDD.n744 0.1445
R1601 VDD.n812 VDD.n646 0.1445
R1602 VDD.n1048 VDD.n646 0.1445
R1603 VDD.n1048 VDD.n1047 0.1445
R1604 VDD.n1047 VDD.n1046 0.1445
R1605 VDD.n1046 VDD.n650 0.1445
R1606 VDD.n1042 VDD.n650 0.1445
R1607 VDD.n1042 VDD.n1041 0.1445
R1608 VDD.n1041 VDD.n1040 0.1445
R1609 VDD.n1040 VDD.n656 0.1445
R1610 VDD.n1036 VDD.n656 0.1445
R1611 VDD.n1036 VDD.n1035 0.1445
R1612 VDD.n1035 VDD.n1034 0.1445
R1613 VDD.n1034 VDD.n662 0.1445
R1614 VDD.n1030 VDD.n662 0.1445
R1615 VDD.n1030 VDD.n1029 0.1445
R1616 VDD.n1029 VDD.n1028 0.1445
R1617 VDD.n1028 VDD.n668 0.1445
R1618 VDD.n1024 VDD.n668 0.1445
R1619 VDD.n1024 VDD.n1023 0.1445
R1620 VDD.n1023 VDD.n1022 0.1445
R1621 VDD.n1022 VDD.n674 0.1445
R1622 VDD.n1018 VDD.n674 0.1445
R1623 VDD.n1018 VDD.n1017 0.1445
R1624 VDD.n1017 VDD.n1016 0.1445
R1625 VDD.n1016 VDD.n680 0.1445
R1626 VDD.n1012 VDD.n680 0.1445
R1627 VDD.n1012 VDD.n1011 0.1445
R1628 VDD.n1011 VDD.n1010 0.1445
R1629 VDD.n1010 VDD.n686 0.1445
R1630 VDD.n1006 VDD.n686 0.1445
R1631 VDD.n1006 VDD.n1005 0.1445
R1632 VDD.n1005 VDD.n1004 0.1445
R1633 VDD.n1004 VDD.n692 0.1445
R1634 VDD.n1000 VDD.n692 0.1445
R1635 VDD.n1000 VDD.n999 0.1445
R1636 VDD.n999 VDD.n998 0.1445
R1637 VDD.n998 VDD.n698 0.1445
R1638 VDD.n994 VDD.n698 0.1445
R1639 VDD.n994 VDD.n993 0.1445
R1640 VDD.n993 VDD.n992 0.1445
R1641 VDD.n992 VDD.n704 0.1445
R1642 VDD.n988 VDD.n704 0.1445
R1643 VDD.n988 VDD.n987 0.1445
R1644 VDD.n987 VDD.n986 0.1445
R1645 VDD.n986 VDD.n710 0.1445
R1646 VDD.n982 VDD.n710 0.1445
R1647 VDD.n982 VDD.n981 0.1445
R1648 VDD.n981 VDD.n980 0.1445
R1649 VDD.n980 VDD.n716 0.1445
R1650 VDD.n976 VDD.n716 0.1445
R1651 VDD.n976 VDD.n975 0.1445
R1652 VDD.n975 VDD.n974 0.1445
R1653 VDD.n974 VDD.n722 0.1445
R1654 VDD.n970 VDD.n722 0.1445
R1655 VDD.n970 VDD.n969 0.1445
R1656 VDD.n969 VDD.n968 0.1445
R1657 VDD.n968 VDD.n728 0.1445
R1658 VDD.n964 VDD.n728 0.1445
R1659 VDD.n964 VDD.n963 0.1445
R1660 VDD.n963 VDD.n962 0.1445
R1661 VDD.n962 VDD.n734 0.1445
R1662 VDD.n958 VDD.n734 0.1445
R1663 VDD.n958 VDD.n957 0.1445
R1664 VDD.n957 VDD.n956 0.1445
R1665 VDD.n956 VDD.n740 0.1445
R1666 VDD.n952 VDD.n740 0.1445
R1667 VDD.n818 VDD.n817 0.1445
R1668 VDD.n819 VDD.n818 0.1445
R1669 VDD.n819 VDD.n805 0.1445
R1670 VDD.n825 VDD.n805 0.1445
R1671 VDD.n826 VDD.n825 0.1445
R1672 VDD.n827 VDD.n826 0.1445
R1673 VDD.n827 VDD.n801 0.1445
R1674 VDD.n833 VDD.n801 0.1445
R1675 VDD.n834 VDD.n833 0.1445
R1676 VDD.n835 VDD.n834 0.1445
R1677 VDD.n835 VDD.n797 0.1445
R1678 VDD.n841 VDD.n797 0.1445
R1679 VDD.n842 VDD.n841 0.1445
R1680 VDD.n843 VDD.n842 0.1445
R1681 VDD.n843 VDD.n793 0.1445
R1682 VDD.n849 VDD.n793 0.1445
R1683 VDD.n850 VDD.n849 0.1445
R1684 VDD.n851 VDD.n850 0.1445
R1685 VDD.n851 VDD.n789 0.1445
R1686 VDD.n857 VDD.n789 0.1445
R1687 VDD.n858 VDD.n857 0.1445
R1688 VDD.n859 VDD.n858 0.1445
R1689 VDD.n859 VDD.n785 0.1445
R1690 VDD.n865 VDD.n785 0.1445
R1691 VDD.n866 VDD.n865 0.1445
R1692 VDD.n867 VDD.n866 0.1445
R1693 VDD.n867 VDD.n781 0.1445
R1694 VDD.n873 VDD.n781 0.1445
R1695 VDD.n874 VDD.n873 0.1445
R1696 VDD.n875 VDD.n874 0.1445
R1697 VDD.n875 VDD.n777 0.1445
R1698 VDD.n881 VDD.n777 0.1445
R1699 VDD.n882 VDD.n881 0.1445
R1700 VDD.n883 VDD.n882 0.1445
R1701 VDD.n883 VDD.n773 0.1445
R1702 VDD.n889 VDD.n773 0.1445
R1703 VDD.n890 VDD.n889 0.1445
R1704 VDD.n891 VDD.n890 0.1445
R1705 VDD.n891 VDD.n769 0.1445
R1706 VDD.n897 VDD.n769 0.1445
R1707 VDD.n898 VDD.n897 0.1445
R1708 VDD.n899 VDD.n898 0.1445
R1709 VDD.n899 VDD.n765 0.1445
R1710 VDD.n905 VDD.n765 0.1445
R1711 VDD.n906 VDD.n905 0.1445
R1712 VDD.n907 VDD.n906 0.1445
R1713 VDD.n907 VDD.n761 0.1445
R1714 VDD.n913 VDD.n761 0.1445
R1715 VDD.n914 VDD.n913 0.1445
R1716 VDD.n915 VDD.n914 0.1445
R1717 VDD.n915 VDD.n757 0.1445
R1718 VDD.n921 VDD.n757 0.1445
R1719 VDD.n922 VDD.n921 0.1445
R1720 VDD.n923 VDD.n922 0.1445
R1721 VDD.n923 VDD.n753 0.1445
R1722 VDD.n929 VDD.n753 0.1445
R1723 VDD.n930 VDD.n929 0.1445
R1724 VDD.n931 VDD.n930 0.1445
R1725 VDD.n931 VDD.n749 0.1445
R1726 VDD.n937 VDD.n749 0.1445
R1727 VDD.n938 VDD.n937 0.1445
R1728 VDD.n939 VDD.n938 0.1445
R1729 VDD.n939 VDD.n745 0.1445
R1730 VDD.n945 VDD.n745 0.1445
R1731 VDD.n946 VDD.n945 0.1445
R1732 VDD.n947 VDD.n946 0.1445
R1733 VDD.n811 VDD.n644 0.1445
R1734 VDD.n1049 VDD.n645 0.1445
R1735 VDD.n1045 VDD.n645 0.1445
R1736 VDD.n1045 VDD.n1044 0.1445
R1737 VDD.n1044 VDD.n1043 0.1445
R1738 VDD.n1043 VDD.n651 0.1445
R1739 VDD.n1039 VDD.n651 0.1445
R1740 VDD.n1039 VDD.n1038 0.1445
R1741 VDD.n1038 VDD.n1037 0.1445
R1742 VDD.n1037 VDD.n657 0.1445
R1743 VDD.n1033 VDD.n657 0.1445
R1744 VDD.n1033 VDD.n1032 0.1445
R1745 VDD.n1032 VDD.n1031 0.1445
R1746 VDD.n1031 VDD.n663 0.1445
R1747 VDD.n1027 VDD.n663 0.1445
R1748 VDD.n1027 VDD.n1026 0.1445
R1749 VDD.n1026 VDD.n1025 0.1445
R1750 VDD.n1025 VDD.n669 0.1445
R1751 VDD.n1021 VDD.n669 0.1445
R1752 VDD.n1021 VDD.n1020 0.1445
R1753 VDD.n1020 VDD.n1019 0.1445
R1754 VDD.n1019 VDD.n675 0.1445
R1755 VDD.n1015 VDD.n675 0.1445
R1756 VDD.n1015 VDD.n1014 0.1445
R1757 VDD.n1014 VDD.n1013 0.1445
R1758 VDD.n1013 VDD.n681 0.1445
R1759 VDD.n1009 VDD.n681 0.1445
R1760 VDD.n1009 VDD.n1008 0.1445
R1761 VDD.n1008 VDD.n1007 0.1445
R1762 VDD.n1007 VDD.n687 0.1445
R1763 VDD.n1003 VDD.n687 0.1445
R1764 VDD.n1003 VDD.n1002 0.1445
R1765 VDD.n1002 VDD.n1001 0.1445
R1766 VDD.n1001 VDD.n693 0.1445
R1767 VDD.n997 VDD.n693 0.1445
R1768 VDD.n997 VDD.n996 0.1445
R1769 VDD.n996 VDD.n995 0.1445
R1770 VDD.n995 VDD.n699 0.1445
R1771 VDD.n991 VDD.n699 0.1445
R1772 VDD.n991 VDD.n990 0.1445
R1773 VDD.n990 VDD.n989 0.1445
R1774 VDD.n989 VDD.n705 0.1445
R1775 VDD.n985 VDD.n705 0.1445
R1776 VDD.n985 VDD.n984 0.1445
R1777 VDD.n984 VDD.n983 0.1445
R1778 VDD.n983 VDD.n711 0.1445
R1779 VDD.n979 VDD.n711 0.1445
R1780 VDD.n979 VDD.n978 0.1445
R1781 VDD.n978 VDD.n977 0.1445
R1782 VDD.n977 VDD.n717 0.1445
R1783 VDD.n973 VDD.n717 0.1445
R1784 VDD.n973 VDD.n972 0.1445
R1785 VDD.n972 VDD.n971 0.1445
R1786 VDD.n971 VDD.n723 0.1445
R1787 VDD.n967 VDD.n723 0.1445
R1788 VDD.n967 VDD.n966 0.1445
R1789 VDD.n966 VDD.n965 0.1445
R1790 VDD.n965 VDD.n729 0.1445
R1791 VDD.n961 VDD.n729 0.1445
R1792 VDD.n961 VDD.n960 0.1445
R1793 VDD.n960 VDD.n959 0.1445
R1794 VDD.n959 VDD.n735 0.1445
R1795 VDD.n955 VDD.n735 0.1445
R1796 VDD.n955 VDD.n954 0.1445
R1797 VDD.n954 VDD.n953 0.1445
R1798 VDD.n429 VDD.n224 0.1445
R1799 VDD.n448 VDD.n224 0.1445
R1800 VDD.n449 VDD.n448 0.1445
R1801 VDD.n450 VDD.n449 0.1445
R1802 VDD.n450 VDD.n206 0.1445
R1803 VDD.n468 VDD.n206 0.1445
R1804 VDD.n469 VDD.n468 0.1445
R1805 VDD.n470 VDD.n469 0.1445
R1806 VDD.n470 VDD.n188 0.1445
R1807 VDD.n488 VDD.n188 0.1445
R1808 VDD.n489 VDD.n488 0.1445
R1809 VDD.n490 VDD.n489 0.1445
R1810 VDD.n490 VDD.n170 0.1445
R1811 VDD.n508 VDD.n170 0.1445
R1812 VDD.n509 VDD.n508 0.1445
R1813 VDD.n510 VDD.n509 0.1445
R1814 VDD.n510 VDD.n152 0.1445
R1815 VDD.n528 VDD.n152 0.1445
R1816 VDD.n529 VDD.n528 0.1445
R1817 VDD.n530 VDD.n529 0.1445
R1818 VDD.n530 VDD.n133 0.1445
R1819 VDD.n556 VDD.n133 0.1445
R1820 VDD.n557 VDD.n556 0.1445
R1821 VDD.n558 VDD.n557 0.1445
R1822 VDD.n558 VDD.n126 0.1445
R1823 VDD.n569 VDD.n126 0.1445
R1824 VDD.n570 VDD.n569 0.1445
R1825 VDD.n571 VDD.n570 0.1445
R1826 VDD.n571 VDD.n120 0.1445
R1827 VDD.n579 VDD.n120 0.1445
R1828 VDD.n580 VDD.n579 0.1445
R1829 VDD.n581 VDD.n580 0.1445
R1830 VDD.n581 VDD.n112 0.1445
R1831 VDD.n591 VDD.n112 0.1445
R1832 VDD.n592 VDD.n591 0.1445
R1833 VDD.n593 VDD.n592 0.1445
R1834 VDD.n593 VDD.n106 0.1445
R1835 VDD.n605 VDD.n106 0.1445
R1836 VDD.n606 VDD.n605 0.1445
R1837 VDD.n607 VDD.n606 0.1445
R1838 VDD.n607 VDD.n100 0.1445
R1839 VDD.n615 VDD.n100 0.1445
R1840 VDD.n616 VDD.n615 0.1445
R1841 VDD.n617 VDD.n616 0.1445
R1842 VDD.n617 VDD.n92 0.1445
R1843 VDD.n627 VDD.n92 0.1445
R1844 VDD.n628 VDD.n627 0.1445
R1845 VDD.n629 VDD.n628 0.1445
R1846 VDD.n629 VDD.n86 0.1445
R1847 VDD.n641 VDD.n86 0.1445
R1848 VDD.n642 VDD.n641 0.1445
R1849 VDD.n1057 VDD.n642 0.1445
R1850 VDD.n542 VDD.n4 0.140885
R1851 VDD.n1106 VDD.n1105 0.140885
R1852 VDD.n375 VDD.n264 0.140885
R1853 VDD.n371 VDD.n370 0.140885
R1854 VDD.n426 VDD.n425 0.121289
R1855 VDD.n312 VDD.n311 0.106487
R1856 VDD.n1050 VDD.n1049 0.0977
R1857 VDD.n314 VDD.n311 0.071785
R1858 VDD.n235 VDD.n230 0.066528
R1859 VDD.n315 VDD.n310 0.0547523
R1860 VDD.n238 VDD.n237 0.0547523
R1861 VDD.n423 VDD.n234 0.0484605
R1862 VDD.n318 VDD.n311 0.0484605
R1863 VDD.n1050 VDD.n644 0.0473
R1864 VDD.n235 VDD.n234 0.0381402
R1865 VDD.n314 VDD.n313 0.0328832
R1866 VDD.n323 VDD.n310 0.0328832
R1867 VDD.n239 VDD.n238 0.0328832
R1868 VDD.n419 VDD.n241 0.0203347
R1869 VDD.n414 VDD.n413 0.0203347
R1870 VDD.n410 VDD.n409 0.0203347
R1871 VDD.n406 VDD.n405 0.0203347
R1872 VDD.n402 VDD.n401 0.0203347
R1873 VDD.n398 VDD.n397 0.0203347
R1874 VDD.n394 VDD.n393 0.0203347
R1875 VDD.n390 VDD.n389 0.0203347
R1876 VDD.n386 VDD.n385 0.0203347
R1877 VDD.n382 VDD.n381 0.0203347
R1878 VDD.n378 VDD.n377 0.0203347
R1879 VDD.n374 VDD.n373 0.0203347
R1880 VDD.n373 VDD.n277 0.0203347
R1881 VDD.n368 VDD.n367 0.0203347
R1882 VDD.n364 VDD.n363 0.0203347
R1883 VDD.n360 VDD.n359 0.0203347
R1884 VDD.n356 VDD.n355 0.0203347
R1885 VDD.n352 VDD.n351 0.0203347
R1886 VDD.n348 VDD.n347 0.0203347
R1887 VDD.n342 VDD.n291 0.0203347
R1888 VDD.n301 VDD.n293 0.0203347
R1889 VDD.n337 VDD.n302 0.0203347
R1890 VDD.n332 VDD.n331 0.0203347
R1891 VDD.n328 VDD.n327 0.0203347
R1892 VDD.n374 VDD.n263 0.019343
R1893 VDD.n279 VDD.n277 0.019343
R1894 VDD.n378 VDD.n261 0.0183512
R1895 VDD.n367 VDD.n280 0.0183512
R1896 VDD.n315 VDD.n311 0.0175327
R1897 VDD.n237 VDD.n234 0.0175327
R1898 VDD.n240 VDD.n239 0.0173595
R1899 VDD.n382 VDD.n259 0.0173595
R1900 VDD.n363 VDD.n282 0.0173595
R1901 VDD.n324 VDD.n323 0.0173595
R1902 VDD.n457 VDD.n216 0.0167896
R1903 VDD.n462 VDD.n212 0.0167896
R1904 VDD.n477 VDD.n198 0.0167896
R1905 VDD.n482 VDD.n194 0.0167896
R1906 VDD.n497 VDD.n180 0.0167896
R1907 VDD.n502 VDD.n176 0.0167896
R1908 VDD.n517 VDD.n162 0.0167896
R1909 VDD.n522 VDD.n158 0.0167896
R1910 VDD.n537 VDD.n144 0.0167896
R1911 VDD.n550 VDD.n141 0.0167896
R1912 VDD.n545 VDD.n143 0.0167896
R1913 VDD VDD.n0 0.0167896
R1914 VDD VDD.n3 0.0167896
R1915 VDD.n1103 VDD.n7 0.0167896
R1916 VDD.n1099 VDD.n1098 0.0167896
R1917 VDD.n21 VDD.n18 0.0167896
R1918 VDD.n1093 VDD.n26 0.0167896
R1919 VDD.n1089 VDD.n1088 0.0167896
R1920 VDD.n40 VDD.n38 0.0167896
R1921 VDD.n1083 VDD.n45 0.0167896
R1922 VDD.n1079 VDD.n1078 0.0167896
R1923 VDD.n59 VDD.n57 0.0167896
R1924 VDD.n1073 VDD.n64 0.0167896
R1925 VDD.n1069 VDD.n1068 0.0167896
R1926 VDD.n386 VDD.n257 0.0163678
R1927 VDD.n359 VDD.n284 0.0163678
R1928 VDD.n546 VDD.n0 0.0159751
R1929 VDD.n6 VDD.n3 0.0159751
R1930 VDD.n390 VDD.n255 0.015376
R1931 VDD.n355 VDD.n286 0.015376
R1932 VDD.n549 VDD.n143 0.0151606
R1933 VDD.n13 VDD.n7 0.0151606
R1934 VDD.n394 VDD.n253 0.0143843
R1935 VDD.n351 VDD.n288 0.0143843
R1936 VDD.n442 VDD.n230 0.0143462
R1937 VDD.n538 VDD.n141 0.0143462
R1938 VDD.n1098 VDD.n1097 0.0143462
R1939 VDD.n313 VDD.n77 0.0143462
R1940 VDD.n521 VDD.n144 0.0135317
R1941 VDD.n1094 VDD.n21 0.0135317
R1942 VDD.n398 VDD.n251 0.0133926
R1943 VDD.n347 VDD.n290 0.0133926
R1944 VDD.n518 VDD.n158 0.0127172
R1945 VDD.n32 VDD.n26 0.0127172
R1946 VDD.n420 VDD.n240 0.0124008
R1947 VDD.n402 VDD.n249 0.0124008
R1948 VDD.n342 VDD.n341 0.0124008
R1949 VDD.n324 VDD.n309 0.0124008
R1950 VDD.n501 VDD.n162 0.0119027
R1951 VDD.n1088 VDD.n1087 0.0119027
R1952 VDD.n244 VDD.n241 0.0114091
R1953 VDD.n406 VDD.n247 0.0114091
R1954 VDD.n338 VDD.n301 0.0114091
R1955 VDD.n328 VDD.n307 0.0114091
R1956 VDD.n439 VDD.n437 0.0110882
R1957 VDD.n498 VDD.n176 0.0110882
R1958 VDD.n1084 VDD.n40 0.0110882
R1959 VDD.n1065 VDD.n1064 0.0110882
R1960 VDD.n422 VDD.n239 0.0104174
R1961 VDD.n413 VDD.n245 0.0104174
R1962 VDD.n410 VDD.n245 0.0104174
R1963 VDD.n306 VDD.n302 0.0104174
R1964 VDD.n332 VDD.n306 0.0104174
R1965 VDD.n323 VDD.n322 0.0104174
R1966 VDD.n442 VDD.n441 0.0102738
R1967 VDD.n481 VDD.n180 0.0102738
R1968 VDD.n51 VDD.n45 0.0102738
R1969 VDD.n1067 VDD.n77 0.0102738
R1970 VDD.n458 VDD.n457 0.00945928
R1971 VDD.n478 VDD.n194 0.00945928
R1972 VDD.n1078 VDD.n1077 0.00945928
R1973 VDD.n1069 VDD.n70 0.00945928
R1974 VDD.n414 VDD.n244 0.00942562
R1975 VDD.n409 VDD.n247 0.00942562
R1976 VDD.n338 VDD.n337 0.00942562
R1977 VDD.n331 VDD.n307 0.00942562
R1978 VDD.n462 VDD.n461 0.0086448
R1979 VDD.n461 VDD.n198 0.0086448
R1980 VDD.n1074 VDD.n59 0.0086448
R1981 VDD.n1074 VDD.n1073 0.0086448
R1982 VDD.n420 VDD.n419 0.00843388
R1983 VDD.n405 VDD.n249 0.00843388
R1984 VDD.n341 VDD.n293 0.00843388
R1985 VDD.n327 VDD.n309 0.00843388
R1986 VDD.n458 VDD.n212 0.00783032
R1987 VDD.n478 VDD.n477 0.00783032
R1988 VDD.n1077 VDD.n57 0.00783032
R1989 VDD.n70 VDD.n64 0.00783032
R1990 VDD.n401 VDD.n251 0.00744215
R1991 VDD.n291 VDD.n290 0.00744215
R1992 VDD.n441 VDD.n216 0.00701584
R1993 VDD.n482 VDD.n481 0.00701584
R1994 VDD.n1079 VDD.n51 0.00701584
R1995 VDD.n1068 VDD.n1067 0.00701584
R1996 VDD.n397 VDD.n253 0.00645041
R1997 VDD.n348 VDD.n288 0.00645041
R1998 VDD.n439 VDD.n438 0.00620136
R1999 VDD.n498 VDD.n497 0.00620136
R2000 VDD.n1084 VDD.n1083 0.00620136
R2001 VDD.n1065 VDD.n79 0.00620136
R2002 VDD.n393 VDD.n255 0.00545868
R2003 VDD.n352 VDD.n286 0.00545868
R2004 VDD.n502 VDD.n501 0.00538688
R2005 VDD.n1087 VDD.n38 0.00538688
R2006 VDD.n518 VDD.n517 0.0045724
R2007 VDD.n1089 VDD.n32 0.0045724
R2008 VDD.n389 VDD.n257 0.00446694
R2009 VDD.n356 VDD.n284 0.00446694
R2010 VDD.n522 VDD.n521 0.00375792
R2011 VDD.n1094 VDD.n1093 0.00375792
R2012 VDD.n437 VDD.n426 0.0035543
R2013 VDD.n1064 VDD.n80 0.0035543
R2014 VDD.n385 VDD.n259 0.00347521
R2015 VDD.n360 VDD.n282 0.00347521
R2016 VDD.n438 VDD.n230 0.00294344
R2017 VDD.n538 VDD.n537 0.00294344
R2018 VDD.n1097 VDD.n18 0.00294344
R2019 VDD.n313 VDD.n79 0.00294344
R2020 VDD.n381 VDD.n261 0.00248347
R2021 VDD.n364 VDD.n280 0.00248347
R2022 VDD.n550 VDD.n549 0.00212896
R2023 VDD.n1099 VDD.n13 0.00212896
R2024 VDD.n377 VDD.n263 0.00149173
R2025 VDD.n368 VDD.n279 0.00149173
R2026 VDD.n546 VDD.n545 0.00131448
R2027 VDD.n1103 VDD.n6 0.00131448
R2028 VSS.n332 VSS.n53 40962.3
R2029 VSS.n333 VSS.n330 289.236
R2030 VSS.n1354 VSS.n51 289.236
R2031 VSS.n333 VSS.n328 289.236
R2032 VSS.n1356 VSS.n51 289.236
R2033 VSS.n1333 VSS.n67 183.458
R2034 VSS.n1333 VSS.n68 183.458
R2035 VSS.n1076 VSS.n305 183.458
R2036 VSS.n305 VSS.n303 183.458
R2037 VSS.n332 VSS.n329 103.93
R2038 VSS.n53 VSS.n51 96.9715
R2039 VSS.n339 VSS.n329 59.3883
R2040 VSS.n339 VSS.n322 59.3883
R2041 VSS.n348 VSS.n322 59.3883
R2042 VSS.n348 VSS.n315 59.3883
R2043 VSS.n356 VSS.n315 59.3883
R2044 VSS.n1077 VSS.n302 59.3883
R2045 VSS.n1085 VSS.n296 59.3883
R2046 VSS.n1101 VSS.n281 59.3883
R2047 VSS.n1109 VSS.n273 59.3883
R2048 VSS.n1117 VSS.n265 59.3883
R2049 VSS.n1133 VSS.n248 59.3883
R2050 VSS.n1141 VSS.n240 59.3883
R2051 VSS.n1149 VSS.n232 59.3883
R2052 VSS.n1165 VSS.n217 59.3883
R2053 VSS.n1173 VSS.n209 59.3883
R2054 VSS.n1181 VSS.n201 59.3883
R2055 VSS.n1189 VSS.n193 59.3883
R2056 VSS.n1197 VSS.n184 59.3883
R2057 VSS.n1205 VSS.n177 59.3883
R2058 VSS.n1213 VSS.n170 59.3883
R2059 VSS.n1221 VSS.n163 59.3883
R2060 VSS.n1229 VSS.n155 59.3883
R2061 VSS.n1245 VSS.n142 59.3883
R2062 VSS.n1261 VSS.n129 59.3883
R2063 VSS.n1269 VSS.n122 59.3883
R2064 VSS.n1277 VSS.n114 59.3883
R2065 VSS.n1285 VSS.n108 59.3883
R2066 VSS.n1293 VSS.n101 59.3883
R2067 VSS.n1301 VSS.n93 59.3883
R2068 VSS.n1318 VSS.n80 59.3883
R2069 VSS.n1335 VSS.n66 59.3883
R2070 VSS.n1343 VSS.n59 59.3883
R2071 VSS.n1345 VSS.n1343 59.3883
R2072 VSS.n1346 VSS.n1345 59.3883
R2073 VSS.n1346 VSS.n52 59.3883
R2074 VSS.n1355 VSS.n52 59.3883
R2075 VSS.n1009 VSS.t176 58.646
R2076 VSS.n1125 VSS.t89 57.9037
R2077 VSS.n1125 VSS.t86 57.9037
R2078 VSS.n954 VSS.t29 57.9037
R2079 VSS.n954 VSS.t26 57.9037
R2080 VSS.n1133 VSS.t83 54.9343
R2081 VSS.t32 VSS.n114 54.9343
R2082 VSS.n1109 VSS.t95 51.9649
R2083 VSS.n1141 VSS.t80 51.9649
R2084 VSS.t35 VSS.n122 51.9649
R2085 VSS.n101 VSS.t20 51.9649
R2086 VSS.n1117 VSS.t4 51.2225
R2087 VSS.n1237 VSS.t8 51.2225
R2088 VSS.n316 VSS.n302 50.4802
R2089 VSS.n1335 VSS.n1334 50.4802
R2090 VSS.n1101 VSS.t98 48.9955
R2091 VSS.n1149 VSS.t77 48.9955
R2092 VSS.t38 VSS.n129 48.9955
R2093 VSS.n93 VSS.t17 48.9955
R2094 VSS.n1093 VSS.t101 46.0261
R2095 VSS.n1157 VSS.t74 46.0261
R2096 VSS.n968 VSS.t41 46.0261
R2097 VSS.n940 VSS.t14 46.0261
R2098 VSS.n1093 VSS.t2 45.2837
R2099 VSS.n1085 VSS.t104 43.0567
R2100 VSS.n1165 VSS.t71 43.0567
R2101 VSS.t44 VSS.n142 43.0567
R2102 VSS.n80 VSS.t11 43.0567
R2103 VSS.n1253 VSS.t0 42.3143
R2104 VSS.n108 VSS.t181 40.8296
R2105 VSS.n1173 VSS.t68 40.0873
R2106 VSS.n976 VSS.t47 40.0873
R2107 VSS.n1077 VSS.t110 37.8603
R2108 VSS.t107 VSS.n66 37.8603
R2109 VSS.n1181 VSS.t65 37.1179
R2110 VSS.t50 VSS.n155 37.1179
R2111 VSS.n1189 VSS.t62 34.1485
R2112 VSS.t53 VSS.t1 33.4062
R2113 VSS.n513 VSS.t109 32.8675
R2114 VSS.n662 VSS.t106 32.8675
R2115 VSS.n940 VSS.t178 31.9215
R2116 VSS.n1197 VSS.t59 31.1791
R2117 VSS.t56 VSS.n170 31.1791
R2118 VSS.n1205 VSS.t56 28.2097
R2119 VSS.n1309 VSS.t178 27.4674
R2120 VSS.n930 VSS.t179 26.0911
R2121 VSS.t62 VSS.n184 25.2403
R2122 VSS.n1213 VSS.t53 25.2403
R2123 VSS.n929 VSS.t9 24.331
R2124 VSS.n928 VSS.t7 24.331
R2125 VSS.n927 VSS.t5 24.331
R2126 VSS.n926 VSS.t3 24.331
R2127 VSS.t65 VSS.n193 22.2709
R2128 VSS.n1221 VSS.t50 22.2709
R2129 VSS.n1067 VSS.t110 21.5286
R2130 VSS.n1327 VSS.t107 21.5286
R2131 VSS.t68 VSS.n201 19.3016
R2132 VSS.n1229 VSS.t47 19.3016
R2133 VSS.t59 VSS.t6 18.5592
R2134 VSS.n968 VSS.t0 17.0745
R2135 VSS.n1067 VSS.t104 16.3322
R2136 VSS.t71 VSS.n209 16.3322
R2137 VSS.n1237 VSS.t44 16.3322
R2138 VSS.n1327 VSS.t11 16.3322
R2139 VSS.n1076 VSS.n293 15.5561
R2140 VSS.n1086 VSS.n293 15.5561
R2141 VSS.n1086 VSS.n289 15.5561
R2142 VSS.n1092 VSS.n289 15.5561
R2143 VSS.n1092 VSS.n278 15.5561
R2144 VSS.n1102 VSS.n278 15.5561
R2145 VSS.n1102 VSS.n274 15.5561
R2146 VSS.n1108 VSS.n274 15.5561
R2147 VSS.n1108 VSS.n262 15.5561
R2148 VSS.n1118 VSS.n262 15.5561
R2149 VSS.n1118 VSS.n258 15.5561
R2150 VSS.n1124 VSS.n258 15.5561
R2151 VSS.n1124 VSS.n247 15.5561
R2152 VSS.n1134 VSS.n247 15.5561
R2153 VSS.n1134 VSS.n243 15.5561
R2154 VSS.n1140 VSS.n243 15.5561
R2155 VSS.n1140 VSS.n231 15.5561
R2156 VSS.n1150 VSS.n231 15.5561
R2157 VSS.n1150 VSS.n227 15.5561
R2158 VSS.n1156 VSS.n227 15.5561
R2159 VSS.n1156 VSS.n216 15.5561
R2160 VSS.n1166 VSS.n216 15.5561
R2161 VSS.n1166 VSS.n212 15.5561
R2162 VSS.n1172 VSS.n212 15.5561
R2163 VSS.n1172 VSS.n200 15.5561
R2164 VSS.n1182 VSS.n200 15.5561
R2165 VSS.n1182 VSS.n196 15.5561
R2166 VSS.n1188 VSS.n196 15.5561
R2167 VSS.n1188 VSS.n183 15.5561
R2168 VSS.n1198 VSS.n183 15.5561
R2169 VSS.n1198 VSS.n179 15.5561
R2170 VSS.n1204 VSS.n179 15.5561
R2171 VSS.n1204 VSS.n169 15.5561
R2172 VSS.n1214 VSS.n169 15.5561
R2173 VSS.n1214 VSS.n165 15.5561
R2174 VSS.n1220 VSS.n165 15.5561
R2175 VSS.n1220 VSS.n154 15.5561
R2176 VSS.n1230 VSS.n154 15.5561
R2177 VSS.n1230 VSS.n150 15.5561
R2178 VSS.n1236 VSS.n150 15.5561
R2179 VSS.n1236 VSS.n141 15.5561
R2180 VSS.n1246 VSS.n141 15.5561
R2181 VSS.n1246 VSS.n137 15.5561
R2182 VSS.n1252 VSS.n137 15.5561
R2183 VSS.n1252 VSS.n128 15.5561
R2184 VSS.n1262 VSS.n128 15.5561
R2185 VSS.n1262 VSS.n124 15.5561
R2186 VSS.n1268 VSS.n124 15.5561
R2187 VSS.n1268 VSS.n113 15.5561
R2188 VSS.n1278 VSS.n113 15.5561
R2189 VSS.n1278 VSS.n109 15.5561
R2190 VSS.n1284 VSS.n109 15.5561
R2191 VSS.n1284 VSS.n98 15.5561
R2192 VSS.n1294 VSS.n98 15.5561
R2193 VSS.n1294 VSS.n94 15.5561
R2194 VSS.n1300 VSS.n94 15.5561
R2195 VSS.n1300 VSS.n85 15.5561
R2196 VSS.n1310 VSS.n85 15.5561
R2197 VSS.n1310 VSS.n81 15.5561
R2198 VSS.n1317 VSS.n81 15.5561
R2199 VSS.n1317 VSS.n72 15.5561
R2200 VSS.n1328 VSS.n72 15.5561
R2201 VSS.n1328 VSS.n68 15.5561
R2202 VSS.n1068 VSS.n303 15.5561
R2203 VSS.n1068 VSS.n294 15.5561
R2204 VSS.n708 VSS.n294 15.5561
R2205 VSS.n708 VSS.n287 15.5561
R2206 VSS.n728 VSS.n287 15.5561
R2207 VSS.n728 VSS.n279 15.5561
R2208 VSS.n701 VSS.n279 15.5561
R2209 VSS.n701 VSS.n271 15.5561
R2210 VSS.n745 VSS.n271 15.5561
R2211 VSS.n745 VSS.n263 15.5561
R2212 VSS.n757 VSS.n263 15.5561
R2213 VSS.n757 VSS.n256 15.5561
R2214 VSS.n759 VSS.n256 15.5561
R2215 VSS.n759 VSS.n249 15.5561
R2216 VSS.n775 VSS.n249 15.5561
R2217 VSS.n775 VSS.n241 15.5561
R2218 VSS.n778 VSS.n241 15.5561
R2219 VSS.n778 VSS.n233 15.5561
R2220 VSS.n1008 VSS.n233 15.5561
R2221 VSS.n1008 VSS.n225 15.5561
R2222 VSS.n1004 VSS.n225 15.5561
R2223 VSS.n1004 VSS.n218 15.5561
R2224 VSS.n1001 VSS.n218 15.5561
R2225 VSS.n1001 VSS.n210 15.5561
R2226 VSS.n998 VSS.n210 15.5561
R2227 VSS.n998 VSS.n202 15.5561
R2228 VSS.n995 VSS.n202 15.5561
R2229 VSS.n995 VSS.n194 15.5561
R2230 VSS.n992 VSS.n194 15.5561
R2231 VSS.n992 VSS.n185 15.5561
R2232 VSS.n989 VSS.n185 15.5561
R2233 VSS.n989 VSS.n178 15.5561
R2234 VSS.n986 VSS.n178 15.5561
R2235 VSS.n986 VSS.n171 15.5561
R2236 VSS.n983 VSS.n171 15.5561
R2237 VSS.n983 VSS.n164 15.5561
R2238 VSS.n980 VSS.n164 15.5561
R2239 VSS.n980 VSS.n156 15.5561
R2240 VSS.n977 VSS.n156 15.5561
R2241 VSS.n977 VSS.n149 15.5561
R2242 VSS.n972 VSS.n149 15.5561
R2243 VSS.n972 VSS.n143 15.5561
R2244 VSS.n969 VSS.n143 15.5561
R2245 VSS.n969 VSS.n136 15.5561
R2246 VSS.n964 VSS.n136 15.5561
R2247 VSS.n964 VSS.n130 15.5561
R2248 VSS.n961 VSS.n130 15.5561
R2249 VSS.n961 VSS.n123 15.5561
R2250 VSS.n958 VSS.n123 15.5561
R2251 VSS.n958 VSS.n115 15.5561
R2252 VSS.n955 VSS.n115 15.5561
R2253 VSS.n955 VSS.n107 15.5561
R2254 VSS.n950 VSS.n107 15.5561
R2255 VSS.n950 VSS.n99 15.5561
R2256 VSS.n947 VSS.n99 15.5561
R2257 VSS.n947 VSS.n92 15.5561
R2258 VSS.n944 VSS.n92 15.5561
R2259 VSS.n944 VSS.n86 15.5561
R2260 VSS.n941 VSS.n86 15.5561
R2261 VSS.n941 VSS.n79 15.5561
R2262 VSS.n936 VSS.n79 15.5561
R2263 VSS.n936 VSS.n73 15.5561
R2264 VSS.n73 VSS.n67 15.5561
R2265 VSS.n338 VSS.n330 15.5561
R2266 VSS.n338 VSS.n321 15.5561
R2267 VSS.n349 VSS.n321 15.5561
R2268 VSS.n349 VSS.n317 15.5561
R2269 VSS.n355 VSS.n317 15.5561
R2270 VSS.n355 VSS.n301 15.5561
R2271 VSS.n1078 VSS.n301 15.5561
R2272 VSS.n1078 VSS.n297 15.5561
R2273 VSS.n1084 VSS.n297 15.5561
R2274 VSS.n1084 VSS.n286 15.5561
R2275 VSS.n1094 VSS.n286 15.5561
R2276 VSS.n1094 VSS.n282 15.5561
R2277 VSS.n1100 VSS.n282 15.5561
R2278 VSS.n1100 VSS.n270 15.5561
R2279 VSS.n1110 VSS.n270 15.5561
R2280 VSS.n1110 VSS.n266 15.5561
R2281 VSS.n1116 VSS.n266 15.5561
R2282 VSS.n1116 VSS.n255 15.5561
R2283 VSS.n1126 VSS.n255 15.5561
R2284 VSS.n1126 VSS.n251 15.5561
R2285 VSS.n1132 VSS.n251 15.5561
R2286 VSS.n1132 VSS.n239 15.5561
R2287 VSS.n1142 VSS.n239 15.5561
R2288 VSS.n1142 VSS.n235 15.5561
R2289 VSS.n1148 VSS.n235 15.5561
R2290 VSS.n1148 VSS.n224 15.5561
R2291 VSS.n1158 VSS.n224 15.5561
R2292 VSS.n1158 VSS.n220 15.5561
R2293 VSS.n1164 VSS.n220 15.5561
R2294 VSS.n1164 VSS.n208 15.5561
R2295 VSS.n1174 VSS.n208 15.5561
R2296 VSS.n1174 VSS.n204 15.5561
R2297 VSS.n1180 VSS.n204 15.5561
R2298 VSS.n1180 VSS.n192 15.5561
R2299 VSS.n1190 VSS.n192 15.5561
R2300 VSS.n1190 VSS.n188 15.5561
R2301 VSS.n1196 VSS.n188 15.5561
R2302 VSS.n1196 VSS.n176 15.5561
R2303 VSS.n1206 VSS.n176 15.5561
R2304 VSS.n1206 VSS.n172 15.5561
R2305 VSS.n1212 VSS.n172 15.5561
R2306 VSS.n1212 VSS.n161 15.5561
R2307 VSS.n1222 VSS.n161 15.5561
R2308 VSS.n1222 VSS.n157 15.5561
R2309 VSS.n1228 VSS.n157 15.5561
R2310 VSS.n1228 VSS.n148 15.5561
R2311 VSS.n1238 VSS.n148 15.5561
R2312 VSS.n1238 VSS.n144 15.5561
R2313 VSS.n1244 VSS.n144 15.5561
R2314 VSS.n1244 VSS.n135 15.5561
R2315 VSS.n1254 VSS.n135 15.5561
R2316 VSS.n1254 VSS.n131 15.5561
R2317 VSS.n1260 VSS.n131 15.5561
R2318 VSS.n1260 VSS.n120 15.5561
R2319 VSS.n1270 VSS.n120 15.5561
R2320 VSS.n1270 VSS.n116 15.5561
R2321 VSS.n1276 VSS.n116 15.5561
R2322 VSS.n1276 VSS.n106 15.5561
R2323 VSS.n1286 VSS.n106 15.5561
R2324 VSS.n1286 VSS.n102 15.5561
R2325 VSS.n1292 VSS.n102 15.5561
R2326 VSS.n1292 VSS.n91 15.5561
R2327 VSS.n1302 VSS.n91 15.5561
R2328 VSS.n1302 VSS.n87 15.5561
R2329 VSS.n1308 VSS.n87 15.5561
R2330 VSS.n1308 VSS.n78 15.5561
R2331 VSS.n1319 VSS.n78 15.5561
R2332 VSS.n1319 VSS.n74 15.5561
R2333 VSS.n1326 VSS.n74 15.5561
R2334 VSS.n1326 VSS.n64 15.5561
R2335 VSS.n1336 VSS.n64 15.5561
R2336 VSS.n1336 VSS.n60 15.5561
R2337 VSS.n1342 VSS.n60 15.5561
R2338 VSS.n1342 VSS.n58 15.5561
R2339 VSS.n1347 VSS.n58 15.5561
R2340 VSS.n1347 VSS.n54 15.5561
R2341 VSS.n1354 VSS.n54 15.5561
R2342 VSS.n340 VSS.n328 15.5561
R2343 VSS.n340 VSS.n323 15.5561
R2344 VSS.n347 VSS.n323 15.5561
R2345 VSS.n347 VSS.n314 15.5561
R2346 VSS.n357 VSS.n314 15.5561
R2347 VSS.n358 VSS.n357 15.5561
R2348 VSS.n358 VSS.n304 15.5561
R2349 VSS.n1066 VSS.n304 15.5561
R2350 VSS.n1066 VSS.n295 15.5561
R2351 VSS.n363 VSS.n295 15.5561
R2352 VSS.n363 VSS.n288 15.5561
R2353 VSS.n364 VSS.n288 15.5561
R2354 VSS.n364 VSS.n280 15.5561
R2355 VSS.n367 VSS.n280 15.5561
R2356 VSS.n367 VSS.n272 15.5561
R2357 VSS.n368 VSS.n272 15.5561
R2358 VSS.n368 VSS.n264 15.5561
R2359 VSS.n371 VSS.n264 15.5561
R2360 VSS.n371 VSS.n257 15.5561
R2361 VSS.n372 VSS.n257 15.5561
R2362 VSS.n372 VSS.n250 15.5561
R2363 VSS.n375 VSS.n250 15.5561
R2364 VSS.n375 VSS.n242 15.5561
R2365 VSS.n376 VSS.n242 15.5561
R2366 VSS.n376 VSS.n234 15.5561
R2367 VSS.n1010 VSS.n234 15.5561
R2368 VSS.n1010 VSS.n226 15.5561
R2369 VSS.n1011 VSS.n226 15.5561
R2370 VSS.n1011 VSS.n219 15.5561
R2371 VSS.n1014 VSS.n219 15.5561
R2372 VSS.n1014 VSS.n211 15.5561
R2373 VSS.n1015 VSS.n211 15.5561
R2374 VSS.n1015 VSS.n203 15.5561
R2375 VSS.n1018 VSS.n203 15.5561
R2376 VSS.n1018 VSS.n195 15.5561
R2377 VSS.n1019 VSS.n195 15.5561
R2378 VSS.n1019 VSS.n187 15.5561
R2379 VSS.n187 VSS.n186 15.5561
R2380 VSS.n186 VSS.n3 15.5561
R2381 VSS.n4 VSS.n3 15.5561
R2382 VSS.n5 VSS.n4 15.5561
R2383 VSS.n162 VSS.n5 15.5561
R2384 VSS.n162 VSS.n8 15.5561
R2385 VSS.n9 VSS.n8 15.5561
R2386 VSS.n10 VSS.n9 15.5561
R2387 VSS.n975 VSS.n10 15.5561
R2388 VSS.n975 VSS.n13 15.5561
R2389 VSS.n14 VSS.n13 15.5561
R2390 VSS.n15 VSS.n14 15.5561
R2391 VSS.n967 VSS.n15 15.5561
R2392 VSS.n967 VSS.n18 15.5561
R2393 VSS.n19 VSS.n18 15.5561
R2394 VSS.n20 VSS.n19 15.5561
R2395 VSS.n121 VSS.n20 15.5561
R2396 VSS.n121 VSS.n23 15.5561
R2397 VSS.n24 VSS.n23 15.5561
R2398 VSS.n25 VSS.n24 15.5561
R2399 VSS.n953 VSS.n25 15.5561
R2400 VSS.n953 VSS.n28 15.5561
R2401 VSS.n29 VSS.n28 15.5561
R2402 VSS.n30 VSS.n29 15.5561
R2403 VSS.n100 VSS.n30 15.5561
R2404 VSS.n100 VSS.n33 15.5561
R2405 VSS.n34 VSS.n33 15.5561
R2406 VSS.n35 VSS.n34 15.5561
R2407 VSS.n939 VSS.n35 15.5561
R2408 VSS.n939 VSS.n38 15.5561
R2409 VSS.n39 VSS.n38 15.5561
R2410 VSS.n40 VSS.n39 15.5561
R2411 VSS.n65 VSS.n40 15.5561
R2412 VSS.n65 VSS.n43 15.5561
R2413 VSS.n44 VSS.n43 15.5561
R2414 VSS.n45 VSS.n44 15.5561
R2415 VSS.n1344 VSS.n45 15.5561
R2416 VSS.n1344 VSS.n48 15.5561
R2417 VSS.n49 VSS.n48 15.5561
R2418 VSS.n1356 VSS.n49 15.5561
R2419 VSS.n727 VSS.t2 14.1051
R2420 VSS.t181 VSS.t23 14.1051
R2421 VSS.n296 VSS.t101 13.3628
R2422 VSS.t74 VSS.n217 13.3628
R2423 VSS.n1245 VSS.t41 13.3628
R2424 VSS.n1318 VSS.t14 13.3628
R2425 VSS.n919 VSS.n918 12.5005
R2426 VSS.n660 VSS.n659 12.5005
R2427 VSS.n658 VSS.n657 12.5005
R2428 VSS.n656 VSS.n655 12.5005
R2429 VSS.n654 VSS.n653 12.5005
R2430 VSS.n652 VSS.n651 12.5005
R2431 VSS.n650 VSS.n649 12.5005
R2432 VSS.n648 VSS.n647 12.5005
R2433 VSS.n646 VSS.n645 12.5005
R2434 VSS.n644 VSS.n643 12.5005
R2435 VSS.n642 VSS.n641 12.5005
R2436 VSS.n640 VSS.n639 12.5005
R2437 VSS.n638 VSS.n637 12.5005
R2438 VSS.n636 VSS.n635 12.5005
R2439 VSS.n634 VSS.n633 12.5005
R2440 VSS.n632 VSS.n631 12.5005
R2441 VSS.n630 VSS.n629 12.5005
R2442 VSS.n628 VSS.n627 12.5005
R2443 VSS.n626 VSS.n625 12.5005
R2444 VSS.n624 VSS.n623 12.5005
R2445 VSS.n622 VSS.n621 12.5005
R2446 VSS.n620 VSS.n619 12.5005
R2447 VSS.n618 VSS.n617 12.5005
R2448 VSS.n616 VSS.n615 12.5005
R2449 VSS.n614 VSS.n613 12.5005
R2450 VSS.n612 VSS.n611 12.5005
R2451 VSS.n610 VSS.n609 12.5005
R2452 VSS.n608 VSS.n607 12.5005
R2453 VSS.n606 VSS.n605 12.5005
R2454 VSS.n604 VSS.n603 12.5005
R2455 VSS.n602 VSS.n601 12.5005
R2456 VSS.n600 VSS.n599 12.5005
R2457 VSS.n597 VSS.n461 12.5005
R2458 VSS.n596 VSS.n595 12.5005
R2459 VSS.n588 VSS.n479 12.5005
R2460 VSS.n590 VSS.n589 12.5005
R2461 VSS.n586 VSS.n480 12.5005
R2462 VSS.n585 VSS.n584 12.5005
R2463 VSS.n577 VSS.n482 12.5005
R2464 VSS.n579 VSS.n578 12.5005
R2465 VSS.n575 VSS.n483 12.5005
R2466 VSS.n574 VSS.n573 12.5005
R2467 VSS.n566 VSS.n485 12.5005
R2468 VSS.n568 VSS.n567 12.5005
R2469 VSS.n564 VSS.n486 12.5005
R2470 VSS.n563 VSS.n562 12.5005
R2471 VSS.n555 VSS.n488 12.5005
R2472 VSS.n557 VSS.n556 12.5005
R2473 VSS.n553 VSS.n489 12.5005
R2474 VSS.n552 VSS.n551 12.5005
R2475 VSS.n544 VSS.n491 12.5005
R2476 VSS.n546 VSS.n545 12.5005
R2477 VSS.n542 VSS.n492 12.5005
R2478 VSS.n541 VSS.n540 12.5005
R2479 VSS.n533 VSS.n494 12.5005
R2480 VSS.n535 VSS.n534 12.5005
R2481 VSS.n531 VSS.n495 12.5005
R2482 VSS.n530 VSS.n529 12.5005
R2483 VSS.n522 VSS.n497 12.5005
R2484 VSS.n524 VSS.n523 12.5005
R2485 VSS.n520 VSS.n498 12.5005
R2486 VSS.n519 VSS.n518 12.5005
R2487 VSS.n921 VSS.n920 12.5005
R2488 VSS.n916 VSS.n915 12.5005
R2489 VSS.n914 VSS.n913 12.5005
R2490 VSS.n906 VSS.n905 12.5005
R2491 VSS.n908 VSS.n907 12.5005
R2492 VSS.n903 VSS.n902 12.5005
R2493 VSS.n901 VSS.n900 12.5005
R2494 VSS.n893 VSS.n892 12.5005
R2495 VSS.n895 VSS.n894 12.5005
R2496 VSS.n890 VSS.n889 12.5005
R2497 VSS.n888 VSS.n887 12.5005
R2498 VSS.n885 VSS.n884 12.5005
R2499 VSS.n675 VSS.n674 12.5005
R2500 VSS.n878 VSS.n877 12.5005
R2501 VSS.n875 VSS.n874 12.5005
R2502 VSS.n872 VSS.n871 12.5005
R2503 VSS.n677 VSS.n676 12.5005
R2504 VSS.n866 VSS.n865 12.5005
R2505 VSS.n863 VSS.n862 12.5005
R2506 VSS.n860 VSS.n859 12.5005
R2507 VSS.n679 VSS.n678 12.5005
R2508 VSS.n854 VSS.n853 12.5005
R2509 VSS.n851 VSS.n850 12.5005
R2510 VSS.n848 VSS.n847 12.5005
R2511 VSS.n681 VSS.n680 12.5005
R2512 VSS.n842 VSS.n841 12.5005
R2513 VSS.n839 VSS.n838 12.5005
R2514 VSS.n836 VSS.n835 12.5005
R2515 VSS.n683 VSS.n682 12.5005
R2516 VSS.n831 VSS.n830 12.5005
R2517 VSS.n827 VSS.n826 12.5005
R2518 VSS.n825 VSS.n824 12.5005
R2519 VSS.n817 VSS.n816 12.5005
R2520 VSS.n819 VSS.n818 12.5005
R2521 VSS.n814 VSS.n813 12.5005
R2522 VSS.n812 VSS.n811 12.5005
R2523 VSS.n804 VSS.n803 12.5005
R2524 VSS.n806 VSS.n805 12.5005
R2525 VSS.n801 VSS.n800 12.5005
R2526 VSS.n799 VSS.n798 12.5005
R2527 VSS.n791 VSS.n790 12.5005
R2528 VSS.n793 VSS.n792 12.5005
R2529 VSS.n788 VSS.n787 12.5005
R2530 VSS.n688 VSS.n687 12.5005
R2531 VSS.n769 VSS.n690 12.5005
R2532 VSS.n770 VSS.n689 12.5005
R2533 VSS.n773 VSS.n772 12.5005
R2534 VSS.n767 VSS.n766 12.5005
R2535 VSS.n751 VSS.n696 12.5005
R2536 VSS.n752 VSS.n695 12.5005
R2537 VSS.n755 VSS.n754 12.5005
R2538 VSS.n750 VSS.n749 12.5005
R2539 VSS.n733 VSS.n700 12.5005
R2540 VSS.n734 VSS.n703 12.5005
R2541 VSS.n737 VSS.n736 12.5005
R2542 VSS.n732 VSS.n731 12.5005
R2543 VSS.n715 VSS.n707 12.5005
R2544 VSS.n716 VSS.n710 12.5005
R2545 VSS.n719 VSS.n718 12.5005
R2546 VSS.n714 VSS.n713 12.5005
R2547 VSS.n924 VSS.t12 12.1268
R2548 VSS.t105 VSS.n307 12.1268
R2549 VSS.t113 VSS.n426 12.1268
R2550 VSS.t175 VSS.n515 12.1268
R2551 VSS.n727 VSS.t98 10.3934
R2552 VSS.n1009 VSS.t77 10.3934
R2553 VSS.n1253 VSS.t38 10.3934
R2554 VSS.n1309 VSS.t17 10.3934
R2555 VSS.n736 VSS.n732 9.86111
R2556 VSS.n734 VSS.n733 9.86111
R2557 VSS.n754 VSS.n750 9.86111
R2558 VSS.n752 VSS.n751 9.86111
R2559 VSS.n772 VSS.n767 9.86111
R2560 VSS.n770 VSS.n769 9.86111
R2561 VSS.n788 VSS.n687 9.86111
R2562 VSS.n872 VSS.n677 9.86111
R2563 VSS.n877 VSS.n875 9.86111
R2564 VSS.n885 VSS.n675 9.86111
R2565 VSS.n890 VSS.n888 9.86111
R2566 VSS.n894 VSS.n893 9.86111
R2567 VSS.n903 VSS.n901 9.86111
R2568 VSS.n907 VSS.n906 9.86111
R2569 VSS.n531 VSS.n530 9.86111
R2570 VSS.n534 VSS.n533 9.86111
R2571 VSS.n542 VSS.n541 9.86111
R2572 VSS.n545 VSS.n544 9.86111
R2573 VSS.n553 VSS.n552 9.86111
R2574 VSS.n556 VSS.n555 9.86111
R2575 VSS.n564 VSS.n563 9.86111
R2576 VSS.n627 VSS.n626 9.86111
R2577 VSS.n631 VSS.n630 9.86111
R2578 VSS.n635 VSS.n634 9.86111
R2579 VSS.n639 VSS.n638 9.86111
R2580 VSS.n643 VSS.n642 9.86111
R2581 VSS.n647 VSS.n646 9.86111
R2582 VSS.n651 VSS.n650 9.86111
R2583 VSS.t6 VSS.n177 9.65103
R2584 VSS.n716 VSS.n715 9.55788
R2585 VSS.n792 VSS.n791 9.55788
R2586 VSS.n865 VSS.n863 9.55788
R2587 VSS.n916 VSS.n914 9.55788
R2588 VSS.n523 VSS.n522 9.55788
R2589 VSS.n567 VSS.n566 9.55788
R2590 VSS.n623 VSS.n622 9.55788
R2591 VSS.n655 VSS.n654 9.55788
R2592 VSS.n801 VSS.n799 9.25465
R2593 VSS.n860 VSS.n679 9.25465
R2594 VSS.n575 VSS.n574 9.25465
R2595 VSS.n619 VSS.n618 9.25465
R2596 VSS.n805 VSS.n804 8.95142
R2597 VSS.n853 VSS.n851 8.95142
R2598 VSS.n578 VSS.n577 8.95142
R2599 VSS.n615 VSS.n614 8.95142
R2600 VSS.n356 VSS.n316 8.90868
R2601 VSS.n1334 VSS.n59 8.90868
R2602 VSS.n814 VSS.n812 8.64819
R2603 VSS.n848 VSS.n681 8.64819
R2604 VSS.n586 VSS.n585 8.64819
R2605 VSS.n611 VSS.n610 8.64819
R2606 VSS.n923 VSS.n922 8.63568
R2607 VSS.n910 VSS.n909 8.63568
R2608 VSS.n897 VSS.n896 8.63568
R2609 VSS.n883 VSS.n882 8.63568
R2610 VSS.n870 VSS.n869 8.63568
R2611 VSS.n858 VSS.n857 8.63568
R2612 VSS.n846 VSS.n845 8.63568
R2613 VSS.n834 VSS.n833 8.63568
R2614 VSS.n823 VSS.n822 8.63568
R2615 VSS.n810 VSS.n809 8.63568
R2616 VSS.n797 VSS.n796 8.63568
R2617 VSS.n785 VSS.n784 8.63568
R2618 VSS.n765 VSS.n764 8.63568
R2619 VSS.n740 VSS.n698 8.63568
R2620 VSS.n739 VSS.n738 8.63568
R2621 VSS.n721 VSS.n720 8.63568
R2622 VSS.n462 VSS.n431 8.63568
R2623 VSS.n464 VSS.n435 8.63568
R2624 VSS.n466 VSS.n439 8.63568
R2625 VSS.n468 VSS.n443 8.63568
R2626 VSS.n470 VSS.n447 8.63568
R2627 VSS.n472 VSS.n451 8.63568
R2628 VSS.n474 VSS.n455 8.63568
R2629 VSS.n476 VSS.n459 8.63568
R2630 VSS.n594 VSS.n593 8.63568
R2631 VSS.n583 VSS.n582 8.63568
R2632 VSS.n572 VSS.n571 8.63568
R2633 VSS.n561 VSS.n560 8.63568
R2634 VSS.n550 VSS.n549 8.63568
R2635 VSS.n539 VSS.n538 8.63568
R2636 VSS.n528 VSS.n527 8.63568
R2637 VSS.n517 VSS.n516 8.63568
R2638 VSS.n912 VSS.n911 8.59884
R2639 VSS.n899 VSS.n898 8.59884
R2640 VSS.n881 VSS.n412 8.59884
R2641 VSS.n880 VSS.n879 8.59884
R2642 VSS.n868 VSS.n867 8.59884
R2643 VSS.n856 VSS.n855 8.59884
R2644 VSS.n844 VSS.n843 8.59884
R2645 VSS.n832 VSS.n831 8.59884
R2646 VSS.n821 VSS.n820 8.59884
R2647 VSS.n808 VSS.n807 8.59884
R2648 VSS.n795 VSS.n794 8.59884
R2649 VSS.n783 VSS.n782 8.59884
R2650 VSS.n763 VSS.n762 8.59884
R2651 VSS.n742 VSS.n741 8.59884
R2652 VSS.n723 VSS.n722 8.59884
R2653 VSS.n463 VSS.n433 8.59884
R2654 VSS.n465 VSS.n437 8.59884
R2655 VSS.n467 VSS.n441 8.59884
R2656 VSS.n469 VSS.n445 8.59884
R2657 VSS.n471 VSS.n449 8.59884
R2658 VSS.n473 VSS.n453 8.59884
R2659 VSS.n475 VSS.n457 8.59884
R2660 VSS.n600 VSS.n477 8.59884
R2661 VSS.n592 VSS.n591 8.59884
R2662 VSS.n581 VSS.n580 8.59884
R2663 VSS.n570 VSS.n569 8.59884
R2664 VSS.n559 VSS.n558 8.59884
R2665 VSS.n548 VSS.n547 8.59884
R2666 VSS.n537 VSS.n536 8.59884
R2667 VSS.n526 VSS.n525 8.59884
R2668 VSS.n818 VSS.n817 8.34496
R2669 VSS.n841 VSS.n839 8.34496
R2670 VSS.n589 VSS.n588 8.34496
R2671 VSS.n607 VSS.n606 8.34496
R2672 VSS.n976 VSS.t8 8.16633
R2673 VSS.n827 VSS.n825 8.04173
R2674 VSS.n836 VSS.n683 8.04173
R2675 VSS.n597 VSS.n596 8.04173
R2676 VSS.n603 VSS.n602 8.04173
R2677 VSS.n830 VSS.n828 7.59812
R2678 VSS.n830 VSS.n829 7.59812
R2679 VSS.n599 VSS.n598 7.59812
R2680 VSS.n599 VSS.n460 7.59812
R2681 VSS.n714 VSS.t103 7.5925
R2682 VSS.n919 VSS.t10 7.5925
R2683 VSS.n519 VSS.t174 7.5925
R2684 VSS.n659 VSS.t112 7.5925
R2685 VSS.n281 VSS.t95 7.42398
R2686 VSS.t80 VSS.n232 7.42398
R2687 VSS.n1261 VSS.t35 7.42398
R2688 VSS.n1301 VSS.t20 7.42398
R2689 VSS.n1351 VSS.n50 7.41662
R2690 VSS.n1352 VSS.n1351 7.41662
R2691 VSS.n335 VSS.n334 7.41662
R2692 VSS.n334 VSS.n326 7.41662
R2693 VSS.n1355 VSS.n53 7.05281
R2694 VSS.n825 VSS.n684 7.01412
R2695 VSS.n837 VSS.n836 7.01412
R2696 VSS.n596 VSS.n478 7.01412
R2697 VSS.n603 VSS.n458 7.01412
R2698 VSS.n718 VSS.n714 7.0085
R2699 VSS.n920 VSS.n919 7.0085
R2700 VSS.n520 VSS.n519 7.0085
R2701 VSS.n659 VSS.n658 7.0085
R2702 VSS.n818 VSS.n815 6.43012
R2703 VSS.n841 VSS.n840 6.43012
R2704 VSS.n589 VSS.n587 6.43012
R2705 VSS.n607 VSS.n456 6.43012
R2706 VSS.n1332 VSS.n1331 6.35102
R2707 VSS.n1074 VSS.n1073 6.35102
R2708 VSS.n1332 VSS.n69 6.27362
R2709 VSS.n1073 VSS.n1072 6.27362
R2710 VSS.n812 VSS.n685 5.84612
R2711 VSS.n849 VSS.n848 5.84612
R2712 VSS.n585 VSS.n481 5.84612
R2713 VSS.n611 VSS.n454 5.84612
R2714 VSS.n932 VSS.n931 5.4941
R2715 VSS.n931 VSS.n930 5.2943
R2716 VSS.n805 VSS.n802 5.26212
R2717 VSS.n853 VSS.n852 5.26212
R2718 VSS.n578 VSS.n576 5.26212
R2719 VSS.n615 VSS.n452 5.26212
R2720 VSS.n934 VSS.n67 5.2005
R2721 VSS.n67 VSS.n66 5.2005
R2722 VSS.n935 VSS.n73 5.2005
R2723 VSS.n1327 VSS.n73 5.2005
R2724 VSS.n937 VSS.n936 5.2005
R2725 VSS.n936 VSS.n80 5.2005
R2726 VSS.n938 VSS.n79 5.2005
R2727 VSS.n1318 VSS.n79 5.2005
R2728 VSS.n942 VSS.n941 5.2005
R2729 VSS.n941 VSS.n940 5.2005
R2730 VSS.n943 VSS.n86 5.2005
R2731 VSS.n1309 VSS.n86 5.2005
R2732 VSS.n945 VSS.n944 5.2005
R2733 VSS.n944 VSS.n93 5.2005
R2734 VSS.n946 VSS.n92 5.2005
R2735 VSS.n1301 VSS.n92 5.2005
R2736 VSS.n948 VSS.n947 5.2005
R2737 VSS.n947 VSS.n101 5.2005
R2738 VSS.n949 VSS.n99 5.2005
R2739 VSS.n1293 VSS.n99 5.2005
R2740 VSS.n951 VSS.n950 5.2005
R2741 VSS.n950 VSS.n108 5.2005
R2742 VSS.n952 VSS.n107 5.2005
R2743 VSS.n1285 VSS.n107 5.2005
R2744 VSS.n956 VSS.n955 5.2005
R2745 VSS.n955 VSS.n954 5.2005
R2746 VSS.n957 VSS.n115 5.2005
R2747 VSS.n1277 VSS.n115 5.2005
R2748 VSS.n959 VSS.n958 5.2005
R2749 VSS.n958 VSS.n114 5.2005
R2750 VSS.n960 VSS.n123 5.2005
R2751 VSS.n1269 VSS.n123 5.2005
R2752 VSS.n962 VSS.n961 5.2005
R2753 VSS.n961 VSS.n122 5.2005
R2754 VSS.n963 VSS.n130 5.2005
R2755 VSS.n1261 VSS.n130 5.2005
R2756 VSS.n965 VSS.n964 5.2005
R2757 VSS.n964 VSS.n129 5.2005
R2758 VSS.n966 VSS.n136 5.2005
R2759 VSS.n1253 VSS.n136 5.2005
R2760 VSS.n970 VSS.n969 5.2005
R2761 VSS.n969 VSS.n968 5.2005
R2762 VSS.n971 VSS.n143 5.2005
R2763 VSS.n1245 VSS.n143 5.2005
R2764 VSS.n973 VSS.n972 5.2005
R2765 VSS.n972 VSS.n142 5.2005
R2766 VSS.n974 VSS.n149 5.2005
R2767 VSS.n1237 VSS.n149 5.2005
R2768 VSS.n978 VSS.n977 5.2005
R2769 VSS.n977 VSS.n976 5.2005
R2770 VSS.n979 VSS.n156 5.2005
R2771 VSS.n1229 VSS.n156 5.2005
R2772 VSS.n981 VSS.n980 5.2005
R2773 VSS.n980 VSS.n155 5.2005
R2774 VSS.n982 VSS.n164 5.2005
R2775 VSS.n1221 VSS.n164 5.2005
R2776 VSS.n984 VSS.n983 5.2005
R2777 VSS.n983 VSS.n163 5.2005
R2778 VSS.n985 VSS.n171 5.2005
R2779 VSS.n1213 VSS.n171 5.2005
R2780 VSS.n987 VSS.n986 5.2005
R2781 VSS.n986 VSS.n170 5.2005
R2782 VSS.n988 VSS.n178 5.2005
R2783 VSS.n1205 VSS.n178 5.2005
R2784 VSS.n990 VSS.n989 5.2005
R2785 VSS.n989 VSS.n177 5.2005
R2786 VSS.n991 VSS.n185 5.2005
R2787 VSS.n1197 VSS.n185 5.2005
R2788 VSS.n993 VSS.n992 5.2005
R2789 VSS.n992 VSS.n184 5.2005
R2790 VSS.n994 VSS.n194 5.2005
R2791 VSS.n1189 VSS.n194 5.2005
R2792 VSS.n996 VSS.n995 5.2005
R2793 VSS.n995 VSS.n193 5.2005
R2794 VSS.n997 VSS.n202 5.2005
R2795 VSS.n1181 VSS.n202 5.2005
R2796 VSS.n999 VSS.n998 5.2005
R2797 VSS.n998 VSS.n201 5.2005
R2798 VSS.n1000 VSS.n210 5.2005
R2799 VSS.n1173 VSS.n210 5.2005
R2800 VSS.n1002 VSS.n1001 5.2005
R2801 VSS.n1001 VSS.n209 5.2005
R2802 VSS.n1003 VSS.n218 5.2005
R2803 VSS.n1165 VSS.n218 5.2005
R2804 VSS.n1005 VSS.n1004 5.2005
R2805 VSS.n1004 VSS.n217 5.2005
R2806 VSS.n1006 VSS.n225 5.2005
R2807 VSS.n1157 VSS.n225 5.2005
R2808 VSS.n1008 VSS.n1007 5.2005
R2809 VSS.n1009 VSS.n1008 5.2005
R2810 VSS.n379 VSS.n233 5.2005
R2811 VSS.n1149 VSS.n233 5.2005
R2812 VSS.n779 VSS.n778 5.2005
R2813 VSS.n778 VSS.n232 5.2005
R2814 VSS.n780 VSS.n241 5.2005
R2815 VSS.n1141 VSS.n241 5.2005
R2816 VSS.n776 VSS.n775 5.2005
R2817 VSS.n775 VSS.n240 5.2005
R2818 VSS.n691 VSS.n249 5.2005
R2819 VSS.n1133 VSS.n249 5.2005
R2820 VSS.n760 VSS.n759 5.2005
R2821 VSS.n759 VSS.n248 5.2005
R2822 VSS.n761 VSS.n256 5.2005
R2823 VSS.n1125 VSS.n256 5.2005
R2824 VSS.n758 VSS.n757 5.2005
R2825 VSS.n757 VSS.n265 5.2005
R2826 VSS.n697 VSS.n263 5.2005
R2827 VSS.n1117 VSS.n263 5.2005
R2828 VSS.n746 VSS.n745 5.2005
R2829 VSS.n745 VSS.n273 5.2005
R2830 VSS.n744 VSS.n271 5.2005
R2831 VSS.n1109 VSS.n271 5.2005
R2832 VSS.n702 VSS.n701 5.2005
R2833 VSS.n701 VSS.n281 5.2005
R2834 VSS.n726 VSS.n279 5.2005
R2835 VSS.n1101 VSS.n279 5.2005
R2836 VSS.n729 VSS.n728 5.2005
R2837 VSS.n728 VSS.n727 5.2005
R2838 VSS.n725 VSS.n287 5.2005
R2839 VSS.n1093 VSS.n287 5.2005
R2840 VSS.n709 VSS.n708 5.2005
R2841 VSS.n708 VSS.n296 5.2005
R2842 VSS.n309 VSS.n294 5.2005
R2843 VSS.n1085 VSS.n294 5.2005
R2844 VSS.n1069 VSS.n1068 5.2005
R2845 VSS.n1068 VSS.n1067 5.2005
R2846 VSS.n1070 VSS.n303 5.2005
R2847 VSS.n1077 VSS.n303 5.2005
R2848 VSS.n1330 VSS.n68 5.2005
R2849 VSS.n68 VSS.n66 5.2005
R2850 VSS.n1329 VSS.n1328 5.2005
R2851 VSS.n1328 VSS.n1327 5.2005
R2852 VSS.n72 VSS.n71 5.2005
R2853 VSS.n80 VSS.n72 5.2005
R2854 VSS.n1317 VSS.n1316 5.2005
R2855 VSS.n1318 VSS.n1317 5.2005
R2856 VSS.n82 VSS.n81 5.2005
R2857 VSS.n940 VSS.n81 5.2005
R2858 VSS.n1311 VSS.n1310 5.2005
R2859 VSS.n1310 VSS.n1309 5.2005
R2860 VSS.n85 VSS.n84 5.2005
R2861 VSS.n93 VSS.n85 5.2005
R2862 VSS.n1300 VSS.n1299 5.2005
R2863 VSS.n1301 VSS.n1300 5.2005
R2864 VSS.n95 VSS.n94 5.2005
R2865 VSS.n101 VSS.n94 5.2005
R2866 VSS.n1295 VSS.n1294 5.2005
R2867 VSS.n1294 VSS.n1293 5.2005
R2868 VSS.n98 VSS.n97 5.2005
R2869 VSS.n108 VSS.n98 5.2005
R2870 VSS.n1284 VSS.n1283 5.2005
R2871 VSS.n1285 VSS.n1284 5.2005
R2872 VSS.n110 VSS.n109 5.2005
R2873 VSS.n954 VSS.n109 5.2005
R2874 VSS.n1279 VSS.n1278 5.2005
R2875 VSS.n1278 VSS.n1277 5.2005
R2876 VSS.n113 VSS.n112 5.2005
R2877 VSS.n114 VSS.n113 5.2005
R2878 VSS.n1268 VSS.n1267 5.2005
R2879 VSS.n1269 VSS.n1268 5.2005
R2880 VSS.n125 VSS.n124 5.2005
R2881 VSS.n124 VSS.n122 5.2005
R2882 VSS.n1263 VSS.n1262 5.2005
R2883 VSS.n1262 VSS.n1261 5.2005
R2884 VSS.n128 VSS.n127 5.2005
R2885 VSS.n129 VSS.n128 5.2005
R2886 VSS.n1252 VSS.n1251 5.2005
R2887 VSS.n1253 VSS.n1252 5.2005
R2888 VSS.n138 VSS.n137 5.2005
R2889 VSS.n968 VSS.n137 5.2005
R2890 VSS.n1247 VSS.n1246 5.2005
R2891 VSS.n1246 VSS.n1245 5.2005
R2892 VSS.n141 VSS.n140 5.2005
R2893 VSS.n142 VSS.n141 5.2005
R2894 VSS.n1236 VSS.n1235 5.2005
R2895 VSS.n1237 VSS.n1236 5.2005
R2896 VSS.n151 VSS.n150 5.2005
R2897 VSS.n976 VSS.n150 5.2005
R2898 VSS.n1231 VSS.n1230 5.2005
R2899 VSS.n1230 VSS.n1229 5.2005
R2900 VSS.n154 VSS.n153 5.2005
R2901 VSS.n155 VSS.n154 5.2005
R2902 VSS.n1220 VSS.n1219 5.2005
R2903 VSS.n1221 VSS.n1220 5.2005
R2904 VSS.n166 VSS.n165 5.2005
R2905 VSS.n165 VSS.n163 5.2005
R2906 VSS.n1215 VSS.n1214 5.2005
R2907 VSS.n1214 VSS.n1213 5.2005
R2908 VSS.n169 VSS.n168 5.2005
R2909 VSS.n170 VSS.n169 5.2005
R2910 VSS.n1204 VSS.n1203 5.2005
R2911 VSS.n1205 VSS.n1204 5.2005
R2912 VSS.n180 VSS.n179 5.2005
R2913 VSS.n179 VSS.n177 5.2005
R2914 VSS.n1199 VSS.n1198 5.2005
R2915 VSS.n1198 VSS.n1197 5.2005
R2916 VSS.n183 VSS.n182 5.2005
R2917 VSS.n184 VSS.n183 5.2005
R2918 VSS.n1188 VSS.n1187 5.2005
R2919 VSS.n1189 VSS.n1188 5.2005
R2920 VSS.n197 VSS.n196 5.2005
R2921 VSS.n196 VSS.n193 5.2005
R2922 VSS.n1183 VSS.n1182 5.2005
R2923 VSS.n1182 VSS.n1181 5.2005
R2924 VSS.n200 VSS.n199 5.2005
R2925 VSS.n201 VSS.n200 5.2005
R2926 VSS.n1172 VSS.n1171 5.2005
R2927 VSS.n1173 VSS.n1172 5.2005
R2928 VSS.n213 VSS.n212 5.2005
R2929 VSS.n212 VSS.n209 5.2005
R2930 VSS.n1167 VSS.n1166 5.2005
R2931 VSS.n1166 VSS.n1165 5.2005
R2932 VSS.n216 VSS.n215 5.2005
R2933 VSS.n217 VSS.n216 5.2005
R2934 VSS.n1156 VSS.n1155 5.2005
R2935 VSS.n1157 VSS.n1156 5.2005
R2936 VSS.n228 VSS.n227 5.2005
R2937 VSS.n1009 VSS.n227 5.2005
R2938 VSS.n1151 VSS.n1150 5.2005
R2939 VSS.n1150 VSS.n1149 5.2005
R2940 VSS.n231 VSS.n230 5.2005
R2941 VSS.n232 VSS.n231 5.2005
R2942 VSS.n1140 VSS.n1139 5.2005
R2943 VSS.n1141 VSS.n1140 5.2005
R2944 VSS.n244 VSS.n243 5.2005
R2945 VSS.n243 VSS.n240 5.2005
R2946 VSS.n1135 VSS.n1134 5.2005
R2947 VSS.n1134 VSS.n1133 5.2005
R2948 VSS.n247 VSS.n246 5.2005
R2949 VSS.n248 VSS.n247 5.2005
R2950 VSS.n1124 VSS.n1123 5.2005
R2951 VSS.n1125 VSS.n1124 5.2005
R2952 VSS.n259 VSS.n258 5.2005
R2953 VSS.n265 VSS.n258 5.2005
R2954 VSS.n1119 VSS.n1118 5.2005
R2955 VSS.n1118 VSS.n1117 5.2005
R2956 VSS.n262 VSS.n261 5.2005
R2957 VSS.n273 VSS.n262 5.2005
R2958 VSS.n1108 VSS.n1107 5.2005
R2959 VSS.n1109 VSS.n1108 5.2005
R2960 VSS.n275 VSS.n274 5.2005
R2961 VSS.n281 VSS.n274 5.2005
R2962 VSS.n1103 VSS.n1102 5.2005
R2963 VSS.n1102 VSS.n1101 5.2005
R2964 VSS.n278 VSS.n277 5.2005
R2965 VSS.n727 VSS.n278 5.2005
R2966 VSS.n1092 VSS.n1091 5.2005
R2967 VSS.n1093 VSS.n1092 5.2005
R2968 VSS.n290 VSS.n289 5.2005
R2969 VSS.n296 VSS.n289 5.2005
R2970 VSS.n1087 VSS.n1086 5.2005
R2971 VSS.n1086 VSS.n1085 5.2005
R2972 VSS.n293 VSS.n292 5.2005
R2973 VSS.n1067 VSS.n293 5.2005
R2974 VSS.n1076 VSS.n1075 5.2005
R2975 VSS.n1077 VSS.n1076 5.2005
R2976 VSS.n331 VSS.n330 5.2005
R2977 VSS.n330 VSS.n329 5.2005
R2978 VSS.n338 VSS.n337 5.2005
R2979 VSS.n339 VSS.n338 5.2005
R2980 VSS.n321 VSS.n320 5.2005
R2981 VSS.n322 VSS.n321 5.2005
R2982 VSS.n350 VSS.n349 5.2005
R2983 VSS.n349 VSS.n348 5.2005
R2984 VSS.n318 VSS.n317 5.2005
R2985 VSS.n317 VSS.n315 5.2005
R2986 VSS.n355 VSS.n354 5.2005
R2987 VSS.n356 VSS.n355 5.2005
R2988 VSS.n301 VSS.n300 5.2005
R2989 VSS.n302 VSS.n301 5.2005
R2990 VSS.n1079 VSS.n1078 5.2005
R2991 VSS.n1078 VSS.n1077 5.2005
R2992 VSS.n298 VSS.n297 5.2005
R2993 VSS.n1067 VSS.n297 5.2005
R2994 VSS.n1084 VSS.n1083 5.2005
R2995 VSS.n1085 VSS.n1084 5.2005
R2996 VSS.n286 VSS.n285 5.2005
R2997 VSS.n296 VSS.n286 5.2005
R2998 VSS.n1095 VSS.n1094 5.2005
R2999 VSS.n1094 VSS.n1093 5.2005
R3000 VSS.n283 VSS.n282 5.2005
R3001 VSS.n727 VSS.n282 5.2005
R3002 VSS.n1100 VSS.n1099 5.2005
R3003 VSS.n1101 VSS.n1100 5.2005
R3004 VSS.n270 VSS.n269 5.2005
R3005 VSS.n281 VSS.n270 5.2005
R3006 VSS.n1111 VSS.n1110 5.2005
R3007 VSS.n1110 VSS.n1109 5.2005
R3008 VSS.n267 VSS.n266 5.2005
R3009 VSS.n273 VSS.n266 5.2005
R3010 VSS.n1116 VSS.n1115 5.2005
R3011 VSS.n1117 VSS.n1116 5.2005
R3012 VSS.n255 VSS.n254 5.2005
R3013 VSS.n265 VSS.n255 5.2005
R3014 VSS.n1127 VSS.n1126 5.2005
R3015 VSS.n1126 VSS.n1125 5.2005
R3016 VSS.n252 VSS.n251 5.2005
R3017 VSS.n251 VSS.n248 5.2005
R3018 VSS.n1132 VSS.n1131 5.2005
R3019 VSS.n1133 VSS.n1132 5.2005
R3020 VSS.n239 VSS.n238 5.2005
R3021 VSS.n240 VSS.n239 5.2005
R3022 VSS.n1143 VSS.n1142 5.2005
R3023 VSS.n1142 VSS.n1141 5.2005
R3024 VSS.n236 VSS.n235 5.2005
R3025 VSS.n235 VSS.n232 5.2005
R3026 VSS.n1148 VSS.n1147 5.2005
R3027 VSS.n1149 VSS.n1148 5.2005
R3028 VSS.n224 VSS.n223 5.2005
R3029 VSS.n1009 VSS.n224 5.2005
R3030 VSS.n1159 VSS.n1158 5.2005
R3031 VSS.n1158 VSS.n1157 5.2005
R3032 VSS.n221 VSS.n220 5.2005
R3033 VSS.n220 VSS.n217 5.2005
R3034 VSS.n1164 VSS.n1163 5.2005
R3035 VSS.n1165 VSS.n1164 5.2005
R3036 VSS.n208 VSS.n207 5.2005
R3037 VSS.n209 VSS.n208 5.2005
R3038 VSS.n1175 VSS.n1174 5.2005
R3039 VSS.n1174 VSS.n1173 5.2005
R3040 VSS.n205 VSS.n204 5.2005
R3041 VSS.n204 VSS.n201 5.2005
R3042 VSS.n1180 VSS.n1179 5.2005
R3043 VSS.n1181 VSS.n1180 5.2005
R3044 VSS.n192 VSS.n191 5.2005
R3045 VSS.n193 VSS.n192 5.2005
R3046 VSS.n1191 VSS.n1190 5.2005
R3047 VSS.n1190 VSS.n1189 5.2005
R3048 VSS.n189 VSS.n188 5.2005
R3049 VSS.n188 VSS.n184 5.2005
R3050 VSS.n1196 VSS.n1195 5.2005
R3051 VSS.n1197 VSS.n1196 5.2005
R3052 VSS.n176 VSS.n175 5.2005
R3053 VSS.n177 VSS.n176 5.2005
R3054 VSS.n1207 VSS.n1206 5.2005
R3055 VSS.n1206 VSS.n1205 5.2005
R3056 VSS.n173 VSS.n172 5.2005
R3057 VSS.n172 VSS.n170 5.2005
R3058 VSS.n1212 VSS.n1211 5.2005
R3059 VSS.n1213 VSS.n1212 5.2005
R3060 VSS.n161 VSS.n160 5.2005
R3061 VSS.n163 VSS.n161 5.2005
R3062 VSS.n1223 VSS.n1222 5.2005
R3063 VSS.n1222 VSS.n1221 5.2005
R3064 VSS.n158 VSS.n157 5.2005
R3065 VSS.n157 VSS.n155 5.2005
R3066 VSS.n1228 VSS.n1227 5.2005
R3067 VSS.n1229 VSS.n1228 5.2005
R3068 VSS.n148 VSS.n147 5.2005
R3069 VSS.n976 VSS.n148 5.2005
R3070 VSS.n1239 VSS.n1238 5.2005
R3071 VSS.n1238 VSS.n1237 5.2005
R3072 VSS.n145 VSS.n144 5.2005
R3073 VSS.n144 VSS.n142 5.2005
R3074 VSS.n1244 VSS.n1243 5.2005
R3075 VSS.n1245 VSS.n1244 5.2005
R3076 VSS.n135 VSS.n134 5.2005
R3077 VSS.n968 VSS.n135 5.2005
R3078 VSS.n1255 VSS.n1254 5.2005
R3079 VSS.n1254 VSS.n1253 5.2005
R3080 VSS.n132 VSS.n131 5.2005
R3081 VSS.n131 VSS.n129 5.2005
R3082 VSS.n1260 VSS.n1259 5.2005
R3083 VSS.n1261 VSS.n1260 5.2005
R3084 VSS.n120 VSS.n119 5.2005
R3085 VSS.n122 VSS.n120 5.2005
R3086 VSS.n1271 VSS.n1270 5.2005
R3087 VSS.n1270 VSS.n1269 5.2005
R3088 VSS.n117 VSS.n116 5.2005
R3089 VSS.n116 VSS.n114 5.2005
R3090 VSS.n1276 VSS.n1275 5.2005
R3091 VSS.n1277 VSS.n1276 5.2005
R3092 VSS.n106 VSS.n105 5.2005
R3093 VSS.n954 VSS.n106 5.2005
R3094 VSS.n1287 VSS.n1286 5.2005
R3095 VSS.n1286 VSS.n1285 5.2005
R3096 VSS.n103 VSS.n102 5.2005
R3097 VSS.n108 VSS.n102 5.2005
R3098 VSS.n1292 VSS.n1291 5.2005
R3099 VSS.n1293 VSS.n1292 5.2005
R3100 VSS.n91 VSS.n90 5.2005
R3101 VSS.n101 VSS.n91 5.2005
R3102 VSS.n1303 VSS.n1302 5.2005
R3103 VSS.n1302 VSS.n1301 5.2005
R3104 VSS.n88 VSS.n87 5.2005
R3105 VSS.n93 VSS.n87 5.2005
R3106 VSS.n1308 VSS.n1307 5.2005
R3107 VSS.n1309 VSS.n1308 5.2005
R3108 VSS.n78 VSS.n77 5.2005
R3109 VSS.n940 VSS.n78 5.2005
R3110 VSS.n1320 VSS.n1319 5.2005
R3111 VSS.n1319 VSS.n1318 5.2005
R3112 VSS.n75 VSS.n74 5.2005
R3113 VSS.n80 VSS.n74 5.2005
R3114 VSS.n1326 VSS.n1325 5.2005
R3115 VSS.n1327 VSS.n1326 5.2005
R3116 VSS.n64 VSS.n63 5.2005
R3117 VSS.n66 VSS.n64 5.2005
R3118 VSS.n1337 VSS.n1336 5.2005
R3119 VSS.n1336 VSS.n1335 5.2005
R3120 VSS.n61 VSS.n60 5.2005
R3121 VSS.n60 VSS.n59 5.2005
R3122 VSS.n1342 VSS.n1341 5.2005
R3123 VSS.n1343 VSS.n1342 5.2005
R3124 VSS.n58 VSS.n57 5.2005
R3125 VSS.n1345 VSS.n58 5.2005
R3126 VSS.n1348 VSS.n1347 5.2005
R3127 VSS.n1347 VSS.n1346 5.2005
R3128 VSS.n55 VSS.n54 5.2005
R3129 VSS.n54 VSS.n52 5.2005
R3130 VSS.n1354 VSS.n1353 5.2005
R3131 VSS.n1355 VSS.n1354 5.2005
R3132 VSS.n1357 VSS.n1356 5.2005
R3133 VSS.n1356 VSS.n1355 5.2005
R3134 VSS.n1358 VSS.n49 5.2005
R3135 VSS.n52 VSS.n49 5.2005
R3136 VSS.n1359 VSS.n48 5.2005
R3137 VSS.n1346 VSS.n48 5.2005
R3138 VSS.n1344 VSS.n46 5.2005
R3139 VSS.n1345 VSS.n1344 5.2005
R3140 VSS.n1363 VSS.n45 5.2005
R3141 VSS.n1343 VSS.n45 5.2005
R3142 VSS.n1364 VSS.n44 5.2005
R3143 VSS.n59 VSS.n44 5.2005
R3144 VSS.n1365 VSS.n43 5.2005
R3145 VSS.n1335 VSS.n43 5.2005
R3146 VSS.n65 VSS.n41 5.2005
R3147 VSS.n66 VSS.n65 5.2005
R3148 VSS.n1369 VSS.n40 5.2005
R3149 VSS.n1327 VSS.n40 5.2005
R3150 VSS.n1370 VSS.n39 5.2005
R3151 VSS.n80 VSS.n39 5.2005
R3152 VSS.n1371 VSS.n38 5.2005
R3153 VSS.n1318 VSS.n38 5.2005
R3154 VSS.n939 VSS.n36 5.2005
R3155 VSS.n940 VSS.n939 5.2005
R3156 VSS.n1375 VSS.n35 5.2005
R3157 VSS.n1309 VSS.n35 5.2005
R3158 VSS.n1376 VSS.n34 5.2005
R3159 VSS.n93 VSS.n34 5.2005
R3160 VSS.n1377 VSS.n33 5.2005
R3161 VSS.n1301 VSS.n33 5.2005
R3162 VSS.n100 VSS.n31 5.2005
R3163 VSS.n101 VSS.n100 5.2005
R3164 VSS.n1381 VSS.n30 5.2005
R3165 VSS.n1293 VSS.n30 5.2005
R3166 VSS.n1382 VSS.n29 5.2005
R3167 VSS.n108 VSS.n29 5.2005
R3168 VSS.n1383 VSS.n28 5.2005
R3169 VSS.n1285 VSS.n28 5.2005
R3170 VSS.n953 VSS.n26 5.2005
R3171 VSS.n954 VSS.n953 5.2005
R3172 VSS.n1387 VSS.n25 5.2005
R3173 VSS.n1277 VSS.n25 5.2005
R3174 VSS.n1388 VSS.n24 5.2005
R3175 VSS.n114 VSS.n24 5.2005
R3176 VSS.n1389 VSS.n23 5.2005
R3177 VSS.n1269 VSS.n23 5.2005
R3178 VSS.n121 VSS.n21 5.2005
R3179 VSS.n122 VSS.n121 5.2005
R3180 VSS.n1393 VSS.n20 5.2005
R3181 VSS.n1261 VSS.n20 5.2005
R3182 VSS.n1394 VSS.n19 5.2005
R3183 VSS.n129 VSS.n19 5.2005
R3184 VSS.n1395 VSS.n18 5.2005
R3185 VSS.n1253 VSS.n18 5.2005
R3186 VSS.n967 VSS.n16 5.2005
R3187 VSS.n968 VSS.n967 5.2005
R3188 VSS.n1399 VSS.n15 5.2005
R3189 VSS.n1245 VSS.n15 5.2005
R3190 VSS.n1400 VSS.n14 5.2005
R3191 VSS.n142 VSS.n14 5.2005
R3192 VSS.n1401 VSS.n13 5.2005
R3193 VSS.n1237 VSS.n13 5.2005
R3194 VSS.n975 VSS.n11 5.2005
R3195 VSS.n976 VSS.n975 5.2005
R3196 VSS.n1405 VSS.n10 5.2005
R3197 VSS.n1229 VSS.n10 5.2005
R3198 VSS.n1406 VSS.n9 5.2005
R3199 VSS.n155 VSS.n9 5.2005
R3200 VSS.n1407 VSS.n8 5.2005
R3201 VSS.n1221 VSS.n8 5.2005
R3202 VSS.n162 VSS.n6 5.2005
R3203 VSS.n163 VSS.n162 5.2005
R3204 VSS.n1411 VSS.n5 5.2005
R3205 VSS.n1213 VSS.n5 5.2005
R3206 VSS.n1412 VSS.n4 5.2005
R3207 VSS.n170 VSS.n4 5.2005
R3208 VSS.n1413 VSS.n3 5.2005
R3209 VSS.n1205 VSS.n3 5.2005
R3210 VSS.n186 VSS.n2 5.2005
R3211 VSS.n186 VSS.n177 5.2005
R3212 VSS.n1020 VSS.n187 5.2005
R3213 VSS.n1197 VSS.n187 5.2005
R3214 VSS.n1023 VSS.n1019 5.2005
R3215 VSS.n1019 VSS.n184 5.2005
R3216 VSS.n1024 VSS.n195 5.2005
R3217 VSS.n1189 VSS.n195 5.2005
R3218 VSS.n1025 VSS.n1018 5.2005
R3219 VSS.n1018 VSS.n193 5.2005
R3220 VSS.n1016 VSS.n203 5.2005
R3221 VSS.n1181 VSS.n203 5.2005
R3222 VSS.n1029 VSS.n1015 5.2005
R3223 VSS.n1015 VSS.n201 5.2005
R3224 VSS.n1030 VSS.n211 5.2005
R3225 VSS.n1173 VSS.n211 5.2005
R3226 VSS.n1031 VSS.n1014 5.2005
R3227 VSS.n1014 VSS.n209 5.2005
R3228 VSS.n1012 VSS.n219 5.2005
R3229 VSS.n1165 VSS.n219 5.2005
R3230 VSS.n1035 VSS.n1011 5.2005
R3231 VSS.n1011 VSS.n217 5.2005
R3232 VSS.n1036 VSS.n226 5.2005
R3233 VSS.n1157 VSS.n226 5.2005
R3234 VSS.n1037 VSS.n1010 5.2005
R3235 VSS.n1010 VSS.n1009 5.2005
R3236 VSS.n377 VSS.n234 5.2005
R3237 VSS.n1149 VSS.n234 5.2005
R3238 VSS.n1041 VSS.n376 5.2005
R3239 VSS.n376 VSS.n232 5.2005
R3240 VSS.n1042 VSS.n242 5.2005
R3241 VSS.n1141 VSS.n242 5.2005
R3242 VSS.n1043 VSS.n375 5.2005
R3243 VSS.n375 VSS.n240 5.2005
R3244 VSS.n373 VSS.n250 5.2005
R3245 VSS.n1133 VSS.n250 5.2005
R3246 VSS.n1047 VSS.n372 5.2005
R3247 VSS.n372 VSS.n248 5.2005
R3248 VSS.n1048 VSS.n257 5.2005
R3249 VSS.n1125 VSS.n257 5.2005
R3250 VSS.n1049 VSS.n371 5.2005
R3251 VSS.n371 VSS.n265 5.2005
R3252 VSS.n369 VSS.n264 5.2005
R3253 VSS.n1117 VSS.n264 5.2005
R3254 VSS.n1053 VSS.n368 5.2005
R3255 VSS.n368 VSS.n273 5.2005
R3256 VSS.n1054 VSS.n272 5.2005
R3257 VSS.n1109 VSS.n272 5.2005
R3258 VSS.n1055 VSS.n367 5.2005
R3259 VSS.n367 VSS.n281 5.2005
R3260 VSS.n365 VSS.n280 5.2005
R3261 VSS.n1101 VSS.n280 5.2005
R3262 VSS.n1059 VSS.n364 5.2005
R3263 VSS.n727 VSS.n364 5.2005
R3264 VSS.n1060 VSS.n288 5.2005
R3265 VSS.n1093 VSS.n288 5.2005
R3266 VSS.n1061 VSS.n363 5.2005
R3267 VSS.n363 VSS.n296 5.2005
R3268 VSS.n311 VSS.n295 5.2005
R3269 VSS.n1085 VSS.n295 5.2005
R3270 VSS.n1066 VSS.n1065 5.2005
R3271 VSS.n1067 VSS.n1066 5.2005
R3272 VSS.n310 VSS.n304 5.2005
R3273 VSS.n1077 VSS.n304 5.2005
R3274 VSS.n359 VSS.n358 5.2005
R3275 VSS.n358 VSS.n302 5.2005
R3276 VSS.n357 VSS.n313 5.2005
R3277 VSS.n357 VSS.n356 5.2005
R3278 VSS.n325 VSS.n314 5.2005
R3279 VSS.n315 VSS.n314 5.2005
R3280 VSS.n347 VSS.n346 5.2005
R3281 VSS.n348 VSS.n347 5.2005
R3282 VSS.n324 VSS.n323 5.2005
R3283 VSS.n323 VSS.n322 5.2005
R3284 VSS.n341 VSS.n340 5.2005
R3285 VSS.n340 VSS.n339 5.2005
R3286 VSS.n328 VSS.n327 5.2005
R3287 VSS.n329 VSS.n328 5.2005
R3288 VSS.n507 VSS.n504 4.96224
R3289 VSS.n670 VSS.n669 4.96224
R3290 VSS.n718 VSS.n717 4.67812
R3291 VSS.n799 VSS.n686 4.67812
R3292 VSS.n861 VSS.n860 4.67812
R3293 VSS.n920 VSS.n917 4.67812
R3294 VSS.n521 VSS.n520 4.67812
R3295 VSS.n574 VSS.n484 4.67812
R3296 VSS.n619 VSS.n450 4.67812
R3297 VSS.n658 VSS.n432 4.67812
R3298 VSS.n512 VSS.n511 4.6445
R3299 VSS.n664 VSS.n663 4.6445
R3300 VSS.n292 VSS.n291 4.5005
R3301 VSS.n1088 VSS.n1087 4.5005
R3302 VSS.n1089 VSS.n290 4.5005
R3303 VSS.n1091 VSS.n1090 4.5005
R3304 VSS.n277 VSS.n276 4.5005
R3305 VSS.n1104 VSS.n1103 4.5005
R3306 VSS.n1105 VSS.n275 4.5005
R3307 VSS.n1107 VSS.n1106 4.5005
R3308 VSS.n261 VSS.n260 4.5005
R3309 VSS.n1120 VSS.n1119 4.5005
R3310 VSS.n1121 VSS.n259 4.5005
R3311 VSS.n1123 VSS.n1122 4.5005
R3312 VSS.n246 VSS.n245 4.5005
R3313 VSS.n1136 VSS.n1135 4.5005
R3314 VSS.n1137 VSS.n244 4.5005
R3315 VSS.n1139 VSS.n1138 4.5005
R3316 VSS.n230 VSS.n229 4.5005
R3317 VSS.n1152 VSS.n1151 4.5005
R3318 VSS.n1153 VSS.n228 4.5005
R3319 VSS.n1155 VSS.n1154 4.5005
R3320 VSS.n215 VSS.n214 4.5005
R3321 VSS.n1168 VSS.n1167 4.5005
R3322 VSS.n1169 VSS.n213 4.5005
R3323 VSS.n1171 VSS.n1170 4.5005
R3324 VSS.n199 VSS.n198 4.5005
R3325 VSS.n1184 VSS.n1183 4.5005
R3326 VSS.n1185 VSS.n197 4.5005
R3327 VSS.n1187 VSS.n1186 4.5005
R3328 VSS.n182 VSS.n181 4.5005
R3329 VSS.n1200 VSS.n1199 4.5005
R3330 VSS.n1201 VSS.n180 4.5005
R3331 VSS.n1203 VSS.n1202 4.5005
R3332 VSS.n168 VSS.n167 4.5005
R3333 VSS.n1216 VSS.n1215 4.5005
R3334 VSS.n1217 VSS.n166 4.5005
R3335 VSS.n1219 VSS.n1218 4.5005
R3336 VSS.n153 VSS.n152 4.5005
R3337 VSS.n1232 VSS.n1231 4.5005
R3338 VSS.n1233 VSS.n151 4.5005
R3339 VSS.n1235 VSS.n1234 4.5005
R3340 VSS.n140 VSS.n139 4.5005
R3341 VSS.n1248 VSS.n1247 4.5005
R3342 VSS.n1249 VSS.n138 4.5005
R3343 VSS.n1251 VSS.n1250 4.5005
R3344 VSS.n127 VSS.n126 4.5005
R3345 VSS.n1264 VSS.n1263 4.5005
R3346 VSS.n1265 VSS.n125 4.5005
R3347 VSS.n1267 VSS.n1266 4.5005
R3348 VSS.n112 VSS.n111 4.5005
R3349 VSS.n1280 VSS.n1279 4.5005
R3350 VSS.n1281 VSS.n110 4.5005
R3351 VSS.n1283 VSS.n1282 4.5005
R3352 VSS.n97 VSS.n96 4.5005
R3353 VSS.n1296 VSS.n1295 4.5005
R3354 VSS.n1297 VSS.n95 4.5005
R3355 VSS.n1299 VSS.n1298 4.5005
R3356 VSS.n84 VSS.n83 4.5005
R3357 VSS.n1312 VSS.n1311 4.5005
R3358 VSS.n1313 VSS.n82 4.5005
R3359 VSS.n1316 VSS.n1315 4.5005
R3360 VSS.n1314 VSS.n71 4.5005
R3361 VSS.n1329 VSS.n70 4.5005
R3362 VSS.n1331 VSS.n1330 4.5005
R3363 VSS.n1075 VSS.n1074 4.5005
R3364 VSS.n666 VSS.n427 4.5005
R3365 VSS.n669 VSS.n668 4.5005
R3366 VSS.n666 VSS.n425 4.5005
R3367 VSS.n665 VSS.n664 4.5005
R3368 VSS.n509 VSS.n502 4.5005
R3369 VSS.n507 VSS.n506 4.5005
R3370 VSS.n509 VSS.n508 4.5005
R3371 VSS.n511 VSS.n510 4.5005
R3372 VSS.n1069 VSS.n308 4.5005
R3373 VSS.n711 VSS.n309 4.5005
R3374 VSS.n712 VSS.n709 4.5005
R3375 VSS.n725 VSS.n724 4.5005
R3376 VSS.n730 VSS.n729 4.5005
R3377 VSS.n726 VSS.n704 4.5005
R3378 VSS.n705 VSS.n702 4.5005
R3379 VSS.n744 VSS.n743 4.5005
R3380 VSS.n747 VSS.n746 4.5005
R3381 VSS.n748 VSS.n697 4.5005
R3382 VSS.n758 VSS.n756 4.5005
R3383 VSS.n762 VSS.n761 4.5005
R3384 VSS.n760 VSS.n694 4.5005
R3385 VSS.n692 VSS.n691 4.5005
R3386 VSS.n776 VSS.n774 4.5005
R3387 VSS.n781 VSS.n780 4.5005
R3388 VSS.n779 VSS.n777 4.5005
R3389 VSS.n786 VSS.n379 4.5005
R3390 VSS.n1007 VSS.n380 4.5005
R3391 VSS.n1006 VSS.n381 4.5005
R3392 VSS.n1005 VSS.n382 4.5005
R3393 VSS.n1003 VSS.n383 4.5005
R3394 VSS.n1002 VSS.n384 4.5005
R3395 VSS.n1000 VSS.n385 4.5005
R3396 VSS.n999 VSS.n386 4.5005
R3397 VSS.n997 VSS.n387 4.5005
R3398 VSS.n996 VSS.n388 4.5005
R3399 VSS.n994 VSS.n389 4.5005
R3400 VSS.n993 VSS.n390 4.5005
R3401 VSS.n991 VSS.n391 4.5005
R3402 VSS.n990 VSS.n392 4.5005
R3403 VSS.n988 VSS.n393 4.5005
R3404 VSS.n987 VSS.n394 4.5005
R3405 VSS.n985 VSS.n395 4.5005
R3406 VSS.n984 VSS.n396 4.5005
R3407 VSS.n982 VSS.n397 4.5005
R3408 VSS.n981 VSS.n398 4.5005
R3409 VSS.n979 VSS.n399 4.5005
R3410 VSS.n978 VSS.n400 4.5005
R3411 VSS.n974 VSS.n401 4.5005
R3412 VSS.n973 VSS.n402 4.5005
R3413 VSS.n971 VSS.n403 4.5005
R3414 VSS.n970 VSS.n404 4.5005
R3415 VSS.n966 VSS.n405 4.5005
R3416 VSS.n965 VSS.n406 4.5005
R3417 VSS.n963 VSS.n407 4.5005
R3418 VSS.n962 VSS.n408 4.5005
R3419 VSS.n960 VSS.n409 4.5005
R3420 VSS.n959 VSS.n410 4.5005
R3421 VSS.n957 VSS.n411 4.5005
R3422 VSS.n956 VSS.n412 4.5005
R3423 VSS.n952 VSS.n413 4.5005
R3424 VSS.n951 VSS.n414 4.5005
R3425 VSS.n949 VSS.n415 4.5005
R3426 VSS.n948 VSS.n416 4.5005
R3427 VSS.n946 VSS.n417 4.5005
R3428 VSS.n945 VSS.n418 4.5005
R3429 VSS.n943 VSS.n419 4.5005
R3430 VSS.n942 VSS.n420 4.5005
R3431 VSS.n938 VSS.n421 4.5005
R3432 VSS.n937 VSS.n422 4.5005
R3433 VSS.n935 VSS.n423 4.5005
R3434 VSS.n934 VSS.n933 4.5005
R3435 VSS.n1071 VSS.n1070 4.5005
R3436 VSS.n335 VSS.n331 4.5005
R3437 VSS.n337 VSS.n336 4.5005
R3438 VSS.n320 VSS.n319 4.5005
R3439 VSS.n351 VSS.n350 4.5005
R3440 VSS.n352 VSS.n318 4.5005
R3441 VSS.n354 VSS.n353 4.5005
R3442 VSS.n300 VSS.n299 4.5005
R3443 VSS.n1080 VSS.n1079 4.5005
R3444 VSS.n1081 VSS.n298 4.5005
R3445 VSS.n1083 VSS.n1082 4.5005
R3446 VSS.n285 VSS.n284 4.5005
R3447 VSS.n1096 VSS.n1095 4.5005
R3448 VSS.n1097 VSS.n283 4.5005
R3449 VSS.n1099 VSS.n1098 4.5005
R3450 VSS.n269 VSS.n268 4.5005
R3451 VSS.n1112 VSS.n1111 4.5005
R3452 VSS.n1113 VSS.n267 4.5005
R3453 VSS.n1115 VSS.n1114 4.5005
R3454 VSS.n254 VSS.n253 4.5005
R3455 VSS.n1128 VSS.n1127 4.5005
R3456 VSS.n1129 VSS.n252 4.5005
R3457 VSS.n1131 VSS.n1130 4.5005
R3458 VSS.n238 VSS.n237 4.5005
R3459 VSS.n1144 VSS.n1143 4.5005
R3460 VSS.n1145 VSS.n236 4.5005
R3461 VSS.n1147 VSS.n1146 4.5005
R3462 VSS.n223 VSS.n222 4.5005
R3463 VSS.n1160 VSS.n1159 4.5005
R3464 VSS.n1161 VSS.n221 4.5005
R3465 VSS.n1163 VSS.n1162 4.5005
R3466 VSS.n207 VSS.n206 4.5005
R3467 VSS.n1176 VSS.n1175 4.5005
R3468 VSS.n1177 VSS.n205 4.5005
R3469 VSS.n1179 VSS.n1178 4.5005
R3470 VSS.n191 VSS.n190 4.5005
R3471 VSS.n1192 VSS.n1191 4.5005
R3472 VSS.n1193 VSS.n189 4.5005
R3473 VSS.n1195 VSS.n1194 4.5005
R3474 VSS.n175 VSS.n174 4.5005
R3475 VSS.n1208 VSS.n1207 4.5005
R3476 VSS.n1209 VSS.n173 4.5005
R3477 VSS.n1211 VSS.n1210 4.5005
R3478 VSS.n160 VSS.n159 4.5005
R3479 VSS.n1224 VSS.n1223 4.5005
R3480 VSS.n1225 VSS.n158 4.5005
R3481 VSS.n1227 VSS.n1226 4.5005
R3482 VSS.n147 VSS.n146 4.5005
R3483 VSS.n1240 VSS.n1239 4.5005
R3484 VSS.n1241 VSS.n145 4.5005
R3485 VSS.n1243 VSS.n1242 4.5005
R3486 VSS.n134 VSS.n133 4.5005
R3487 VSS.n1256 VSS.n1255 4.5005
R3488 VSS.n1257 VSS.n132 4.5005
R3489 VSS.n1259 VSS.n1258 4.5005
R3490 VSS.n119 VSS.n118 4.5005
R3491 VSS.n1272 VSS.n1271 4.5005
R3492 VSS.n1273 VSS.n117 4.5005
R3493 VSS.n1275 VSS.n1274 4.5005
R3494 VSS.n105 VSS.n104 4.5005
R3495 VSS.n1288 VSS.n1287 4.5005
R3496 VSS.n1289 VSS.n103 4.5005
R3497 VSS.n1291 VSS.n1290 4.5005
R3498 VSS.n90 VSS.n89 4.5005
R3499 VSS.n1304 VSS.n1303 4.5005
R3500 VSS.n1305 VSS.n88 4.5005
R3501 VSS.n1307 VSS.n1306 4.5005
R3502 VSS.n77 VSS.n76 4.5005
R3503 VSS.n1321 VSS.n1320 4.5005
R3504 VSS.n1322 VSS.n75 4.5005
R3505 VSS.n1325 VSS.n1324 4.5005
R3506 VSS.n931 VSS.n62 4.5005
R3507 VSS.n1323 VSS.n63 4.5005
R3508 VSS.n1338 VSS.n1337 4.5005
R3509 VSS.n1339 VSS.n61 4.5005
R3510 VSS.n1341 VSS.n1340 4.5005
R3511 VSS.n57 VSS.n56 4.5005
R3512 VSS.n1349 VSS.n1348 4.5005
R3513 VSS.n1350 VSS.n55 4.5005
R3514 VSS.n1353 VSS.n1352 4.5005
R3515 VSS.n342 VSS.n341 4.5005
R3516 VSS.n343 VSS.n324 4.5005
R3517 VSS.n346 VSS.n345 4.5005
R3518 VSS.n344 VSS.n325 4.5005
R3519 VSS.n313 VSS.n312 4.5005
R3520 VSS.n360 VSS.n359 4.5005
R3521 VSS.n361 VSS.n310 4.5005
R3522 VSS.n1065 VSS.n1064 4.5005
R3523 VSS.n1063 VSS.n311 4.5005
R3524 VSS.n1062 VSS.n1061 4.5005
R3525 VSS.n1060 VSS.n362 4.5005
R3526 VSS.n1059 VSS.n1058 4.5005
R3527 VSS.n1057 VSS.n365 4.5005
R3528 VSS.n1056 VSS.n1055 4.5005
R3529 VSS.n1054 VSS.n366 4.5005
R3530 VSS.n1053 VSS.n1052 4.5005
R3531 VSS.n1051 VSS.n369 4.5005
R3532 VSS.n1050 VSS.n1049 4.5005
R3533 VSS.n1048 VSS.n370 4.5005
R3534 VSS.n1047 VSS.n1046 4.5005
R3535 VSS.n1045 VSS.n373 4.5005
R3536 VSS.n1044 VSS.n1043 4.5005
R3537 VSS.n1042 VSS.n374 4.5005
R3538 VSS.n1041 VSS.n1040 4.5005
R3539 VSS.n1039 VSS.n377 4.5005
R3540 VSS.n1038 VSS.n1037 4.5005
R3541 VSS.n1036 VSS.n378 4.5005
R3542 VSS.n1035 VSS.n1034 4.5005
R3543 VSS.n1033 VSS.n1012 4.5005
R3544 VSS.n1032 VSS.n1031 4.5005
R3545 VSS.n1030 VSS.n1013 4.5005
R3546 VSS.n1029 VSS.n1028 4.5005
R3547 VSS.n1027 VSS.n1016 4.5005
R3548 VSS.n1026 VSS.n1025 4.5005
R3549 VSS.n1024 VSS.n1017 4.5005
R3550 VSS.n1023 VSS.n1022 4.5005
R3551 VSS.n1021 VSS.n1020 4.5005
R3552 VSS.n2 VSS.n0 4.5005
R3553 VSS.n1414 VSS.n1413 4.5005
R3554 VSS.n1412 VSS.n1 4.5005
R3555 VSS.n1411 VSS.n1410 4.5005
R3556 VSS.n1409 VSS.n6 4.5005
R3557 VSS.n1408 VSS.n1407 4.5005
R3558 VSS.n1406 VSS.n7 4.5005
R3559 VSS.n1405 VSS.n1404 4.5005
R3560 VSS.n1403 VSS.n11 4.5005
R3561 VSS.n1402 VSS.n1401 4.5005
R3562 VSS.n1400 VSS.n12 4.5005
R3563 VSS.n1399 VSS.n1398 4.5005
R3564 VSS.n1397 VSS.n16 4.5005
R3565 VSS.n1396 VSS.n1395 4.5005
R3566 VSS.n1394 VSS.n17 4.5005
R3567 VSS.n1393 VSS.n1392 4.5005
R3568 VSS.n1391 VSS.n21 4.5005
R3569 VSS.n1390 VSS.n1389 4.5005
R3570 VSS.n1388 VSS.n22 4.5005
R3571 VSS.n1387 VSS.n1386 4.5005
R3572 VSS.n1385 VSS.n26 4.5005
R3573 VSS.n1384 VSS.n1383 4.5005
R3574 VSS.n1382 VSS.n27 4.5005
R3575 VSS.n1381 VSS.n1380 4.5005
R3576 VSS.n1379 VSS.n31 4.5005
R3577 VSS.n1378 VSS.n1377 4.5005
R3578 VSS.n1376 VSS.n32 4.5005
R3579 VSS.n1375 VSS.n1374 4.5005
R3580 VSS.n1373 VSS.n36 4.5005
R3581 VSS.n1372 VSS.n1371 4.5005
R3582 VSS.n1370 VSS.n37 4.5005
R3583 VSS.n1369 VSS.n1368 4.5005
R3584 VSS.n1367 VSS.n41 4.5005
R3585 VSS.n1366 VSS.n1365 4.5005
R3586 VSS.n1364 VSS.n42 4.5005
R3587 VSS.n1363 VSS.n1362 4.5005
R3588 VSS.n1361 VSS.n46 4.5005
R3589 VSS.n1360 VSS.n1359 4.5005
R3590 VSS.n1358 VSS.n47 4.5005
R3591 VSS.n1357 VSS.n50 4.5005
R3592 VSS.n327 VSS.n326 4.5005
R3593 VSS.n273 VSS.t92 4.45459
R3594 VSS.t83 VSS.n240 4.45459
R3595 VSS.n1293 VSS.t23 4.45459
R3596 VSS.n715 VSS.n706 4.09412
R3597 VSS.n792 VSS.n789 4.09412
R3598 VSS.n865 VSS.n864 4.09412
R3599 VSS.n914 VSS.n672 4.09412
R3600 VSS.n522 VSS.n496 4.09412
R3601 VSS.n567 VSS.n565 4.09412
R3602 VSS.n623 VSS.n448 4.09412
R3603 VSS.n654 VSS.n434 4.09412
R3604 VSS.t92 VSS.t4 3.71224
R3605 VSS.n1269 VSS.t180 3.71224
R3606 VSS.n923 VSS.t15 3.5285
R3607 VSS.t12 VSS.n923 3.5285
R3608 VSS.n911 VSS.t18 3.5285
R3609 VSS.n911 VSS.t15 3.5285
R3610 VSS.n910 VSS.t21 3.5285
R3611 VSS.t18 VSS.n910 3.5285
R3612 VSS.n898 VSS.t24 3.5285
R3613 VSS.n898 VSS.t21 3.5285
R3614 VSS.n897 VSS.t27 3.5285
R3615 VSS.t24 VSS.n897 3.5285
R3616 VSS.t30 VSS.n881 3.5285
R3617 VSS.n881 VSS.t27 3.5285
R3618 VSS.n882 VSS.t33 3.5285
R3619 VSS.n882 VSS.t30 3.5285
R3620 VSS.n880 VSS.t36 3.5285
R3621 VSS.t33 VSS.n880 3.5285
R3622 VSS.n869 VSS.t39 3.5285
R3623 VSS.n869 VSS.t36 3.5285
R3624 VSS.n868 VSS.t42 3.5285
R3625 VSS.t39 VSS.n868 3.5285
R3626 VSS.n857 VSS.t45 3.5285
R3627 VSS.n857 VSS.t42 3.5285
R3628 VSS.n856 VSS.t48 3.5285
R3629 VSS.t45 VSS.n856 3.5285
R3630 VSS.n845 VSS.t51 3.5285
R3631 VSS.n845 VSS.t48 3.5285
R3632 VSS.n844 VSS.t54 3.5285
R3633 VSS.t51 VSS.n844 3.5285
R3634 VSS.n833 VSS.t57 3.5285
R3635 VSS.n833 VSS.t54 3.5285
R3636 VSS.n832 VSS.t60 3.5285
R3637 VSS.t57 VSS.n832 3.5285
R3638 VSS.n822 VSS.t63 3.5285
R3639 VSS.n822 VSS.t60 3.5285
R3640 VSS.n821 VSS.t66 3.5285
R3641 VSS.t63 VSS.n821 3.5285
R3642 VSS.n809 VSS.t69 3.5285
R3643 VSS.n809 VSS.t66 3.5285
R3644 VSS.n808 VSS.t72 3.5285
R3645 VSS.t69 VSS.n808 3.5285
R3646 VSS.n796 VSS.t75 3.5285
R3647 VSS.n796 VSS.t72 3.5285
R3648 VSS.n795 VSS.t78 3.5285
R3649 VSS.t75 VSS.n795 3.5285
R3650 VSS.n784 VSS.t81 3.5285
R3651 VSS.n784 VSS.t78 3.5285
R3652 VSS.n783 VSS.t84 3.5285
R3653 VSS.t81 VSS.n783 3.5285
R3654 VSS.n764 VSS.t87 3.5285
R3655 VSS.n764 VSS.t84 3.5285
R3656 VSS.n763 VSS.t90 3.5285
R3657 VSS.t87 VSS.n763 3.5285
R3658 VSS.t93 VSS.n740 3.5285
R3659 VSS.n740 VSS.t90 3.5285
R3660 VSS.n741 VSS.t96 3.5285
R3661 VSS.n741 VSS.t93 3.5285
R3662 VSS.n739 VSS.t99 3.5285
R3663 VSS.t96 VSS.n739 3.5285
R3664 VSS.n722 VSS.t102 3.5285
R3665 VSS.n722 VSS.t99 3.5285
R3666 VSS.n721 VSS.t105 3.5285
R3667 VSS.t102 VSS.n721 3.5285
R3668 VSS.t115 VSS.n462 3.5285
R3669 VSS.n462 VSS.t113 3.5285
R3670 VSS.t117 VSS.n463 3.5285
R3671 VSS.n463 VSS.t115 3.5285
R3672 VSS.t119 VSS.n464 3.5285
R3673 VSS.n464 VSS.t117 3.5285
R3674 VSS.t121 VSS.n465 3.5285
R3675 VSS.n465 VSS.t119 3.5285
R3676 VSS.t123 VSS.n466 3.5285
R3677 VSS.n466 VSS.t121 3.5285
R3678 VSS.t125 VSS.n467 3.5285
R3679 VSS.n467 VSS.t123 3.5285
R3680 VSS.t127 VSS.n468 3.5285
R3681 VSS.n468 VSS.t125 3.5285
R3682 VSS.t129 VSS.n469 3.5285
R3683 VSS.n469 VSS.t127 3.5285
R3684 VSS.t131 VSS.n470 3.5285
R3685 VSS.n470 VSS.t129 3.5285
R3686 VSS.t133 VSS.n471 3.5285
R3687 VSS.n471 VSS.t131 3.5285
R3688 VSS.t135 VSS.n472 3.5285
R3689 VSS.n472 VSS.t133 3.5285
R3690 VSS.t137 VSS.n473 3.5285
R3691 VSS.n473 VSS.t135 3.5285
R3692 VSS.t139 VSS.n474 3.5285
R3693 VSS.n474 VSS.t137 3.5285
R3694 VSS.t141 VSS.n475 3.5285
R3695 VSS.n475 VSS.t139 3.5285
R3696 VSS.t143 VSS.n476 3.5285
R3697 VSS.n476 VSS.t141 3.5285
R3698 VSS.t145 VSS.n477 3.5285
R3699 VSS.n477 VSS.t143 3.5285
R3700 VSS.n593 VSS.t147 3.5285
R3701 VSS.n593 VSS.t145 3.5285
R3702 VSS.n592 VSS.t149 3.5285
R3703 VSS.t147 VSS.n592 3.5285
R3704 VSS.n582 VSS.t151 3.5285
R3705 VSS.n582 VSS.t149 3.5285
R3706 VSS.n581 VSS.t153 3.5285
R3707 VSS.t151 VSS.n581 3.5285
R3708 VSS.n571 VSS.t155 3.5285
R3709 VSS.n571 VSS.t153 3.5285
R3710 VSS.n570 VSS.t157 3.5285
R3711 VSS.t155 VSS.n570 3.5285
R3712 VSS.n560 VSS.t159 3.5285
R3713 VSS.n560 VSS.t157 3.5285
R3714 VSS.n559 VSS.t161 3.5285
R3715 VSS.t159 VSS.n559 3.5285
R3716 VSS.n549 VSS.t163 3.5285
R3717 VSS.n549 VSS.t161 3.5285
R3718 VSS.n548 VSS.t165 3.5285
R3719 VSS.t163 VSS.n548 3.5285
R3720 VSS.n538 VSS.t167 3.5285
R3721 VSS.n538 VSS.t165 3.5285
R3722 VSS.n537 VSS.t169 3.5285
R3723 VSS.t167 VSS.n537 3.5285
R3724 VSS.n527 VSS.t171 3.5285
R3725 VSS.n527 VSS.t169 3.5285
R3726 VSS.n526 VSS.t173 3.5285
R3727 VSS.t171 VSS.n526 3.5285
R3728 VSS.n516 VSS.t175 3.5285
R3729 VSS.n516 VSS.t173 3.5285
R3730 VSS.n736 VSS.n735 3.51012
R3731 VSS.n768 VSS.n687 3.51012
R3732 VSS.n873 VSS.n872 3.51012
R3733 VSS.n907 VSS.n904 3.51012
R3734 VSS.n532 VSS.n531 3.51012
R3735 VSS.n563 VSS.n487 3.51012
R3736 VSS.n627 VSS.n446 3.51012
R3737 VSS.n650 VSS.n436 3.51012
R3738 VSS.n733 VSS.n699 3.22935
R3739 VSS.n771 VSS.n770 3.22935
R3740 VSS.n877 VSS.n876 3.22935
R3741 VSS.n901 VSS.n673 3.22935
R3742 VSS.n533 VSS.n493 3.22935
R3743 VSS.n556 VSS.n554 3.22935
R3744 VSS.n631 VSS.n444 3.22935
R3745 VSS.n646 VSS.n438 3.22935
R3746 VSS.n928 VSS.n927 3.1253
R3747 VSS.n754 VSS.n753 2.94858
R3748 VSS.n767 VSS.n693 2.94858
R3749 VSS.n886 VSS.n885 2.94858
R3750 VSS.n894 VSS.n891 2.94858
R3751 VSS.n543 VSS.n542 2.94858
R3752 VSS.n552 VSS.n490 2.94858
R3753 VSS.n635 VSS.n442 2.94858
R3754 VSS.n642 VSS.n440 2.94858
R3755 VSS.n930 VSS.n929 2.7509
R3756 VSS.n753 VSS.n752 2.66781
R3757 VSS.n751 VSS.n693 2.66781
R3758 VSS.n888 VSS.n886 2.66781
R3759 VSS.n891 VSS.n890 2.66781
R3760 VSS.n545 VSS.n543 2.66781
R3761 VSS.n544 VSS.n490 2.66781
R3762 VSS.n638 VSS.n442 2.66781
R3763 VSS.n639 VSS.n440 2.66781
R3764 VSS.n925 VSS.t182 2.59313
R3765 VSS.n926 VSS.n925 2.5799
R3766 VSS.n925 VSS.t177 2.45388
R3767 VSS.n505 VSS.n502 2.45385
R3768 VSS.n427 VSS.n424 2.45385
R3769 VSS.n750 VSS.n699 2.38704
R3770 VSS.n772 VSS.n771 2.38704
R3771 VSS.n876 VSS.n675 2.38704
R3772 VSS.n893 VSS.n673 2.38704
R3773 VSS.n541 VSS.n493 2.38704
R3774 VSS.n554 VSS.n553 2.38704
R3775 VSS.n634 VSS.n444 2.38704
R3776 VSS.n643 VSS.n438 2.38704
R3777 VSS.n501 VSS.n499 2.35093
R3778 VSS.n429 VSS.n428 2.35093
R3779 VSS.n735 VSS.n734 2.10627
R3780 VSS.n769 VSS.n768 2.10627
R3781 VSS.n875 VSS.n873 2.10627
R3782 VSS.n904 VSS.n903 2.10627
R3783 VSS.n534 VSS.n532 2.10627
R3784 VSS.n555 VSS.n487 2.10627
R3785 VSS.n630 VSS.n446 2.10627
R3786 VSS.n647 VSS.n436 2.10627
R3787 VSS.n717 VSS.t100 1.8255
R3788 VSS.n706 VSS.t97 1.8255
R3789 VSS.n732 VSS.n706 1.8255
R3790 VSS.n735 VSS.t94 1.8255
R3791 VSS.n699 VSS.t91 1.8255
R3792 VSS.n753 VSS.t88 1.8255
R3793 VSS.n693 VSS.t85 1.8255
R3794 VSS.n771 VSS.t82 1.8255
R3795 VSS.n768 VSS.t79 1.8255
R3796 VSS.n789 VSS.t76 1.8255
R3797 VSS.n789 VSS.n788 1.8255
R3798 VSS.n686 VSS.t73 1.8255
R3799 VSS.n802 VSS.t70 1.8255
R3800 VSS.n685 VSS.t67 1.8255
R3801 VSS.n815 VSS.t64 1.8255
R3802 VSS.n684 VSS.t61 1.8255
R3803 VSS.n828 VSS.t58 1.8255
R3804 VSS.n829 VSS.t55 1.8255
R3805 VSS.n837 VSS.t52 1.8255
R3806 VSS.n840 VSS.t49 1.8255
R3807 VSS.n849 VSS.t46 1.8255
R3808 VSS.n852 VSS.t43 1.8255
R3809 VSS.n861 VSS.t40 1.8255
R3810 VSS.n864 VSS.t37 1.8255
R3811 VSS.n864 VSS.n677 1.8255
R3812 VSS.n873 VSS.t34 1.8255
R3813 VSS.n876 VSS.t31 1.8255
R3814 VSS.n886 VSS.t28 1.8255
R3815 VSS.n891 VSS.t25 1.8255
R3816 VSS.n673 VSS.t22 1.8255
R3817 VSS.n904 VSS.t19 1.8255
R3818 VSS.n672 VSS.t16 1.8255
R3819 VSS.n906 VSS.n672 1.8255
R3820 VSS.n917 VSS.t13 1.8255
R3821 VSS.n521 VSS.t172 1.8255
R3822 VSS.n496 VSS.t170 1.8255
R3823 VSS.n530 VSS.n496 1.8255
R3824 VSS.n532 VSS.t168 1.8255
R3825 VSS.n493 VSS.t166 1.8255
R3826 VSS.n543 VSS.t164 1.8255
R3827 VSS.n490 VSS.t162 1.8255
R3828 VSS.n554 VSS.t160 1.8255
R3829 VSS.n487 VSS.t158 1.8255
R3830 VSS.n565 VSS.t156 1.8255
R3831 VSS.n565 VSS.n564 1.8255
R3832 VSS.n484 VSS.t154 1.8255
R3833 VSS.n576 VSS.t152 1.8255
R3834 VSS.n481 VSS.t150 1.8255
R3835 VSS.n587 VSS.t148 1.8255
R3836 VSS.n478 VSS.t146 1.8255
R3837 VSS.n598 VSS.t144 1.8255
R3838 VSS.n460 VSS.t142 1.8255
R3839 VSS.n458 VSS.t140 1.8255
R3840 VSS.n456 VSS.t138 1.8255
R3841 VSS.n454 VSS.t136 1.8255
R3842 VSS.n452 VSS.t134 1.8255
R3843 VSS.n450 VSS.t132 1.8255
R3844 VSS.n448 VSS.t130 1.8255
R3845 VSS.n626 VSS.n448 1.8255
R3846 VSS.n446 VSS.t128 1.8255
R3847 VSS.n444 VSS.t126 1.8255
R3848 VSS.n442 VSS.t124 1.8255
R3849 VSS.n440 VSS.t122 1.8255
R3850 VSS.n438 VSS.t120 1.8255
R3851 VSS.n436 VSS.t118 1.8255
R3852 VSS.n434 VSS.t116 1.8255
R3853 VSS.n651 VSS.n434 1.8255
R3854 VSS.n432 VSS.t114 1.8255
R3855 VSS.n717 VSS.n716 1.54473
R3856 VSS.n791 VSS.n686 1.54473
R3857 VSS.n863 VSS.n861 1.54473
R3858 VSS.n917 VSS.n916 1.54473
R3859 VSS.n523 VSS.n521 1.54473
R3860 VSS.n566 VSS.n484 1.54473
R3861 VSS.n622 VSS.n450 1.54473
R3862 VSS.n655 VSS.n432 1.54473
R3863 VSS.n265 VSS.t89 1.4852
R3864 VSS.t86 VSS.n248 1.4852
R3865 VSS.n1277 VSS.t29 1.4852
R3866 VSS.n1285 VSS.t26 1.4852
R3867 VSS.t111 VSS.n500 1.3415
R3868 VSS.n501 VSS.t111 1.3415
R3869 VSS.n430 VSS.t108 1.3415
R3870 VSS.t108 VSS.n429 1.3415
R3871 VSS.n802 VSS.n801 1.26396
R3872 VSS.n852 VSS.n679 1.26396
R3873 VSS.n576 VSS.n575 1.26396
R3874 VSS.n618 VSS.n452 1.26396
R3875 VSS.n929 VSS.n928 1.1957
R3876 VSS.n804 VSS.n685 0.983192
R3877 VSS.n851 VSS.n849 0.983192
R3878 VSS.n577 VSS.n481 0.983192
R3879 VSS.n614 VSS.n454 0.983192
R3880 VSS.n515 VSS.n306 0.760935
R3881 VSS.n667 VSS.n426 0.760935
R3882 VSS.n1072 VSS.n306 0.744324
R3883 VSS.n667 VSS.n69 0.744324
R3884 VSS.n1157 VSS.t176 0.742848
R3885 VSS.t1 VSS.n163 0.742848
R3886 VSS.t180 VSS.t32 0.742848
R3887 VSS.n815 VSS.n814 0.702423
R3888 VSS.n840 VSS.n681 0.702423
R3889 VSS.n587 VSS.n586 0.702423
R3890 VSS.n610 VSS.n456 0.702423
R3891 VSS.n927 VSS.n926 0.6305
R3892 VSS.n817 VSS.n684 0.421654
R3893 VSS.n839 VSS.n837 0.421654
R3894 VSS.n588 VSS.n478 0.421654
R3895 VSS.n606 VSS.n458 0.421654
R3896 VSS.n1073 VSS.n305 0.168242
R3897 VSS.n316 VSS.n305 0.168242
R3898 VSS.n1333 VSS.n1332 0.168242
R3899 VSS.n1334 VSS.n1333 0.168242
R3900 VSS.n341 VSS.n327 0.1445
R3901 VSS.n341 VSS.n324 0.1445
R3902 VSS.n346 VSS.n324 0.1445
R3903 VSS.n346 VSS.n325 0.1445
R3904 VSS.n325 VSS.n313 0.1445
R3905 VSS.n359 VSS.n313 0.1445
R3906 VSS.n359 VSS.n310 0.1445
R3907 VSS.n1065 VSS.n310 0.1445
R3908 VSS.n1065 VSS.n311 0.1445
R3909 VSS.n1061 VSS.n311 0.1445
R3910 VSS.n1061 VSS.n1060 0.1445
R3911 VSS.n1060 VSS.n1059 0.1445
R3912 VSS.n1059 VSS.n365 0.1445
R3913 VSS.n1055 VSS.n365 0.1445
R3914 VSS.n1055 VSS.n1054 0.1445
R3915 VSS.n1054 VSS.n1053 0.1445
R3916 VSS.n1053 VSS.n369 0.1445
R3917 VSS.n1049 VSS.n369 0.1445
R3918 VSS.n1049 VSS.n1048 0.1445
R3919 VSS.n1048 VSS.n1047 0.1445
R3920 VSS.n1047 VSS.n373 0.1445
R3921 VSS.n1043 VSS.n373 0.1445
R3922 VSS.n1043 VSS.n1042 0.1445
R3923 VSS.n1042 VSS.n1041 0.1445
R3924 VSS.n1041 VSS.n377 0.1445
R3925 VSS.n1037 VSS.n377 0.1445
R3926 VSS.n1037 VSS.n1036 0.1445
R3927 VSS.n1036 VSS.n1035 0.1445
R3928 VSS.n1035 VSS.n1012 0.1445
R3929 VSS.n1031 VSS.n1012 0.1445
R3930 VSS.n1031 VSS.n1030 0.1445
R3931 VSS.n1030 VSS.n1029 0.1445
R3932 VSS.n1029 VSS.n1016 0.1445
R3933 VSS.n1025 VSS.n1016 0.1445
R3934 VSS.n1025 VSS.n1024 0.1445
R3935 VSS.n1024 VSS.n1023 0.1445
R3936 VSS.n1023 VSS.n1020 0.1445
R3937 VSS.n1020 VSS.n2 0.1445
R3938 VSS.n1413 VSS.n2 0.1445
R3939 VSS.n1413 VSS.n1412 0.1445
R3940 VSS.n1412 VSS.n1411 0.1445
R3941 VSS.n1411 VSS.n6 0.1445
R3942 VSS.n1407 VSS.n6 0.1445
R3943 VSS.n1407 VSS.n1406 0.1445
R3944 VSS.n1406 VSS.n1405 0.1445
R3945 VSS.n1405 VSS.n11 0.1445
R3946 VSS.n1401 VSS.n11 0.1445
R3947 VSS.n1401 VSS.n1400 0.1445
R3948 VSS.n1400 VSS.n1399 0.1445
R3949 VSS.n1399 VSS.n16 0.1445
R3950 VSS.n1395 VSS.n16 0.1445
R3951 VSS.n1395 VSS.n1394 0.1445
R3952 VSS.n1394 VSS.n1393 0.1445
R3953 VSS.n1393 VSS.n21 0.1445
R3954 VSS.n1389 VSS.n21 0.1445
R3955 VSS.n1389 VSS.n1388 0.1445
R3956 VSS.n1388 VSS.n1387 0.1445
R3957 VSS.n1387 VSS.n26 0.1445
R3958 VSS.n1383 VSS.n26 0.1445
R3959 VSS.n1383 VSS.n1382 0.1445
R3960 VSS.n1382 VSS.n1381 0.1445
R3961 VSS.n1381 VSS.n31 0.1445
R3962 VSS.n1377 VSS.n31 0.1445
R3963 VSS.n1377 VSS.n1376 0.1445
R3964 VSS.n1376 VSS.n1375 0.1445
R3965 VSS.n1375 VSS.n36 0.1445
R3966 VSS.n1371 VSS.n36 0.1445
R3967 VSS.n1371 VSS.n1370 0.1445
R3968 VSS.n1370 VSS.n1369 0.1445
R3969 VSS.n1369 VSS.n41 0.1445
R3970 VSS.n1365 VSS.n41 0.1445
R3971 VSS.n1365 VSS.n1364 0.1445
R3972 VSS.n1364 VSS.n1363 0.1445
R3973 VSS.n1363 VSS.n46 0.1445
R3974 VSS.n1359 VSS.n46 0.1445
R3975 VSS.n1359 VSS.n1358 0.1445
R3976 VSS.n1358 VSS.n1357 0.1445
R3977 VSS.n1075 VSS.n292 0.1445
R3978 VSS.n1087 VSS.n292 0.1445
R3979 VSS.n1087 VSS.n290 0.1445
R3980 VSS.n1091 VSS.n290 0.1445
R3981 VSS.n1091 VSS.n277 0.1445
R3982 VSS.n1103 VSS.n277 0.1445
R3983 VSS.n1103 VSS.n275 0.1445
R3984 VSS.n1107 VSS.n275 0.1445
R3985 VSS.n1107 VSS.n261 0.1445
R3986 VSS.n1119 VSS.n261 0.1445
R3987 VSS.n1119 VSS.n259 0.1445
R3988 VSS.n1123 VSS.n259 0.1445
R3989 VSS.n1123 VSS.n246 0.1445
R3990 VSS.n1135 VSS.n246 0.1445
R3991 VSS.n1135 VSS.n244 0.1445
R3992 VSS.n1139 VSS.n244 0.1445
R3993 VSS.n1139 VSS.n230 0.1445
R3994 VSS.n1151 VSS.n230 0.1445
R3995 VSS.n1151 VSS.n228 0.1445
R3996 VSS.n1155 VSS.n228 0.1445
R3997 VSS.n1155 VSS.n215 0.1445
R3998 VSS.n1167 VSS.n215 0.1445
R3999 VSS.n1167 VSS.n213 0.1445
R4000 VSS.n1171 VSS.n213 0.1445
R4001 VSS.n1171 VSS.n199 0.1445
R4002 VSS.n1183 VSS.n199 0.1445
R4003 VSS.n1183 VSS.n197 0.1445
R4004 VSS.n1187 VSS.n197 0.1445
R4005 VSS.n1187 VSS.n182 0.1445
R4006 VSS.n1199 VSS.n182 0.1445
R4007 VSS.n1199 VSS.n180 0.1445
R4008 VSS.n1203 VSS.n180 0.1445
R4009 VSS.n1203 VSS.n168 0.1445
R4010 VSS.n1215 VSS.n168 0.1445
R4011 VSS.n1215 VSS.n166 0.1445
R4012 VSS.n1219 VSS.n166 0.1445
R4013 VSS.n1219 VSS.n153 0.1445
R4014 VSS.n1231 VSS.n153 0.1445
R4015 VSS.n1231 VSS.n151 0.1445
R4016 VSS.n1235 VSS.n151 0.1445
R4017 VSS.n1235 VSS.n140 0.1445
R4018 VSS.n1247 VSS.n140 0.1445
R4019 VSS.n1247 VSS.n138 0.1445
R4020 VSS.n1251 VSS.n138 0.1445
R4021 VSS.n1251 VSS.n127 0.1445
R4022 VSS.n1263 VSS.n127 0.1445
R4023 VSS.n1263 VSS.n125 0.1445
R4024 VSS.n1267 VSS.n125 0.1445
R4025 VSS.n1267 VSS.n112 0.1445
R4026 VSS.n1279 VSS.n112 0.1445
R4027 VSS.n1279 VSS.n110 0.1445
R4028 VSS.n1283 VSS.n110 0.1445
R4029 VSS.n1283 VSS.n97 0.1445
R4030 VSS.n1295 VSS.n97 0.1445
R4031 VSS.n1295 VSS.n95 0.1445
R4032 VSS.n1299 VSS.n95 0.1445
R4033 VSS.n1299 VSS.n84 0.1445
R4034 VSS.n1311 VSS.n84 0.1445
R4035 VSS.n1311 VSS.n82 0.1445
R4036 VSS.n1316 VSS.n82 0.1445
R4037 VSS.n1316 VSS.n71 0.1445
R4038 VSS.n1329 VSS.n71 0.1445
R4039 VSS.n1330 VSS.n1329 0.1445
R4040 VSS.n1074 VSS.n291 0.1445
R4041 VSS.n1088 VSS.n291 0.1445
R4042 VSS.n1089 VSS.n1088 0.1445
R4043 VSS.n1090 VSS.n1089 0.1445
R4044 VSS.n1090 VSS.n276 0.1445
R4045 VSS.n1104 VSS.n276 0.1445
R4046 VSS.n1105 VSS.n1104 0.1445
R4047 VSS.n1106 VSS.n1105 0.1445
R4048 VSS.n1106 VSS.n260 0.1445
R4049 VSS.n1120 VSS.n260 0.1445
R4050 VSS.n1121 VSS.n1120 0.1445
R4051 VSS.n1122 VSS.n1121 0.1445
R4052 VSS.n1122 VSS.n245 0.1445
R4053 VSS.n1136 VSS.n245 0.1445
R4054 VSS.n1137 VSS.n1136 0.1445
R4055 VSS.n1138 VSS.n1137 0.1445
R4056 VSS.n1138 VSS.n229 0.1445
R4057 VSS.n1152 VSS.n229 0.1445
R4058 VSS.n1153 VSS.n1152 0.1445
R4059 VSS.n1154 VSS.n1153 0.1445
R4060 VSS.n1154 VSS.n214 0.1445
R4061 VSS.n1168 VSS.n214 0.1445
R4062 VSS.n1169 VSS.n1168 0.1445
R4063 VSS.n1170 VSS.n1169 0.1445
R4064 VSS.n1170 VSS.n198 0.1445
R4065 VSS.n1184 VSS.n198 0.1445
R4066 VSS.n1185 VSS.n1184 0.1445
R4067 VSS.n1186 VSS.n1185 0.1445
R4068 VSS.n1186 VSS.n181 0.1445
R4069 VSS.n1200 VSS.n181 0.1445
R4070 VSS.n1201 VSS.n1200 0.1445
R4071 VSS.n1202 VSS.n1201 0.1445
R4072 VSS.n1202 VSS.n167 0.1445
R4073 VSS.n1216 VSS.n167 0.1445
R4074 VSS.n1217 VSS.n1216 0.1445
R4075 VSS.n1218 VSS.n1217 0.1445
R4076 VSS.n1218 VSS.n152 0.1445
R4077 VSS.n1232 VSS.n152 0.1445
R4078 VSS.n1233 VSS.n1232 0.1445
R4079 VSS.n1234 VSS.n1233 0.1445
R4080 VSS.n1234 VSS.n139 0.1445
R4081 VSS.n1248 VSS.n139 0.1445
R4082 VSS.n1249 VSS.n1248 0.1445
R4083 VSS.n1250 VSS.n1249 0.1445
R4084 VSS.n1250 VSS.n126 0.1445
R4085 VSS.n1264 VSS.n126 0.1445
R4086 VSS.n1265 VSS.n1264 0.1445
R4087 VSS.n1266 VSS.n1265 0.1445
R4088 VSS.n1266 VSS.n111 0.1445
R4089 VSS.n1280 VSS.n111 0.1445
R4090 VSS.n1281 VSS.n1280 0.1445
R4091 VSS.n1282 VSS.n1281 0.1445
R4092 VSS.n1282 VSS.n96 0.1445
R4093 VSS.n1296 VSS.n96 0.1445
R4094 VSS.n1297 VSS.n1296 0.1445
R4095 VSS.n1298 VSS.n1297 0.1445
R4096 VSS.n1298 VSS.n83 0.1445
R4097 VSS.n1312 VSS.n83 0.1445
R4098 VSS.n1313 VSS.n1312 0.1445
R4099 VSS.n1315 VSS.n1313 0.1445
R4100 VSS.n1315 VSS.n1314 0.1445
R4101 VSS.n1314 VSS.n70 0.1445
R4102 VSS.n1331 VSS.n70 0.1445
R4103 VSS.n508 VSS.n507 0.1445
R4104 VSS.n669 VSS.n425 0.1445
R4105 VSS.n1070 VSS.n1069 0.1445
R4106 VSS.n1069 VSS.n309 0.1445
R4107 VSS.n709 VSS.n309 0.1445
R4108 VSS.n725 VSS.n709 0.1445
R4109 VSS.n729 VSS.n725 0.1445
R4110 VSS.n729 VSS.n726 0.1445
R4111 VSS.n726 VSS.n702 0.1445
R4112 VSS.n744 VSS.n702 0.1445
R4113 VSS.n746 VSS.n744 0.1445
R4114 VSS.n746 VSS.n697 0.1445
R4115 VSS.n758 VSS.n697 0.1445
R4116 VSS.n761 VSS.n758 0.1445
R4117 VSS.n761 VSS.n760 0.1445
R4118 VSS.n760 VSS.n691 0.1445
R4119 VSS.n776 VSS.n691 0.1445
R4120 VSS.n780 VSS.n776 0.1445
R4121 VSS.n780 VSS.n779 0.1445
R4122 VSS.n779 VSS.n379 0.1445
R4123 VSS.n1007 VSS.n379 0.1445
R4124 VSS.n1007 VSS.n1006 0.1445
R4125 VSS.n1006 VSS.n1005 0.1445
R4126 VSS.n1005 VSS.n1003 0.1445
R4127 VSS.n1003 VSS.n1002 0.1445
R4128 VSS.n1002 VSS.n1000 0.1445
R4129 VSS.n1000 VSS.n999 0.1445
R4130 VSS.n999 VSS.n997 0.1445
R4131 VSS.n997 VSS.n996 0.1445
R4132 VSS.n996 VSS.n994 0.1445
R4133 VSS.n994 VSS.n993 0.1445
R4134 VSS.n993 VSS.n991 0.1445
R4135 VSS.n991 VSS.n990 0.1445
R4136 VSS.n990 VSS.n988 0.1445
R4137 VSS.n988 VSS.n987 0.1445
R4138 VSS.n987 VSS.n985 0.1445
R4139 VSS.n985 VSS.n984 0.1445
R4140 VSS.n984 VSS.n982 0.1445
R4141 VSS.n982 VSS.n981 0.1445
R4142 VSS.n981 VSS.n979 0.1445
R4143 VSS.n979 VSS.n978 0.1445
R4144 VSS.n978 VSS.n974 0.1445
R4145 VSS.n974 VSS.n973 0.1445
R4146 VSS.n973 VSS.n971 0.1445
R4147 VSS.n971 VSS.n970 0.1445
R4148 VSS.n970 VSS.n966 0.1445
R4149 VSS.n966 VSS.n965 0.1445
R4150 VSS.n965 VSS.n963 0.1445
R4151 VSS.n963 VSS.n962 0.1445
R4152 VSS.n962 VSS.n960 0.1445
R4153 VSS.n960 VSS.n959 0.1445
R4154 VSS.n959 VSS.n957 0.1445
R4155 VSS.n957 VSS.n956 0.1445
R4156 VSS.n956 VSS.n952 0.1445
R4157 VSS.n952 VSS.n951 0.1445
R4158 VSS.n951 VSS.n949 0.1445
R4159 VSS.n949 VSS.n948 0.1445
R4160 VSS.n948 VSS.n946 0.1445
R4161 VSS.n946 VSS.n945 0.1445
R4162 VSS.n945 VSS.n943 0.1445
R4163 VSS.n943 VSS.n942 0.1445
R4164 VSS.n942 VSS.n938 0.1445
R4165 VSS.n938 VSS.n937 0.1445
R4166 VSS.n937 VSS.n935 0.1445
R4167 VSS.n935 VSS.n934 0.1445
R4168 VSS.n337 VSS.n331 0.1445
R4169 VSS.n337 VSS.n320 0.1445
R4170 VSS.n350 VSS.n320 0.1445
R4171 VSS.n350 VSS.n318 0.1445
R4172 VSS.n354 VSS.n318 0.1445
R4173 VSS.n354 VSS.n300 0.1445
R4174 VSS.n1079 VSS.n300 0.1445
R4175 VSS.n1079 VSS.n298 0.1445
R4176 VSS.n1083 VSS.n298 0.1445
R4177 VSS.n1083 VSS.n285 0.1445
R4178 VSS.n1095 VSS.n285 0.1445
R4179 VSS.n1095 VSS.n283 0.1445
R4180 VSS.n1099 VSS.n283 0.1445
R4181 VSS.n1099 VSS.n269 0.1445
R4182 VSS.n1111 VSS.n269 0.1445
R4183 VSS.n1111 VSS.n267 0.1445
R4184 VSS.n1115 VSS.n267 0.1445
R4185 VSS.n1115 VSS.n254 0.1445
R4186 VSS.n1127 VSS.n254 0.1445
R4187 VSS.n1127 VSS.n252 0.1445
R4188 VSS.n1131 VSS.n252 0.1445
R4189 VSS.n1131 VSS.n238 0.1445
R4190 VSS.n1143 VSS.n238 0.1445
R4191 VSS.n1143 VSS.n236 0.1445
R4192 VSS.n1147 VSS.n236 0.1445
R4193 VSS.n1147 VSS.n223 0.1445
R4194 VSS.n1159 VSS.n223 0.1445
R4195 VSS.n1159 VSS.n221 0.1445
R4196 VSS.n1163 VSS.n221 0.1445
R4197 VSS.n1163 VSS.n207 0.1445
R4198 VSS.n1175 VSS.n207 0.1445
R4199 VSS.n1175 VSS.n205 0.1445
R4200 VSS.n1179 VSS.n205 0.1445
R4201 VSS.n1179 VSS.n191 0.1445
R4202 VSS.n1191 VSS.n191 0.1445
R4203 VSS.n1191 VSS.n189 0.1445
R4204 VSS.n1195 VSS.n189 0.1445
R4205 VSS.n1195 VSS.n175 0.1445
R4206 VSS.n1207 VSS.n175 0.1445
R4207 VSS.n1207 VSS.n173 0.1445
R4208 VSS.n1211 VSS.n173 0.1445
R4209 VSS.n1211 VSS.n160 0.1445
R4210 VSS.n1223 VSS.n160 0.1445
R4211 VSS.n1223 VSS.n158 0.1445
R4212 VSS.n1227 VSS.n158 0.1445
R4213 VSS.n1227 VSS.n147 0.1445
R4214 VSS.n1239 VSS.n147 0.1445
R4215 VSS.n1239 VSS.n145 0.1445
R4216 VSS.n1243 VSS.n145 0.1445
R4217 VSS.n1243 VSS.n134 0.1445
R4218 VSS.n1255 VSS.n134 0.1445
R4219 VSS.n1255 VSS.n132 0.1445
R4220 VSS.n1259 VSS.n132 0.1445
R4221 VSS.n1259 VSS.n119 0.1445
R4222 VSS.n1271 VSS.n119 0.1445
R4223 VSS.n1271 VSS.n117 0.1445
R4224 VSS.n1275 VSS.n117 0.1445
R4225 VSS.n1275 VSS.n105 0.1445
R4226 VSS.n1287 VSS.n105 0.1445
R4227 VSS.n1287 VSS.n103 0.1445
R4228 VSS.n1291 VSS.n103 0.1445
R4229 VSS.n1291 VSS.n90 0.1445
R4230 VSS.n1303 VSS.n90 0.1445
R4231 VSS.n1303 VSS.n88 0.1445
R4232 VSS.n1307 VSS.n88 0.1445
R4233 VSS.n1307 VSS.n77 0.1445
R4234 VSS.n1320 VSS.n77 0.1445
R4235 VSS.n1320 VSS.n75 0.1445
R4236 VSS.n1325 VSS.n75 0.1445
R4237 VSS.n1325 VSS.n63 0.1445
R4238 VSS.n1337 VSS.n63 0.1445
R4239 VSS.n1337 VSS.n61 0.1445
R4240 VSS.n1341 VSS.n61 0.1445
R4241 VSS.n1341 VSS.n57 0.1445
R4242 VSS.n1348 VSS.n57 0.1445
R4243 VSS.n1348 VSS.n55 0.1445
R4244 VSS.n1353 VSS.n55 0.1445
R4245 VSS.n336 VSS.n335 0.1445
R4246 VSS.n336 VSS.n319 0.1445
R4247 VSS.n351 VSS.n319 0.1445
R4248 VSS.n352 VSS.n351 0.1445
R4249 VSS.n353 VSS.n352 0.1445
R4250 VSS.n353 VSS.n299 0.1445
R4251 VSS.n1080 VSS.n299 0.1445
R4252 VSS.n1081 VSS.n1080 0.1445
R4253 VSS.n1082 VSS.n1081 0.1445
R4254 VSS.n1082 VSS.n284 0.1445
R4255 VSS.n1096 VSS.n284 0.1445
R4256 VSS.n1097 VSS.n1096 0.1445
R4257 VSS.n1098 VSS.n1097 0.1445
R4258 VSS.n1098 VSS.n268 0.1445
R4259 VSS.n1112 VSS.n268 0.1445
R4260 VSS.n1113 VSS.n1112 0.1445
R4261 VSS.n1114 VSS.n1113 0.1445
R4262 VSS.n1114 VSS.n253 0.1445
R4263 VSS.n1128 VSS.n253 0.1445
R4264 VSS.n1129 VSS.n1128 0.1445
R4265 VSS.n1130 VSS.n1129 0.1445
R4266 VSS.n1130 VSS.n237 0.1445
R4267 VSS.n1144 VSS.n237 0.1445
R4268 VSS.n1145 VSS.n1144 0.1445
R4269 VSS.n1146 VSS.n1145 0.1445
R4270 VSS.n1146 VSS.n222 0.1445
R4271 VSS.n1160 VSS.n222 0.1445
R4272 VSS.n1161 VSS.n1160 0.1445
R4273 VSS.n1162 VSS.n1161 0.1445
R4274 VSS.n1162 VSS.n206 0.1445
R4275 VSS.n1176 VSS.n206 0.1445
R4276 VSS.n1177 VSS.n1176 0.1445
R4277 VSS.n1178 VSS.n1177 0.1445
R4278 VSS.n1178 VSS.n190 0.1445
R4279 VSS.n1192 VSS.n190 0.1445
R4280 VSS.n1193 VSS.n1192 0.1445
R4281 VSS.n1194 VSS.n1193 0.1445
R4282 VSS.n1194 VSS.n174 0.1445
R4283 VSS.n1208 VSS.n174 0.1445
R4284 VSS.n1209 VSS.n1208 0.1445
R4285 VSS.n1210 VSS.n1209 0.1445
R4286 VSS.n1210 VSS.n159 0.1445
R4287 VSS.n1224 VSS.n159 0.1445
R4288 VSS.n1225 VSS.n1224 0.1445
R4289 VSS.n1226 VSS.n1225 0.1445
R4290 VSS.n1226 VSS.n146 0.1445
R4291 VSS.n1240 VSS.n146 0.1445
R4292 VSS.n1241 VSS.n1240 0.1445
R4293 VSS.n1242 VSS.n1241 0.1445
R4294 VSS.n1242 VSS.n133 0.1445
R4295 VSS.n1256 VSS.n133 0.1445
R4296 VSS.n1257 VSS.n1256 0.1445
R4297 VSS.n1258 VSS.n1257 0.1445
R4298 VSS.n1258 VSS.n118 0.1445
R4299 VSS.n1272 VSS.n118 0.1445
R4300 VSS.n1273 VSS.n1272 0.1445
R4301 VSS.n1274 VSS.n1273 0.1445
R4302 VSS.n1274 VSS.n104 0.1445
R4303 VSS.n1288 VSS.n104 0.1445
R4304 VSS.n1289 VSS.n1288 0.1445
R4305 VSS.n1290 VSS.n1289 0.1445
R4306 VSS.n1290 VSS.n89 0.1445
R4307 VSS.n1304 VSS.n89 0.1445
R4308 VSS.n1305 VSS.n1304 0.1445
R4309 VSS.n1306 VSS.n1305 0.1445
R4310 VSS.n1306 VSS.n76 0.1445
R4311 VSS.n1321 VSS.n76 0.1445
R4312 VSS.n1322 VSS.n1321 0.1445
R4313 VSS.n1324 VSS.n1322 0.1445
R4314 VSS.n1324 VSS.n1323 0.1445
R4315 VSS.n1339 VSS.n1338 0.1445
R4316 VSS.n1340 VSS.n1339 0.1445
R4317 VSS.n1340 VSS.n56 0.1445
R4318 VSS.n1349 VSS.n56 0.1445
R4319 VSS.n1350 VSS.n1349 0.1445
R4320 VSS.n1352 VSS.n1350 0.1445
R4321 VSS.n342 VSS.n326 0.1445
R4322 VSS.n343 VSS.n342 0.1445
R4323 VSS.n345 VSS.n343 0.1445
R4324 VSS.n345 VSS.n344 0.1445
R4325 VSS.n344 VSS.n312 0.1445
R4326 VSS.n360 VSS.n312 0.1445
R4327 VSS.n361 VSS.n360 0.1445
R4328 VSS.n1064 VSS.n361 0.1445
R4329 VSS.n1064 VSS.n1063 0.1445
R4330 VSS.n1063 VSS.n1062 0.1445
R4331 VSS.n1062 VSS.n362 0.1445
R4332 VSS.n1058 VSS.n362 0.1445
R4333 VSS.n1058 VSS.n1057 0.1445
R4334 VSS.n1057 VSS.n1056 0.1445
R4335 VSS.n1056 VSS.n366 0.1445
R4336 VSS.n1052 VSS.n366 0.1445
R4337 VSS.n1052 VSS.n1051 0.1445
R4338 VSS.n1051 VSS.n1050 0.1445
R4339 VSS.n1050 VSS.n370 0.1445
R4340 VSS.n1046 VSS.n370 0.1445
R4341 VSS.n1046 VSS.n1045 0.1445
R4342 VSS.n1045 VSS.n1044 0.1445
R4343 VSS.n1044 VSS.n374 0.1445
R4344 VSS.n1040 VSS.n374 0.1445
R4345 VSS.n1040 VSS.n1039 0.1445
R4346 VSS.n1039 VSS.n1038 0.1445
R4347 VSS.n1038 VSS.n378 0.1445
R4348 VSS.n1034 VSS.n378 0.1445
R4349 VSS.n1034 VSS.n1033 0.1445
R4350 VSS.n1033 VSS.n1032 0.1445
R4351 VSS.n1032 VSS.n1013 0.1445
R4352 VSS.n1028 VSS.n1013 0.1445
R4353 VSS.n1028 VSS.n1027 0.1445
R4354 VSS.n1027 VSS.n1026 0.1445
R4355 VSS.n1026 VSS.n1017 0.1445
R4356 VSS.n1022 VSS.n1017 0.1445
R4357 VSS.n1022 VSS.n1021 0.1445
R4358 VSS.n1021 VSS.n0 0.1445
R4359 VSS.n1414 VSS.n1 0.1445
R4360 VSS.n1410 VSS.n1 0.1445
R4361 VSS.n1410 VSS.n1409 0.1445
R4362 VSS.n1409 VSS.n1408 0.1445
R4363 VSS.n1408 VSS.n7 0.1445
R4364 VSS.n1404 VSS.n7 0.1445
R4365 VSS.n1404 VSS.n1403 0.1445
R4366 VSS.n1403 VSS.n1402 0.1445
R4367 VSS.n1402 VSS.n12 0.1445
R4368 VSS.n1398 VSS.n12 0.1445
R4369 VSS.n1398 VSS.n1397 0.1445
R4370 VSS.n1397 VSS.n1396 0.1445
R4371 VSS.n1396 VSS.n17 0.1445
R4372 VSS.n1392 VSS.n17 0.1445
R4373 VSS.n1392 VSS.n1391 0.1445
R4374 VSS.n1391 VSS.n1390 0.1445
R4375 VSS.n1390 VSS.n22 0.1445
R4376 VSS.n1386 VSS.n22 0.1445
R4377 VSS.n1386 VSS.n1385 0.1445
R4378 VSS.n1385 VSS.n1384 0.1445
R4379 VSS.n1384 VSS.n27 0.1445
R4380 VSS.n1380 VSS.n27 0.1445
R4381 VSS.n1380 VSS.n1379 0.1445
R4382 VSS.n1379 VSS.n1378 0.1445
R4383 VSS.n1378 VSS.n32 0.1445
R4384 VSS.n1374 VSS.n32 0.1445
R4385 VSS.n1374 VSS.n1373 0.1445
R4386 VSS.n1373 VSS.n1372 0.1445
R4387 VSS.n1372 VSS.n37 0.1445
R4388 VSS.n1368 VSS.n37 0.1445
R4389 VSS.n1368 VSS.n1367 0.1445
R4390 VSS.n1367 VSS.n1366 0.1445
R4391 VSS.n1366 VSS.n42 0.1445
R4392 VSS.n1362 VSS.n42 0.1445
R4393 VSS.n1362 VSS.n1361 0.1445
R4394 VSS.n1361 VSS.n1360 0.1445
R4395 VSS.n1360 VSS.n47 0.1445
R4396 VSS.n50 VSS.n47 0.1445
R4397 VSS.n828 VSS.n827 0.140885
R4398 VSS.n829 VSS.n683 0.140885
R4399 VSS.n598 VSS.n597 0.140885
R4400 VSS.n602 VSS.n460 0.140885
R4401 VSS.n1338 VSS.n62 0.1193
R4402 VSS.n1351 VSS.n51 0.0950455
R4403 VSS.n334 VSS.n333 0.0950455
R4404 VSS.n333 VSS.n332 0.0950455
R4405 VSS.n508 VSS.n500 0.0725
R4406 VSS.n511 VSS.n500 0.0725
R4407 VSS.n502 VSS.n501 0.0725
R4408 VSS.n430 VSS.n425 0.0725
R4409 VSS.n664 VSS.n430 0.0725
R4410 VSS.n429 VSS.n427 0.0725
R4411 VSS VSS.n0 0.0725
R4412 VSS VSS.n1414 0.0725
R4413 VSS.n670 VSS.n424 0.062039
R4414 VSS.n505 VSS.n504 0.062039
R4415 VSS.n663 VSS.n662 0.0603745
R4416 VSS.n513 VSS.n512 0.0603745
R4417 VSS.n666 VSS.n665 0.0306255
R4418 VSS.n510 VSS.n509 0.0306255
R4419 VSS.n668 VSS.n667 0.0304372
R4420 VSS.n506 VSS.n306 0.0304372
R4421 VSS.n668 VSS.n424 0.0299499
R4422 VSS.n506 VSS.n505 0.0299499
R4423 VSS.n671 VSS.n670 0.0294958
R4424 VSS.n662 VSS.n661 0.0294958
R4425 VSS.n504 VSS.n503 0.0294958
R4426 VSS.n514 VSS.n513 0.0294958
R4427 VSS.n1323 VSS.n62 0.0257
R4428 VSS.n524 VSS.n498 0.0203347
R4429 VSS.n529 VSS.n497 0.0203347
R4430 VSS.n535 VSS.n495 0.0203347
R4431 VSS.n540 VSS.n494 0.0203347
R4432 VSS.n546 VSS.n492 0.0203347
R4433 VSS.n551 VSS.n491 0.0203347
R4434 VSS.n557 VSS.n489 0.0203347
R4435 VSS.n562 VSS.n488 0.0203347
R4436 VSS.n568 VSS.n486 0.0203347
R4437 VSS.n573 VSS.n485 0.0203347
R4438 VSS.n579 VSS.n483 0.0203347
R4439 VSS.n584 VSS.n482 0.0203347
R4440 VSS.n590 VSS.n480 0.0203347
R4441 VSS.n595 VSS.n479 0.0203347
R4442 VSS.n600 VSS.n461 0.0203347
R4443 VSS.n601 VSS.n600 0.0203347
R4444 VSS.n605 VSS.n604 0.0203347
R4445 VSS.n609 VSS.n608 0.0203347
R4446 VSS.n613 VSS.n612 0.0203347
R4447 VSS.n617 VSS.n616 0.0203347
R4448 VSS.n621 VSS.n620 0.0203347
R4449 VSS.n625 VSS.n624 0.0203347
R4450 VSS.n629 VSS.n628 0.0203347
R4451 VSS.n633 VSS.n632 0.0203347
R4452 VSS.n637 VSS.n636 0.0203347
R4453 VSS.n641 VSS.n640 0.0203347
R4454 VSS.n645 VSS.n644 0.0203347
R4455 VSS.n649 VSS.n648 0.0203347
R4456 VSS.n653 VSS.n652 0.0203347
R4457 VSS.n657 VSS.n656 0.0203347
R4458 VSS.n594 VSS.n461 0.019343
R4459 VSS.n601 VSS.n459 0.019343
R4460 VSS.n591 VSS.n479 0.0183512
R4461 VSS.n605 VSS.n457 0.0183512
R4462 VSS.n583 VSS.n480 0.0173595
R4463 VSS.n609 VSS.n455 0.0173595
R4464 VSS.n580 VSS.n482 0.0163678
R4465 VSS.n613 VSS.n453 0.0163678
R4466 VSS.n663 VSS.n428 0.0162497
R4467 VSS.n512 VSS.n499 0.0162497
R4468 VSS.n665 VSS.n428 0.0157769
R4469 VSS.n510 VSS.n499 0.0157769
R4470 VSS.n518 VSS.n517 0.015376
R4471 VSS.n572 VSS.n483 0.015376
R4472 VSS.n617 VSS.n451 0.015376
R4473 VSS.n660 VSS.n431 0.015376
R4474 VSS.n525 VSS.n524 0.0143843
R4475 VSS.n569 VSS.n485 0.0143843
R4476 VSS.n621 VSS.n449 0.0143843
R4477 VSS.n656 VSS.n433 0.0143843
R4478 VSS.n515 VSS.n514 0.0135165
R4479 VSS.n661 VSS.n426 0.0135165
R4480 VSS.n529 VSS.n528 0.0133926
R4481 VSS.n561 VSS.n486 0.0133926
R4482 VSS.n625 VSS.n447 0.0133926
R4483 VSS.n652 VSS.n435 0.0133926
R4484 VSS.n536 VSS.n535 0.0124008
R4485 VSS.n558 VSS.n488 0.0124008
R4486 VSS.n629 VSS.n445 0.0124008
R4487 VSS.n648 VSS.n437 0.0124008
R4488 VSS.n540 VSS.n539 0.0114091
R4489 VSS.n550 VSS.n489 0.0114091
R4490 VSS.n633 VSS.n443 0.0114091
R4491 VSS.n644 VSS.n439 0.0114091
R4492 VSS.n518 VSS.n514 0.0112851
R4493 VSS.n661 VSS.n660 0.0112851
R4494 VSS.n503 VSS.n307 0.01119
R4495 VSS.n924 VSS.n671 0.01119
R4496 VSS.n547 VSS.n546 0.0104174
R4497 VSS.n547 VSS.n491 0.0104174
R4498 VSS.n637 VSS.n441 0.0104174
R4499 VSS.n640 VSS.n441 0.0104174
R4500 VSS.n539 VSS.n492 0.00942562
R4501 VSS.n551 VSS.n550 0.00942562
R4502 VSS.n636 VSS.n443 0.00942562
R4503 VSS.n641 VSS.n439 0.00942562
R4504 VSS.n1072 VSS.n1071 0.00925566
R4505 VSS.n713 VSS.n308 0.0086448
R4506 VSS.n713 VSS.n711 0.0086448
R4507 VSS.n719 VSS.n712 0.0086448
R4508 VSS.n712 VSS.n710 0.0086448
R4509 VSS.n724 VSS.n710 0.0086448
R4510 VSS.n730 VSS.n707 0.0086448
R4511 VSS.n731 VSS.n730 0.0086448
R4512 VSS.n731 VSS.n704 0.0086448
R4513 VSS.n737 VSS.n705 0.0086448
R4514 VSS.n705 VSS.n703 0.0086448
R4515 VSS.n743 VSS.n703 0.0086448
R4516 VSS.n747 VSS.n700 0.0086448
R4517 VSS.n749 VSS.n747 0.0086448
R4518 VSS.n749 VSS.n748 0.0086448
R4519 VSS.n756 VSS.n755 0.0086448
R4520 VSS.n756 VSS.n695 0.0086448
R4521 VSS.n762 VSS.n695 0.0086448
R4522 VSS.n762 VSS.n696 0.0086448
R4523 VSS.n696 VSS.n694 0.0086448
R4524 VSS.n766 VSS.n694 0.0086448
R4525 VSS.n773 VSS.n692 0.0086448
R4526 VSS.n774 VSS.n773 0.0086448
R4527 VSS.n774 VSS.n689 0.0086448
R4528 VSS.n781 VSS.n690 0.0086448
R4529 VSS.n777 VSS.n690 0.0086448
R4530 VSS.n777 VSS.n688 0.0086448
R4531 VSS.n787 VSS.n786 0.0086448
R4532 VSS.n787 VSS.n380 0.0086448
R4533 VSS.n793 VSS.n380 0.0086448
R4534 VSS.n790 VSS.n381 0.0086448
R4535 VSS.n790 VSS.n382 0.0086448
R4536 VSS.n798 VSS.n382 0.0086448
R4537 VSS.n800 VSS.n383 0.0086448
R4538 VSS.n800 VSS.n384 0.0086448
R4539 VSS.n806 VSS.n384 0.0086448
R4540 VSS.n803 VSS.n385 0.0086448
R4541 VSS.n803 VSS.n386 0.0086448
R4542 VSS.n811 VSS.n386 0.0086448
R4543 VSS.n813 VSS.n387 0.0086448
R4544 VSS.n813 VSS.n388 0.0086448
R4545 VSS.n819 VSS.n388 0.0086448
R4546 VSS.n816 VSS.n389 0.0086448
R4547 VSS.n816 VSS.n390 0.0086448
R4548 VSS.n824 VSS.n390 0.0086448
R4549 VSS.n826 VSS.n391 0.0086448
R4550 VSS.n826 VSS.n392 0.0086448
R4551 VSS.n831 VSS.n392 0.0086448
R4552 VSS.n831 VSS.n393 0.0086448
R4553 VSS.n682 VSS.n393 0.0086448
R4554 VSS.n682 VSS.n394 0.0086448
R4555 VSS.n835 VSS.n395 0.0086448
R4556 VSS.n838 VSS.n395 0.0086448
R4557 VSS.n838 VSS.n396 0.0086448
R4558 VSS.n842 VSS.n397 0.0086448
R4559 VSS.n680 VSS.n397 0.0086448
R4560 VSS.n680 VSS.n398 0.0086448
R4561 VSS.n847 VSS.n399 0.0086448
R4562 VSS.n850 VSS.n399 0.0086448
R4563 VSS.n850 VSS.n400 0.0086448
R4564 VSS.n854 VSS.n401 0.0086448
R4565 VSS.n678 VSS.n401 0.0086448
R4566 VSS.n678 VSS.n402 0.0086448
R4567 VSS.n859 VSS.n403 0.0086448
R4568 VSS.n862 VSS.n403 0.0086448
R4569 VSS.n862 VSS.n404 0.0086448
R4570 VSS.n866 VSS.n405 0.0086448
R4571 VSS.n676 VSS.n405 0.0086448
R4572 VSS.n676 VSS.n406 0.0086448
R4573 VSS.n871 VSS.n407 0.0086448
R4574 VSS.n874 VSS.n407 0.0086448
R4575 VSS.n874 VSS.n408 0.0086448
R4576 VSS.n878 VSS.n409 0.0086448
R4577 VSS.n674 VSS.n409 0.0086448
R4578 VSS.n674 VSS.n410 0.0086448
R4579 VSS.n884 VSS.n411 0.0086448
R4580 VSS.n887 VSS.n411 0.0086448
R4581 VSS.n887 VSS.n412 0.0086448
R4582 VSS.n889 VSS.n412 0.0086448
R4583 VSS.n889 VSS.n413 0.0086448
R4584 VSS.n895 VSS.n413 0.0086448
R4585 VSS.n892 VSS.n414 0.0086448
R4586 VSS.n892 VSS.n415 0.0086448
R4587 VSS.n900 VSS.n415 0.0086448
R4588 VSS.n902 VSS.n416 0.0086448
R4589 VSS.n902 VSS.n417 0.0086448
R4590 VSS.n908 VSS.n417 0.0086448
R4591 VSS.n905 VSS.n418 0.0086448
R4592 VSS.n905 VSS.n419 0.0086448
R4593 VSS.n913 VSS.n419 0.0086448
R4594 VSS.n915 VSS.n420 0.0086448
R4595 VSS.n915 VSS.n421 0.0086448
R4596 VSS.n921 VSS.n421 0.0086448
R4597 VSS.n918 VSS.n422 0.0086448
R4598 VSS.n918 VSS.n423 0.0086448
R4599 VSS.n536 VSS.n494 0.00843388
R4600 VSS.n558 VSS.n557 0.00843388
R4601 VSS.n632 VSS.n445 0.00843388
R4602 VSS.n645 VSS.n437 0.00843388
R4603 VSS.n755 VSS.n698 0.00783032
R4604 VSS.n766 VSS.n765 0.00783032
R4605 VSS.n823 VSS.n391 0.00783032
R4606 VSS.n834 VSS.n394 0.00783032
R4607 VSS.n884 VSS.n883 0.00783032
R4608 VSS.n896 VSS.n895 0.00783032
R4609 VSS.n528 VSS.n495 0.00744215
R4610 VSS.n562 VSS.n561 0.00744215
R4611 VSS.n628 VSS.n447 0.00744215
R4612 VSS.n649 VSS.n435 0.00744215
R4613 VSS.n742 VSS.n700 0.00701584
R4614 VSS.n782 VSS.n689 0.00701584
R4615 VSS.n820 VSS.n389 0.00701584
R4616 VSS.n843 VSS.n396 0.00701584
R4617 VSS.n879 VSS.n878 0.00701584
R4618 VSS.n900 VSS.n899 0.00701584
R4619 VSS.n525 VSS.n497 0.00645041
R4620 VSS.n569 VSS.n568 0.00645041
R4621 VSS.n624 VSS.n449 0.00645041
R4622 VSS.n653 VSS.n433 0.00645041
R4623 VSS.n932 VSS.n69 0.00640498
R4624 VSS.n738 VSS.n737 0.00620136
R4625 VSS.n785 VSS.n688 0.00620136
R4626 VSS.n810 VSS.n387 0.00620136
R4627 VSS.n846 VSS.n398 0.00620136
R4628 VSS.n871 VSS.n870 0.00620136
R4629 VSS.n909 VSS.n908 0.00620136
R4630 VSS.n517 VSS.n498 0.00545868
R4631 VSS.n573 VSS.n572 0.00545868
R4632 VSS.n620 VSS.n451 0.00545868
R4633 VSS.n657 VSS.n431 0.00545868
R4634 VSS.n1071 VSS.n307 0.00538688
R4635 VSS.n723 VSS.n707 0.00538688
R4636 VSS.n794 VSS.n793 0.00538688
R4637 VSS.n807 VSS.n385 0.00538688
R4638 VSS.n855 VSS.n400 0.00538688
R4639 VSS.n867 VSS.n866 0.00538688
R4640 VSS.n913 VSS.n912 0.00538688
R4641 VSS.n933 VSS.n924 0.00538688
R4642 VSS.n720 VSS.n711 0.0045724
R4643 VSS.n720 VSS.n719 0.0045724
R4644 VSS.n798 VSS.n797 0.0045724
R4645 VSS.n797 VSS.n383 0.0045724
R4646 VSS.n858 VSS.n402 0.0045724
R4647 VSS.n859 VSS.n858 0.0045724
R4648 VSS.n922 VSS.n921 0.0045724
R4649 VSS.n922 VSS.n422 0.0045724
R4650 VSS.n580 VSS.n579 0.00446694
R4651 VSS.n616 VSS.n453 0.00446694
R4652 VSS.n724 VSS.n723 0.00375792
R4653 VSS.n794 VSS.n381 0.00375792
R4654 VSS.n807 VSS.n806 0.00375792
R4655 VSS.n855 VSS.n854 0.00375792
R4656 VSS.n867 VSS.n404 0.00375792
R4657 VSS.n912 VSS.n420 0.00375792
R4658 VSS.n584 VSS.n583 0.00347521
R4659 VSS.n612 VSS.n455 0.00347521
R4660 VSS.n933 VSS.n932 0.00335068
R4661 VSS.n738 VSS.n704 0.00294344
R4662 VSS.n786 VSS.n785 0.00294344
R4663 VSS.n811 VSS.n810 0.00294344
R4664 VSS.n847 VSS.n846 0.00294344
R4665 VSS.n870 VSS.n406 0.00294344
R4666 VSS.n909 VSS.n418 0.00294344
R4667 VSS.n591 VSS.n590 0.00248347
R4668 VSS.n608 VSS.n457 0.00248347
R4669 VSS.n743 VSS.n742 0.00212896
R4670 VSS.n782 VSS.n781 0.00212896
R4671 VSS.n820 VSS.n819 0.00212896
R4672 VSS.n843 VSS.n842 0.00212896
R4673 VSS.n879 VSS.n408 0.00212896
R4674 VSS.n899 VSS.n416 0.00212896
R4675 VSS.n595 VSS.n594 0.00149173
R4676 VSS.n604 VSS.n459 0.00149173
R4677 VSS.n748 VSS.n698 0.00131448
R4678 VSS.n765 VSS.n692 0.00131448
R4679 VSS.n824 VSS.n823 0.00131448
R4680 VSS.n835 VSS.n834 0.00131448
R4681 VSS.n883 VSS.n410 0.00131448
R4682 VSS.n896 VSS.n414 0.00131448
R4683 VSS.n503 VSS.n308 0.00121267
R4684 VSS.n671 VSS.n423 0.00121267
R4685 VSS.n667 VSS.n666 0.000688285
R4686 VSS.n509 VSS.n306 0.000688285
C0 VDD spike 0.55154f
C1 VK spike 4.19185f
C2 VIp VT 2.2219f
C3 a_5154_n131# VMEM 1.16978f
C4 a_786_5705# VMEM 2.33252f
C5 VDD a_7190_5705# 1.51744f
C6 VDD a_5862_5705# 1.51841f
C7 VIp VKdn 2.83584f
C8 VDD a_2746_n131# 4.06296f
C9 VDD a_2118_n481# 1.97255f
C10 a_318_n131# a_2118_n481# 0.93395f
C11 VNA a_2746_n131# 4.3497f
C12 VDD VKup 0.59942f
C13 VDD a_786_5705# 5.44972f
C14 VK Vlk 4.90246f
C15 VKup VNA 4.13927f
C16 VMEM Vamp_bias 1.50894f
C17 spike a_5862_5705# 0.71121f
C18 spike a_2746_n131# 6.65271f
C19 VKdn spike 3.40925f
C20 VDD VMEM 0.59723f
C21 a_2118_n481# a_2746_n131# 10.5065f
C22 a_3826_n131# a_2118_n481# 0.56499f
C23 Vlk a_2746_n131# 2.89836f
C24 a_786_5705# a_2118_n481# 6.90728f
C25 VDD VNA 0.59928f
C26 spike VMEM 5.91877f
C27 VMEM VT 1.87365f
C28 Vlk VSS 9.46763f
C29 VK VSS 9.88175f
C30 VKdn VSS 7.61708f
C31 VIp VSS 6.73027f
C32 Vamp_bias VSS 4.25697f
C33 VT VSS 5.3346f
C34 VMEM VSS 21.00601f
C35 spike VSS 15.6854f
C36 VNA VSS 8.86708f
C37 VKup VSS 6.35479f
C38 VDD VSS 0.14492p
C39 a_5154_n131# VSS 5.26718f
C40 a_3826_n131# VSS 3.98105f
C41 a_2498_n131# VSS 4.23367f
C42 a_318_n131# VSS 6.80788f
C43 a_7190_5705# VSS 1.72033f
C44 a_5862_5705# VSS 1.72033f
C45 a_2746_n131# VSS 8.56204f
C46 a_2118_n481# VSS 9.58518f
C47 a_786_5705# VSS 9.30014f
C48 VKup.t0 VSS 0.94522f
C49 VNA.t0 VSS 1.79132f
C50 spike.t3 VSS 2.0251f
C51 spike.t2 VSS 14.0267f
C52 spike.n0 VSS 1.1838f
C53 spike.n1 VSS 1.27266f
C54 spike.n2 VSS 2.42474f
C55 VMEM.t3 VSS 13.1941f
C56 VT.t0 VSS 1.85217f
C57 VIp.t0 VSS 1.12979f
C58 VKdn.t0 VSS 1.35928f
C59 VK.t0 VSS 1.97868f
C60 Vlk.t0 VSS 1.72803f
.ends
