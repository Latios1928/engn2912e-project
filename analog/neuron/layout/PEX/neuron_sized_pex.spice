* NGSPICE file created from neuron_sized_flat.ext - technology: gf180mcuD

.subckt neuron_sized_flat VSS Vlk VK VT Vamp_bias VIp VKdn VNA VKup VMEM spike VDD
X0 a_8270_2214# a_9750_6632# spike.t0 VSS.t3 nfet_03v3 ad=0.2014p pd=1.98u as=0.2014p ps=1.98u w=0.22u l=0.28u
X1 VSS.t53 VSS.t52 VSS.t53 VSS.t18 nfet_03v3 ad=0.61p pd=3.22u as=0 ps=0 w=1u l=1u
X2 VDD.t11 VDD.t9 VDD.t11 VDD.t10 pfet_03v3 ad=0.2166p pd=2.06u as=0 ps=0 w=0.22u l=0.28u
X3 VSS.t16 VSS.t14 VSS.t16 VSS.t15 nfet_03v3 ad=0.61p pd=3.22u as=0 ps=0 w=1u l=1u
X4 VDD.t17 VDD.t15 VDD.t17 VDD.t16 pfet_03v3 ad=0.2166p pd=2.06u as=0 ps=0 w=0.22u l=0.28u
X5 VSS.t19 VSS.t17 VSS.t19 VSS.t18 nfet_03v3 ad=0.61p pd=3.22u as=0 ps=0 w=1u l=1u
X6 VSS.t30 VSS.t28 VSS.t30 VSS.t29 nfet_03v3 ad=0.2014p pd=1.98u as=0 ps=0 w=0.22u l=0.28u
X7 a_4712_2292# Vamp_bias.t0 VSS.t7 VSS.t6 nfet_03v3 ad=0.2014p pd=1.98u as=0.2014p ps=1.98u w=0.22u l=0.28u
X8 a_9750_6632# a_4474_6632# a_7550_2214# VSS.t2 nfet_03v3 ad=0.2014p pd=1.98u as=0.2014p ps=1.98u w=0.22u l=0.28u
X9 VSS.t41 VSS.t40 VSS.t41 VSS.t12 nfet_03v3 ad=0.61p pd=3.22u as=0 ps=0 w=1u l=1u
X10 VSS.t49 VSS.t48 VSS.t49 VSS.t12 nfet_03v3 ad=0.61p pd=3.22u as=0 ps=0 w=1u l=1u
X11 VDD.t41 VDD.t40 VDD.t41 VDD.t13 pfet_03v3 ad=0.2166p pd=2.06u as=0 ps=0 w=0.22u l=0.28u
X12 VSS.t32 VSS.t31 VSS.t32 VSS.t6 nfet_03v3 ad=0.2014p pd=1.98u as=0 ps=0 w=0.22u l=0.28u
X13 VDD.t45 VDD.t44 VDD.t45 VDD.t19 pfet_03v3 ad=0.65p pd=3.3u as=0 ps=0 w=1u l=1u
X14 VSS.t13 VSS.t11 VSS.t13 VSS.t12 nfet_03v3 ad=0.61p pd=3.22u as=0 ps=0 w=1u l=1u
X15 a_4474_6632# a_3704_6616# VDD.t49 VDD.t13 pfet_03v3 ad=0.2166p pd=2.06u as=0.2166p ps=2.06u w=0.22u l=0.28u
X16 VSS.t55 VSS.t54 VSS.t55 VSS.t21 nfet_03v3 ad=0.2014p pd=1.98u as=0 ps=0 w=0.22u l=0.28u
X17 a_5916_6554# VKup.t0 VDD.t52 VDD.t19 pfet_03v3 ad=0.65p pd=3.3u as=0.65p ps=3.3u w=1u l=1u
X18 VMEM.t0 spike.t3 a_3430_2214# VSS.t0 nfet_03v3 ad=0.2014p pd=1.98u as=0.2014p ps=1.98u w=0.22u l=5u
X19 VMEM.t1 a_9750_6632# a_2722_6554# VDD.t55 pfet_03v3 ad=0.2166p pd=2.06u as=0.2166p ps=2.06u w=0.22u l=0.28u
X20 VSS.t57 VSS.t56 VSS.t57 VSS.t24 nfet_03v3 ad=0.2014p pd=1.98u as=0 ps=0 w=0.22u l=0.28u
X21 VDD.t14 VDD.t12 VDD.t14 VDD.t13 pfet_03v3 ad=0.2166p pd=2.06u as=0 ps=0 w=0.22u l=0.28u
X22 VSS.t47 VSS.t46 VSS.t47 VSS.t38 nfet_03v3 ad=0.61p pd=3.22u as=0 ps=0 w=1u l=1u
X23 VDD.t20 VDD.t18 VDD.t20 VDD.t19 pfet_03v3 ad=0.65p pd=3.3u as=0 ps=0 w=1u l=1u
X24 VDD.t47 VDD.t46 VDD.t47 VDD.t22 pfet_03v3 ad=0.65p pd=3.3u as=0 ps=0 w=1u l=1u
X25 VSS.t43 VSS.t42 VSS.t43 VSS.t21 nfet_03v3 ad=0.2014p pd=1.98u as=0 ps=0 w=0.22u l=0.28u
X26 VSS.t69 VSS.t68 VSS.t69 VSS.t38 nfet_03v3 ad=0.61p pd=3.22u as=0 ps=0 w=1u l=1u
X27 VDD.t31 VDD.t30 VDD.t31 VDD.t22 pfet_03v3 ad=0.65p pd=3.3u as=0 ps=0 w=1u l=1u
X28 VDD.t37 VDD.t36 VDD.t37 VDD.t7 pfet_03v3 ad=0.2166p pd=2.06u as=0 ps=0 w=0.22u l=0.28u
X29 VSS.t39 VSS.t37 VSS.t39 VSS.t38 nfet_03v3 ad=0.61p pd=3.22u as=0 ps=0 w=1u l=1u
X30 VSS.t22 VSS.t20 VSS.t22 VSS.t21 nfet_03v3 ad=0.2014p pd=1.98u as=0 ps=0 w=0.22u l=0.28u
X31 a_4712_2292# VMEM.t4 a_3704_6616# VSS.t24 nfet_03v3 ad=0.2014p pd=1.98u as=0.2014p ps=1.98u w=0.22u l=0.28u
X32 VSS.t59 VSS.t58 VSS.t59 VSS.t8 nfet_03v3 ad=0.2014p pd=1.98u as=0 ps=0 w=0.22u l=0.28u
X33 spike.t2 VSS.t1 cap_mim_2f0_m4m5_noshield c_width=10u c_length=10u
X34 VDD.t27 VDD.t26 VDD.t27 VDD.t7 pfet_03v3 ad=0.2166p pd=2.06u as=0 ps=0 w=0.22u l=0.28u
X35 VDD.t33 VDD.t32 VDD.t33 VDD.t1 pfet_03v3 ad=0.65p pd=3.3u as=0 ps=0 w=1u l=1u
X36 VDD.t35 VDD.t34 VDD.t35 VDD.t4 pfet_03v3 ad=0.65p pd=3.3u as=0 ps=0 w=1u l=1u
X37 VDD.t39 VDD.t38 VDD.t39 VDD.t10 pfet_03v3 ad=0.2166p pd=2.06u as=0 ps=0 w=0.22u l=0.28u
X38 VDD.t23 VDD.t21 VDD.t23 VDD.t22 pfet_03v3 ad=0.65p pd=3.3u as=0 ps=0 w=1u l=1u
X39 VDD.t43 VDD.t42 VDD.t43 VDD.t16 pfet_03v3 ad=0.2166p pd=2.06u as=0 ps=0 w=0.22u l=0.28u
X40 VSS.t25 VSS.t23 VSS.t25 VSS.t24 nfet_03v3 ad=0.2014p pd=1.98u as=0 ps=0 w=0.22u l=0.28u
X41 a_7550_2214# VIp.t0 VSS.t10 VSS.t9 nfet_03v3 ad=0.61p pd=3.22u as=0.61p ps=3.22u w=1u l=1u
X42 VSS.t61 VSS.t60 VSS.t61 VSS.t29 nfet_03v3 ad=0.2014p pd=1.98u as=0 ps=0 w=0.22u l=0.28u
X43 a_8270_2214# VKdn.t0 VSS.t5 VSS.t4 nfet_03v3 ad=0.61p pd=3.22u as=0.61p ps=3.22u w=1u l=1u
X44 VSS.t65 VSS.t64 VSS.t65 VSS.t9 nfet_03v3 ad=0.61p pd=3.22u as=0 ps=0 w=1u l=1u
X45 VDD.t25 VDD.t24 VDD.t25 VDD.t1 pfet_03v3 ad=0.65p pd=3.3u as=0 ps=0 w=1u l=1u
X46 VDD.t48 a_3704_6616# a_3704_6616# VDD.t10 pfet_03v3 ad=0.2166p pd=2.06u as=0.2166p ps=2.06u w=0.22u l=0.28u
X47 a_5916_6554# a_9750_6632# spike.t1 VDD.t54 pfet_03v3 ad=0.2166p pd=2.06u as=0.2166p ps=2.06u w=0.22u l=0.28u
X48 VSS.t67 VSS.t66 VSS.t67 VSS.t4 nfet_03v3 ad=0.61p pd=3.22u as=0 ps=0 w=1u l=1u
X49 a_2722_6554# VNA.t0 VDD.t53 VDD.t4 pfet_03v3 ad=0.65p pd=3.3u as=0.65p ps=3.3u w=1u l=1u
X50 VDD.t29 VDD.t28 VDD.t29 VDD.t16 pfet_03v3 ad=0.2166p pd=2.06u as=0 ps=0 w=0.22u l=0.28u
X51 a_4474_6632# VT.t0 a_4712_2292# VSS.t8 nfet_03v3 ad=0.2014p pd=1.98u as=0.2014p ps=1.98u w=0.22u l=0.28u
X52 VSS.t34 VSS.t33 VSS.t34 VSS.t9 nfet_03v3 ad=0.61p pd=3.22u as=0 ps=0 w=1u l=1u
X53 VDD.t8 VDD.t6 VDD.t8 VDD.t7 pfet_03v3 ad=0.2166p pd=2.06u as=0 ps=0 w=0.22u l=0.28u
X54 VSS.t36 VSS.t35 VSS.t36 VSS.t4 nfet_03v3 ad=0.61p pd=3.22u as=0 ps=0 w=1u l=1u
X55 VMEM.t2 Vlk.t0 VSS.t71 VSS.t15 nfet_03v3 ad=0.61p pd=3.22u as=0.61p ps=3.22u w=1u l=1u
X56 VSS.t63 VSS.t62 VSS.t63 VSS.t6 nfet_03v3 ad=0.2014p pd=1.98u as=0 ps=0 w=0.22u l=0.28u
X57 a_3430_2214# VK.t0 VSS.t70 VSS.t18 nfet_03v3 ad=0.61p pd=3.22u as=0.61p ps=3.22u w=1u l=1u
X58 VSS.t45 VSS.t44 VSS.t45 VSS.t29 nfet_03v3 ad=0.2014p pd=1.98u as=0 ps=0 w=0.22u l=0.28u
X59 VSS.t51 VSS.t50 VSS.t51 VSS.t15 nfet_03v3 ad=0.61p pd=3.22u as=0 ps=0 w=1u l=1u
X60 VMEM.t3 VSS.t72 cap_mim_2f0_m4m5_noshield c_width=22.18u c_length=22.18u
X61 VDD.t2 VDD.t0 VDD.t2 VDD.t1 pfet_03v3 ad=0.65p pd=3.3u as=0 ps=0 w=1u l=1u
X62 VDD.t5 VDD.t3 VDD.t5 VDD.t4 pfet_03v3 ad=0.65p pd=3.3u as=0 ps=0 w=1u l=1u
X63 a_9750_6632# a_4474_6632# VDD.t51 VDD.t50 pfet_03v3 ad=0.2166p pd=2.06u as=0.2166p ps=2.06u w=0.22u l=0.28u
X64 VSS.t27 VSS.t26 VSS.t27 VSS.t8 nfet_03v3 ad=0.2014p pd=1.98u as=0 ps=0 w=0.22u l=0.28u
R0 VKdn VKdn.t0 39.7267
R1 Vamp_bias Vamp_bias.t0 45.1008
R2 VT VT.t0 43.4785
R3 VIp VIp.t0 38.7368
R4 VK VK.t0 33.5617
R5 Vlk Vlk.t0 32.5718
R6 VMEM.n2 VMEM.t1 48.8322
R7 VMEM.n0 VMEM.t0 30.2872
R8 VMEM.n0 VMEM.t4 27.5328
R9 VMEM.n3 VMEM.n2 14.6573
R10 VMEM.n1 VMEM.t2 14.2268
R11 VMEM.n3 VMEM.n1 2.723
R12 VMEM.n1 VMEM.n0 2.0525
R13 VMEM VMEM.n3 0.3425
R14 VMEM.n2 VMEM.t3 0.194673
R15 spike.n0 spike.t1 23.1349
R16 spike.n0 spike.t0 21.9686
R17 spike.n2 spike.t2 19.9809
R18 spike.n1 spike.t3 12.607
R19 spike spike.n2 6.962
R20 spike.n1 spike.n0 4.2715
R21 spike.n2 spike.n1 0.1715
R22 VKup VKup.t0 36.7938
R23 VNA VNA.t0 33.9205
R24 VDD.n72 VDD.t50 1087.52
R25 VDD.t55 VDD.n1 769.438
R26 VDD.t54 VDD.t55 476.724
R27 VDD.t50 VDD.t54 476.724
R28 VDD.n71 VDD.n3 436.591
R29 VDD.n73 VDD.n3 436.591
R30 VDD.n73 VDD.n1 436.591
R31 VDD.n71 VDD.n1 436.591
R32 VDD.n72 VDD.t22 391.993
R33 VDD.t22 VDD.t19 338.921
R34 VDD.t4 VDD.t1 338.921
R35 VDD.t16 VDD.t13 332.402
R36 VDD.t19 VDD.t16 305.401
R37 VDD.t7 VDD.t4 305.401
R38 VDD.t13 VDD.t10 271.882
R39 VDD.t10 VDD.t7 271.882
R40 VDD.t1 VDD.n3 253.609
R41 VDD.n53 VDD.t6 22.8087
R42 VDD.n56 VDD.t9 22.8087
R43 VDD.n59 VDD.t12 22.8087
R44 VDD.n62 VDD.t15 22.8087
R45 VDD.n28 VDD.t42 22.6193
R46 VDD.n31 VDD.t40 22.6193
R47 VDD.n34 VDD.t38 22.6193
R48 VDD.n37 VDD.t36 22.6193
R49 VDD.n16 VDD.t26 22.5197
R50 VDD.n9 VDD.t28 22.5197
R51 VDD.n0 VDD.t51 16.5713
R52 VDD.n55 VDD.t11 16.0988
R53 VDD.n60 VDD.t14 16.0988
R54 VDD.t27 VDD.n15 15.9954
R55 VDD.t29 VDD.n8 15.9908
R56 VDD.n27 VDD.t43 15.9188
R57 VDD.n29 VDD.t43 15.9188
R58 VDD.n30 VDD.t41 15.9188
R59 VDD.n32 VDD.t41 15.9188
R60 VDD.n33 VDD.t39 15.9188
R61 VDD.n35 VDD.t39 15.9188
R62 VDD.n36 VDD.t37 15.9188
R63 VDD.n38 VDD.t37 15.9188
R64 VDD.n47 VDD.t0 15.6041
R65 VDD.n50 VDD.t3 15.6041
R66 VDD.n65 VDD.t18 15.6041
R67 VDD.n68 VDD.t21 15.6041
R68 VDD.n13 VDD.t48 15.5657
R69 VDD.n12 VDD.t49 15.5657
R70 VDD.n5 VDD.t30 15.5314
R71 VDD.n20 VDD.t24 15.5189
R72 VDD.n17 VDD.t8 15.5183
R73 VDD.t8 VDD.n15 15.5183
R74 VDD.n11 VDD.t14 15.5183
R75 VDD.t11 VDD.n14 15.5183
R76 VDD.n10 VDD.t17 15.5183
R77 VDD.t17 VDD.n8 15.5183
R78 VDD.n16 VDD.t27 15.5119
R79 VDD.n9 VDD.t29 15.5119
R80 VDD.n22 VDD.t46 15.4146
R81 VDD.n25 VDD.t44 15.4146
R82 VDD.n40 VDD.t34 15.4146
R83 VDD.n43 VDD.t32 15.4146
R84 VDD.n51 VDD.t5 8.75653
R85 VDD.n66 VDD.t20 8.75653
R86 VDD.t25 VDD.n19 8.64853
R87 VDD.n18 VDD.t53 8.64853
R88 VDD.n7 VDD.t52 8.64853
R89 VDD.t31 VDD.n4 8.64853
R90 VDD.t47 VDD.n2 8.57653
R91 VDD.n23 VDD.t47 8.57653
R92 VDD.n24 VDD.t45 8.57653
R93 VDD.n26 VDD.t45 8.57653
R94 VDD.n39 VDD.t35 8.57653
R95 VDD.n41 VDD.t35 8.57653
R96 VDD.n42 VDD.t33 8.57653
R97 VDD.n44 VDD.t33 8.57653
R98 VDD.n5 VDD.t31 8.27153
R99 VDD.n20 VDD.t25 8.22124
R100 VDD.n21 VDD.t2 8.17603
R101 VDD.t2 VDD.n19 8.17603
R102 VDD.n18 VDD.t5 8.17603
R103 VDD.n7 VDD.t20 8.17603
R104 VDD.n6 VDD.t23 8.17603
R105 VDD.t23 VDD.n4 8.17603
R106 VDD.n75 VDD.n74 6.2375
R107 VDD VDD.n75 5.6435
R108 VDD.n75 VDD.n0 4.2989
R109 VDD.n70 VDD.n0 1.9391
R110 VDD.n46 VDD.n45 1.0661
R111 VDD.n45 VDD.n44 1.0661
R112 VDD.n6 VDD.n5 0.584375
R113 VDD.n46 VDD.n21 0.581
R114 VDD.n48 VDD.n19 0.581
R115 VDD.n49 VDD.n18 0.581
R116 VDD.n52 VDD.n17 0.581
R117 VDD.n54 VDD.n15 0.581
R118 VDD.n57 VDD.n14 0.581
R119 VDD.n58 VDD.n11 0.581
R120 VDD.n61 VDD.n10 0.581
R121 VDD.n63 VDD.n8 0.581
R122 VDD.n64 VDD.n7 0.581
R123 VDD.n67 VDD.n6 0.581
R124 VDD.n69 VDD.n4 0.581
R125 VDD.n21 VDD.n20 0.541625
R126 VDD.n70 VDD.n69 0.5297
R127 VDD.n74 VDD.n2 0.5297
R128 VDD.n17 VDD.n16 0.49775
R129 VDD.n10 VDD.n9 0.49775
R130 VDD.n14 VDD.n13 0.43025
R131 VDD.n12 VDD.n11 0.43025
R132 VDD.n45 VDD.n3 0.3505
R133 VDD.n75 VDD.n1 0.3505
R134 VDD.n61 VDD.n60 0.3155
R135 VDD.n30 VDD.n29 0.3155
R136 VDD.n13 VDD.n12 0.261026
R137 VDD.n69 VDD.n68 0.2291
R138 VDD.n68 VDD.n67 0.2291
R139 VDD.n66 VDD.n65 0.2291
R140 VDD.n65 VDD.n64 0.2291
R141 VDD.n51 VDD.n50 0.2291
R142 VDD.n50 VDD.n49 0.2291
R143 VDD.n48 VDD.n47 0.2291
R144 VDD.n47 VDD.n46 0.2291
R145 VDD.n22 VDD.n2 0.2291
R146 VDD.n23 VDD.n22 0.2291
R147 VDD.n25 VDD.n24 0.2291
R148 VDD.n26 VDD.n25 0.2291
R149 VDD.n40 VDD.n39 0.2291
R150 VDD.n41 VDD.n40 0.2291
R151 VDD.n43 VDD.n42 0.2291
R152 VDD.n44 VDD.n43 0.2291
R153 VDD.n67 VDD.n66 0.1985
R154 VDD.n64 VDD.n63 0.1985
R155 VDD.n58 VDD.n57 0.1985
R156 VDD.n55 VDD.n54 0.1985
R157 VDD.n52 VDD.n51 0.1985
R158 VDD.n49 VDD.n48 0.1985
R159 VDD.n24 VDD.n23 0.1985
R160 VDD.n27 VDD.n26 0.1985
R161 VDD.n33 VDD.n32 0.1985
R162 VDD.n36 VDD.n35 0.1985
R163 VDD.n39 VDD.n38 0.1985
R164 VDD.n42 VDD.n41 0.1985
R165 VDD.n63 VDD.n62 0.1643
R166 VDD.n62 VDD.n61 0.1643
R167 VDD.n60 VDD.n59 0.1643
R168 VDD.n59 VDD.n58 0.1643
R169 VDD.n57 VDD.n56 0.1643
R170 VDD.n56 VDD.n55 0.1643
R171 VDD.n54 VDD.n53 0.1643
R172 VDD.n53 VDD.n52 0.1643
R173 VDD.n28 VDD.n27 0.1643
R174 VDD.n29 VDD.n28 0.1643
R175 VDD.n31 VDD.n30 0.1643
R176 VDD.n32 VDD.n31 0.1643
R177 VDD.n34 VDD.n33 0.1643
R178 VDD.n35 VDD.n34 0.1643
R179 VDD.n37 VDD.n36 0.1643
R180 VDD.n38 VDD.n37 0.1643
R181 VDD.n71 VDD.n70 0.0493372
R182 VDD.n72 VDD.n71 0.0493372
R183 VDD.n74 VDD.n73 0.0493372
R184 VDD.n73 VDD.n72 0.0493372
R185 VSS.n72 VSS.n71 24968.3
R186 VSS.n71 VSS.n6 24790.6
R187 VSS.t0 VSS.t3 869.471
R188 VSS.n70 VSS.n4 811.37
R189 VSS.n114 VSS.n4 811.37
R190 VSS.n114 VSS.n3 811.37
R191 VSS.n70 VSS.n3 811.37
R192 VSS.n73 VSS.t0 625.226
R193 VSS.t3 VSS.t2 593.672
R194 VSS.t2 VSS.t38 559.782
R195 VSS.t8 VSS.t24 488.493
R196 VSS.n111 VSS.n7 484.19
R197 VSS.n111 VSS.n8 484.19
R198 VSS.n74 VSS.n8 484.19
R199 VSS.n74 VSS.n7 484.19
R200 VSS.n112 VSS.n6 432.399
R201 VSS.n73 VSS.n72 426.555
R202 VSS.t38 VSS.t4 420.712
R203 VSS.t4 VSS.t9 420.712
R204 VSS.t18 VSS.t15 420.712
R205 VSS.t15 VSS.t12 420.712
R206 VSS.t29 VSS.t8 412.531
R207 VSS.t24 VSS.t21 412.531
R208 VSS.t21 VSS.t18 378.642
R209 VSS.t6 VSS.t29 336.57
R210 VSS.n113 VSS.t6 335.401
R211 VSS.t12 VSS.n112 315.534
R212 VSS.n6 VSS.n4 292.219
R213 VSS.n72 VSS.n3 286.377
R214 VSS.t9 VSS.n5 37.3971
R215 VSS.n87 VSS.t62 22.785
R216 VSS.n90 VSS.t60 22.785
R217 VSS.n93 VSS.t58 22.785
R218 VSS.n96 VSS.t56 22.785
R219 VSS.n99 VSS.t54 22.785
R220 VSS.n36 VSS.t20 22.6193
R221 VSS.n39 VSS.t23 22.6193
R222 VSS.n42 VSS.t26 22.6193
R223 VSS.n45 VSS.t28 22.6193
R224 VSS.n48 VSS.t31 22.6193
R225 VSS.n20 VSS.t42 22.5008
R226 VSS.n17 VSS.t44 22.5008
R227 VSS.n67 VSS.n66 21.6589
R228 VSS.t43 VSS.n19 15.8189
R229 VSS.t45 VSS.n16 15.8143
R230 VSS.n15 VSS.t7 15.8143
R231 VSS.n86 VSS.t63 15.8143
R232 VSS.n88 VSS.t63 15.8143
R233 VSS.n89 VSS.t61 15.8143
R234 VSS.n91 VSS.t61 15.8143
R235 VSS.n92 VSS.t59 15.8143
R236 VSS.n94 VSS.t59 15.8143
R237 VSS.n95 VSS.t57 15.8143
R238 VSS.n97 VSS.t57 15.8143
R239 VSS.n98 VSS.t55 15.8143
R240 VSS.n100 VSS.t55 15.8143
R241 VSS.n38 VSS.t25 15.6568
R242 VSS.n40 VSS.t25 15.6568
R243 VSS.n41 VSS.t27 15.6568
R244 VSS.n43 VSS.t27 15.6568
R245 VSS.n49 VSS.t32 15.6568
R246 VSS.n102 VSS.t52 15.5074
R247 VSS.n105 VSS.t50 15.5074
R248 VSS.n108 VSS.t48 15.5074
R249 VSS.n78 VSS.t68 15.5074
R250 VSS.n81 VSS.t66 15.5074
R251 VSS.n83 VSS.t64 15.5074
R252 VSS.n25 VSS.t40 15.4524
R253 VSS.n11 VSS.t46 15.4524
R254 VSS.n27 VSS.t11 15.3416
R255 VSS.n30 VSS.t14 15.3416
R256 VSS.n33 VSS.t17 15.3416
R257 VSS.n52 VSS.t33 15.3416
R258 VSS.n55 VSS.t35 15.3416
R259 VSS.n58 VSS.t37 15.3416
R260 VSS.n20 VSS.t43 15.3011
R261 VSS.n17 VSS.t45 15.3011
R262 VSS.n21 VSS.t22 15.2585
R263 VSS.t22 VSS.n19 15.2585
R264 VSS.n18 VSS.t30 15.2585
R265 VSS.t30 VSS.n16 15.2585
R266 VSS.n15 VSS.t32 15.2585
R267 VSS.n69 VSS.n68 10.4324
R268 VSS.n69 VSS.n67 9.7331
R269 VSS.n109 VSS.t49 9.43428
R270 VSS.n26 VSS.t41 9.41178
R271 VSS.n23 VSS.t71 9.41178
R272 VSS.n22 VSS.t70 9.41178
R273 VSS.n14 VSS.t10 9.41178
R274 VSS.n13 VSS.t5 9.41178
R275 VSS.t47 VSS.n10 9.41178
R276 VSS.n85 VSS.t65 9.41178
R277 VSS.n101 VSS.t53 9.41178
R278 VSS.n103 VSS.t53 9.41178
R279 VSS.n104 VSS.t51 9.41178
R280 VSS.n106 VSS.t51 9.41178
R281 VSS.n107 VSS.t49 9.41178
R282 VSS.n77 VSS.t69 9.41178
R283 VSS.n79 VSS.t69 9.41178
R284 VSS.n80 VSS.t67 9.41178
R285 VSS.n82 VSS.t67 9.41178
R286 VSS.t65 VSS.n84 9.41178
R287 VSS.n31 VSS.t16 9.25428
R288 VSS.n34 VSS.t19 9.25428
R289 VSS.n53 VSS.t34 9.25428
R290 VSS.n56 VSS.t36 9.25428
R291 VSS.t41 VSS.n25 8.95021
R292 VSS.n11 VSS.t47 8.95021
R293 VSS.n24 VSS.t13 8.85603
R294 VSS.n26 VSS.t13 8.85603
R295 VSS.n23 VSS.t16 8.85603
R296 VSS.n22 VSS.t19 8.85603
R297 VSS.n14 VSS.t34 8.85603
R298 VSS.n13 VSS.t36 8.85603
R299 VSS.n12 VSS.t39 8.85603
R300 VSS.t39 VSS.n10 8.85603
R301 VSS.n113 VSS.n5 5.84372
R302 VSS.n68 VSS.n2 5.234
R303 VSS VSS.n0 4.9379
R304 VSS VSS.n2 4.9379
R305 VSS.n75 VSS.n59 4.6472
R306 VSS.n60 VSS 4.5455
R307 VSS.n65 VSS.n64 4.5005
R308 VSS.n77 VSS.n76 3.4493
R309 VSS.n60 VSS.n0 3.2324
R310 VSS.n61 VSS.n60 1.9841
R311 VSS.t72 VSS.n62 1.69879
R312 VSS.n110 VSS.n9 1.0544
R313 VSS.n110 VSS.n109 1.0184
R314 VSS.n76 VSS.n75 1.0184
R315 VSS.n66 VSS.n62 0.787647
R316 VSS.n67 VSS.n61 0.6998
R317 VSS.n65 VSS.n63 0.676565
R318 VSS.n109 VSS.n2 0.5585
R319 VSS.n76 VSS.n0 0.5585
R320 VSS VSS.n1 0.536
R321 VSS.n21 VSS.n20 0.489875
R322 VSS.n18 VSS.n17 0.489875
R323 VSS.n25 VSS.n24 0.446
R324 VSS.n12 VSS.n11 0.446
R325 VSS.n41 VSS.n40 0.4325
R326 VSS.n95 VSS.n94 0.4325
R327 VSS.n24 VSS.n9 0.39875
R328 VSS.n28 VSS.n26 0.39875
R329 VSS.n29 VSS.n23 0.39875
R330 VSS.n32 VSS.n22 0.39875
R331 VSS.n35 VSS.n21 0.39875
R332 VSS.n37 VSS.n19 0.39875
R333 VSS.n44 VSS.n18 0.39875
R334 VSS.n46 VSS.n16 0.39875
R335 VSS.n47 VSS.n15 0.39875
R336 VSS.n50 VSS.n14 0.39875
R337 VSS.n54 VSS.n13 0.39875
R338 VSS.n57 VSS.n12 0.39875
R339 VSS.n59 VSS.n10 0.39875
R340 VSS.n75 VSS.n74 0.3255
R341 VSS.n74 VSS.n73 0.3255
R342 VSS.n111 VSS.n110 0.3255
R343 VSS.n112 VSS.n111 0.3255
R344 VSS.n44 VSS.n43 0.3155
R345 VSS.n38 VSS.n37 0.3155
R346 VSS.n92 VSS.n91 0.3155
R347 VSS.n98 VSS.n97 0.3155
R348 VSS.n59 VSS.n58 0.2255
R349 VSS.n58 VSS.n57 0.2255
R350 VSS.n56 VSS.n55 0.2255
R351 VSS.n55 VSS.n54 0.2255
R352 VSS.n53 VSS.n52 0.2255
R353 VSS.n34 VSS.n33 0.2255
R354 VSS.n33 VSS.n32 0.2255
R355 VSS.n31 VSS.n30 0.2255
R356 VSS.n30 VSS.n29 0.2255
R357 VSS.n28 VSS.n27 0.2255
R358 VSS.n27 VSS.n9 0.2255
R359 VSS.n102 VSS.n101 0.2255
R360 VSS.n103 VSS.n102 0.2255
R361 VSS.n105 VSS.n104 0.2255
R362 VSS.n106 VSS.n105 0.2255
R363 VSS.n108 VSS.n107 0.2255
R364 VSS.n78 VSS.n77 0.2255
R365 VSS.n79 VSS.n78 0.2255
R366 VSS.n81 VSS.n80 0.2255
R367 VSS.n82 VSS.n81 0.2255
R368 VSS.n84 VSS.n83 0.2255
R369 VSS.n57 VSS.n56 0.1985
R370 VSS.n54 VSS.n53 0.1985
R371 VSS.n50 VSS.n49 0.1985
R372 VSS.n47 VSS.n46 0.1985
R373 VSS.n35 VSS.n34 0.1985
R374 VSS.n32 VSS.n31 0.1985
R375 VSS.n29 VSS.n28 0.1985
R376 VSS.n86 VSS.n85 0.1985
R377 VSS.n89 VSS.n88 0.1985
R378 VSS.n101 VSS.n100 0.1985
R379 VSS.n104 VSS.n103 0.1985
R380 VSS.n107 VSS.n106 0.1985
R381 VSS.n80 VSS.n79 0.1985
R382 VSS.n84 VSS.n82 0.1985
R383 VSS.n51 VSS.n50 0.1679
R384 VSS.n85 VSS.n1 0.1679
R385 VSS.n49 VSS.n48 0.1607
R386 VSS.n48 VSS.n47 0.1607
R387 VSS.n46 VSS.n45 0.1607
R388 VSS.n45 VSS.n44 0.1607
R389 VSS.n43 VSS.n42 0.1607
R390 VSS.n42 VSS.n41 0.1607
R391 VSS.n40 VSS.n39 0.1607
R392 VSS.n39 VSS.n38 0.1607
R393 VSS.n37 VSS.n36 0.1607
R394 VSS.n36 VSS.n35 0.1607
R395 VSS.n87 VSS.n86 0.1607
R396 VSS.n88 VSS.n87 0.1607
R397 VSS.n90 VSS.n89 0.1607
R398 VSS.n91 VSS.n90 0.1607
R399 VSS.n93 VSS.n92 0.1607
R400 VSS.n94 VSS.n93 0.1607
R401 VSS.n96 VSS.n95 0.1607
R402 VSS.n97 VSS.n96 0.1607
R403 VSS.n99 VSS.n98 0.1607
R404 VSS.n100 VSS.n99 0.1607
R405 VSS.n109 VSS.n108 0.0815
R406 VSS.n68 VSS.n4 0.0582778
R407 VSS.n61 VSS.n3 0.0582778
R408 VSS.n52 VSS.n51 0.0581
R409 VSS.n83 VSS.n1 0.0581
R410 VSS.n51 VSS.n7 0.0408101
R411 VSS.n7 VSS.n5 0.0408101
R412 VSS.n8 VSS.n1 0.0408101
R413 VSS.n8 VSS.n5 0.0408101
R414 VSS VSS.n114 0.0340484
R415 VSS.n114 VSS.n113 0.0340484
R416 VSS.n70 VSS.n69 0.0340484
R417 VSS.n71 VSS.n70 0.0340484
R418 VSS.n64 VSS.n62 0.0291016
R419 VSS.n66 VSS.n65 0.0277
R420 VSS.n63 VSS.t72 0.00659526
R421 VSS.n64 VSS.t1 0.00271429
R422 VSS.t1 VSS.n63 0.00101118
C0 a_3430_2214# a_3704_6616# 0.54505f
C1 VKup VDD 1.32286f
C2 Vamp_bias VT 3.21822f
C3 a_4712_2292# a_3430_2214# 1.21685f
C4 VT a_3704_6616# 0.60243f
C5 a_2722_6554# VDD 1.69839f
C6 Vamp_bias VIp 3.96017f
C7 a_4474_6632# VDD 3.49663f
C8 VKdn VIp 4.33519f
C9 a_2722_6554# VKdn 3.13554f
C10 spike VDD 2.70645f
C11 VK Vlk 1.53408f
C12 a_7550_2214# a_3430_2214# 1.19361f
C13 a_5916_6554# VDD 3.2623f
C14 VNA VKdn 1.54102f
C15 VMEM VDD 2.45793f
C16 a_3704_6616# VDD 0.7712f
C17 VMEM a_3704_6616# 0.76799f
C18 a_7550_2214# a_8270_2214# 0.74832f
C19 VDD a_9750_6632# 1.99802f
C20 VT VK 1.95077f
C21 VKdn VSS 8.83548f
C22 Vamp_bias VSS 8.14685f
C23 VT VSS 6.86182f
C24 VIp VSS 8.26674f
C25 VK VSS 4.00901f
C26 Vlk VSS 2.84087f
C27 VMEM VSS 19.60754f
C28 spike VSS 11.1446f
C29 VKup VSS 4.4606f
C30 VNA VSS 3.20144f
C31 VDD VSS 0.1063p
C32 a_8270_2214# VSS 3.49814f
C33 a_7550_2214# VSS 1.97794f
C34 a_4712_2292# VSS 1.94331f
C35 a_3430_2214# VSS 4.24419f
C36 a_9750_6632# VSS 5.66746f
C37 a_5916_6554# VSS 3.73154f
C38 a_4474_6632# VSS 7.62216f
C39 a_3704_6616# VSS 4.54072f
C40 a_2722_6554# VSS 7.59541f
C41 VDD.n1 VSS 1.41855f
C42 VDD.n3 VSS 0.80553f
C43 VDD.t55 VSS 1.48072f
C44 VDD.t54 VSS 1.13286f
C45 VDD.t50 VSS 1.85859f
C46 VDD.t1 VSS 0.70422f
C47 VDD.t4 VSS 0.76556f
C48 VDD.t7 VSS 0.68591f
C49 VDD.t10 VSS 0.64608f
C50 VDD.t13 VSS 0.71799f
C51 VDD.t16 VSS 0.75782f
C52 VDD.t19 VSS 0.76556f
C53 VDD.t22 VSS 0.86845f
C54 VDD.n72 VSS 1.75792f
C55 VNA.t0 VSS 0.72024f
C56 VKup.t0 VSS 0.51171f
C57 spike.t2 VSS 3.27075f
C58 VMEM.t3 VSS 4.64294f
C59 Vlk.t0 VSS 0.55301f
C60 VK.t0 VSS 1.16937f
C61 VIp.t0 VSS 2.69208f
C62 VT.t0 VSS 1.41256f
C63 Vamp_bias.t0 VSS 1.79547f
C64 VKdn.t0 VSS 2.92601f
.ends
