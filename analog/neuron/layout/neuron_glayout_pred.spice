* LVS reference for neuron_glayout.gds (glayout_floorplan.two_row)
* note: M1: 0.22/0.28 -> 0.5/0.64 (W/L kept)
* note: M2: 0.22/0.28 -> 0.5/0.64 (W/L kept)
* note: M3: 0.22/0.28 -> 0.5/0.64 (W/L kept)
* note: M4: 0.22/0.28 -> 0.5/0.64 (W/L kept)
* note: M5: 0.22/0.28 -> 0.5/0.64 (W/L kept)
* note: M6: 0.22/5 -> 0.5/11.36 (W/L kept)
* note: net x1_net2 -> VT (1 terminals)
.subckt neuron_glayout VSS VDD VMEM VNA Vlk VK VIp VKup VKdn Vamp_bias VT spike
Xx1_M3 x1_net1 Vamp_bias VSS VSS nfet_03v3 L=0.64u W=0.5u nf=1
Xx1_M1 x1_net3 VMEM x1_net1 VSS nfet_03v3 L=2u W=4u nf=1
Xx1_M2 net1 VT x1_net1 VSS nfet_03v3 L=2u W=4u nf=1
XM1 net2 net1 net4 VSS nfet_03v3 L=0.64u W=0.5u nf=1
XM8 net4 VIp VSS VSS nfet_03v3 L=1u W=1u nf=1
XM2 spike net2 net5 VSS nfet_03v3 L=0.64u W=0.5u nf=1
XM7 net5 VKdn VSS VSS nfet_03v3 L=1u W=1u nf=1
XM6 VMEM spike net6 VSS nfet_03v3 L=11.36u W=0.5u nf=1
XM10 net6 VK VSS VSS nfet_03v3 L=1u W=1u nf=1
XM11 VMEM Vlk VSS VSS nfet_03v3 L=1u W=1u nf=1
Xx1_M4 x1_net3 x1_net3 VDD VDD pfet_03v3 L=8u W=0.5u nf=1
Xx1_M5 net1 x1_net3 VDD VDD pfet_03v3 L=8u W=0.5u nf=1
XM3 net2 net1 VDD VDD pfet_03v3 L=0.64u W=0.5u nf=1
XM4 spike net2 net3 VDD pfet_03v3 L=0.64u W=0.5u nf=1
XM12 net3 VKup VDD VDD pfet_03v3 L=1u W=1u nf=1
XM5 VMEM net2 net7 VDD pfet_03v3 L=0.64u W=0.5u nf=1
XM9 net7 VNA VDD VDD pfet_03v3 L=1u W=1u nf=1
XC1 spike VSS cap_mim_2f0fF c_width=10e-6 c_length=10e-6 m=1
XC2 VMEM VSS cap_mim_2f0fF c_width=22.18e-6 c_length=22.18e-6 m=1
XDNN0 VSS VSS VSS VSS nfet_03v3 L=1u W=0.5u nf=1
XDNN1 VSS VSS VSS VSS nfet_03v3 L=1u W=0.5u nf=1
XDNN2 VSS VSS VSS VSS nfet_03v3 L=1u W=0.5u nf=1
XDNN3 VSS VSS VSS VSS nfet_03v3 L=1u W=0.5u nf=1
XDNN4 VSS VSS VSS VSS nfet_03v3 L=1u W=0.5u nf=1
XDNN5 VSS VSS VSS VSS nfet_03v3 L=1u W=0.5u nf=1
XDNN6 VSS VSS VSS VSS nfet_03v3 L=1u W=0.5u nf=1
XDNN7 VSS VSS VSS VSS nfet_03v3 L=1u W=0.5u nf=1
XDNN8 VSS VSS VSS VSS nfet_03v3 L=1u W=0.5u nf=1
XDNN9 VSS VSS VSS VSS nfet_03v3 L=1u W=0.5u nf=1
XDNN10 VSS VSS VSS VSS nfet_03v3 L=1u W=0.5u nf=1
XDNN11 VSS VSS VSS VSS nfet_03v3 L=1u W=0.5u nf=1
XDNN12 VSS VSS VSS VSS nfet_03v3 L=1u W=0.5u nf=1
XDNN13 VSS VSS VSS VSS nfet_03v3 L=1u W=0.5u nf=1
XDNN14 VSS VSS VSS VSS nfet_03v3 L=1u W=0.5u nf=1
XDNN15 VSS VSS VSS VSS nfet_03v3 L=1u W=0.5u nf=1
XDNN16 VSS VSS VSS VSS nfet_03v3 L=1u W=0.5u nf=1
XDNN17 VSS VSS VSS VSS nfet_03v3 L=1u W=0.5u nf=1
XDNN18 VSS VSS VSS VSS nfet_03v3 L=1u W=0.5u nf=1
XDNN19 VSS VSS VSS VSS nfet_03v3 L=1u W=0.5u nf=1
XDNN20 VSS VSS VSS VSS nfet_03v3 L=1u W=0.5u nf=1
XDNN21 VSS VSS VSS VSS nfet_03v3 L=1u W=0.5u nf=1
XDNN22 VSS VSS VSS VSS nfet_03v3 L=1u W=0.5u nf=1
XDNN23 VSS VSS VSS VSS nfet_03v3 L=1u W=0.5u nf=1
XDNN24 VSS VSS VSS VSS nfet_03v3 L=1u W=0.5u nf=1
XDNN25 VSS VSS VSS VSS nfet_03v3 L=1u W=0.5u nf=1
XDNN26 VSS VSS VSS VSS nfet_03v3 L=1u W=0.5u nf=1
XDNN27 VSS VSS VSS VSS nfet_03v3 L=1u W=0.5u nf=1
XDNN28 VSS VSS VSS VSS nfet_03v3 L=1u W=0.5u nf=1
XDNN29 VSS VSS VSS VSS nfet_03v3 L=1u W=0.5u nf=1
XDNN30 VSS VSS VSS VSS nfet_03v3 L=1u W=0.5u nf=1
XDNN31 VSS VSS VSS VSS nfet_03v3 L=1u W=0.5u nf=1
XDNS0 VSS VSS VSS VSS nfet_03v3 L=1u W=0.5u nf=1
XDNS1 VSS VSS VSS VSS nfet_03v3 L=1u W=0.5u nf=1
XDNS2 VSS VSS VSS VSS nfet_03v3 L=1u W=0.5u nf=1
XDNS3 VSS VSS VSS VSS nfet_03v3 L=1u W=0.5u nf=1
XDNS4 VSS VSS VSS VSS nfet_03v3 L=1u W=0.5u nf=1
XDNS5 VSS VSS VSS VSS nfet_03v3 L=1u W=0.5u nf=1
XDNS6 VSS VSS VSS VSS nfet_03v3 L=1u W=0.5u nf=1
XDNS7 VSS VSS VSS VSS nfet_03v3 L=1u W=0.5u nf=1
XDNS8 VSS VSS VSS VSS nfet_03v3 L=1u W=0.5u nf=1
XDNS9 VSS VSS VSS VSS nfet_03v3 L=1u W=0.5u nf=1
XDNS10 VSS VSS VSS VSS nfet_03v3 L=1u W=0.5u nf=1
XDNS11 VSS VSS VSS VSS nfet_03v3 L=1u W=0.5u nf=1
XDNS12 VSS VSS VSS VSS nfet_03v3 L=1u W=0.5u nf=1
XDNS13 VSS VSS VSS VSS nfet_03v3 L=1u W=0.5u nf=1
XDNS14 VSS VSS VSS VSS nfet_03v3 L=1u W=0.5u nf=1
XDNS15 VSS VSS VSS VSS nfet_03v3 L=1u W=0.5u nf=1
XDNS16 VSS VSS VSS VSS nfet_03v3 L=1u W=0.5u nf=1
XDNS17 VSS VSS VSS VSS nfet_03v3 L=1u W=0.5u nf=1
XDNS18 VSS VSS VSS VSS nfet_03v3 L=1u W=0.5u nf=1
XDNS19 VSS VSS VSS VSS nfet_03v3 L=1u W=0.5u nf=1
XDNS20 VSS VSS VSS VSS nfet_03v3 L=1u W=0.5u nf=1
XDNS21 VSS VSS VSS VSS nfet_03v3 L=1u W=0.5u nf=1
XDNS22 VSS VSS VSS VSS nfet_03v3 L=1u W=0.5u nf=1
XDNS23 VSS VSS VSS VSS nfet_03v3 L=1u W=0.5u nf=1
XDNS24 VSS VSS VSS VSS nfet_03v3 L=1u W=0.5u nf=1
XDNS25 VSS VSS VSS VSS nfet_03v3 L=1u W=0.5u nf=1
XDNS26 VSS VSS VSS VSS nfet_03v3 L=1u W=0.5u nf=1
XDNS27 VSS VSS VSS VSS nfet_03v3 L=1u W=0.5u nf=1
XDNS28 VSS VSS VSS VSS nfet_03v3 L=1u W=0.5u nf=1
XDNS29 VSS VSS VSS VSS nfet_03v3 L=1u W=0.5u nf=1
XDNS30 VSS VSS VSS VSS nfet_03v3 L=1u W=0.5u nf=1
XDNS31 VSS VSS VSS VSS nfet_03v3 L=1u W=0.5u nf=1
XDNW0 VSS VSS VSS VSS nfet_03v3 L=1u W=4u nf=1
XDNE0 VSS VSS VSS VSS nfet_03v3 L=1u W=4u nf=1
XDPN0 VDD VDD VDD VDD pfet_03v3 L=1u W=0.5u nf=1
XDPN1 VDD VDD VDD VDD pfet_03v3 L=1u W=0.5u nf=1
XDPN2 VDD VDD VDD VDD pfet_03v3 L=1u W=0.5u nf=1
XDPN3 VDD VDD VDD VDD pfet_03v3 L=1u W=0.5u nf=1
XDPN4 VDD VDD VDD VDD pfet_03v3 L=1u W=0.5u nf=1
XDPN5 VDD VDD VDD VDD pfet_03v3 L=1u W=0.5u nf=1
XDPN6 VDD VDD VDD VDD pfet_03v3 L=1u W=0.5u nf=1
XDPN7 VDD VDD VDD VDD pfet_03v3 L=1u W=0.5u nf=1
XDPN8 VDD VDD VDD VDD pfet_03v3 L=1u W=0.5u nf=1
XDPN9 VDD VDD VDD VDD pfet_03v3 L=1u W=0.5u nf=1
XDPN10 VDD VDD VDD VDD pfet_03v3 L=1u W=0.5u nf=1
XDPN11 VDD VDD VDD VDD pfet_03v3 L=1u W=0.5u nf=1
XDPN12 VDD VDD VDD VDD pfet_03v3 L=1u W=0.5u nf=1
XDPN13 VDD VDD VDD VDD pfet_03v3 L=1u W=0.5u nf=1
XDPN14 VDD VDD VDD VDD pfet_03v3 L=1u W=0.5u nf=1
XDPN15 VDD VDD VDD VDD pfet_03v3 L=1u W=0.5u nf=1
XDPN16 VDD VDD VDD VDD pfet_03v3 L=1u W=0.5u nf=1
XDPN17 VDD VDD VDD VDD pfet_03v3 L=1u W=0.5u nf=1
XDPN18 VDD VDD VDD VDD pfet_03v3 L=1u W=0.5u nf=1
XDPN19 VDD VDD VDD VDD pfet_03v3 L=1u W=0.5u nf=1
XDPN20 VDD VDD VDD VDD pfet_03v3 L=1u W=0.5u nf=1
XDPN21 VDD VDD VDD VDD pfet_03v3 L=1u W=0.5u nf=1
XDPN22 VDD VDD VDD VDD pfet_03v3 L=1u W=0.5u nf=1
XDPN23 VDD VDD VDD VDD pfet_03v3 L=1u W=0.5u nf=1
XDPN24 VDD VDD VDD VDD pfet_03v3 L=1u W=0.5u nf=1
XDPN25 VDD VDD VDD VDD pfet_03v3 L=1u W=0.5u nf=1
XDPS0 VDD VDD VDD VDD pfet_03v3 L=1u W=0.5u nf=1
XDPS1 VDD VDD VDD VDD pfet_03v3 L=1u W=0.5u nf=1
XDPS2 VDD VDD VDD VDD pfet_03v3 L=1u W=0.5u nf=1
XDPS3 VDD VDD VDD VDD pfet_03v3 L=1u W=0.5u nf=1
XDPS4 VDD VDD VDD VDD pfet_03v3 L=1u W=0.5u nf=1
XDPS5 VDD VDD VDD VDD pfet_03v3 L=1u W=0.5u nf=1
XDPS6 VDD VDD VDD VDD pfet_03v3 L=1u W=0.5u nf=1
XDPS7 VDD VDD VDD VDD pfet_03v3 L=1u W=0.5u nf=1
XDPS8 VDD VDD VDD VDD pfet_03v3 L=1u W=0.5u nf=1
XDPS9 VDD VDD VDD VDD pfet_03v3 L=1u W=0.5u nf=1
XDPS10 VDD VDD VDD VDD pfet_03v3 L=1u W=0.5u nf=1
XDPS11 VDD VDD VDD VDD pfet_03v3 L=1u W=0.5u nf=1
XDPS12 VDD VDD VDD VDD pfet_03v3 L=1u W=0.5u nf=1
XDPS13 VDD VDD VDD VDD pfet_03v3 L=1u W=0.5u nf=1
XDPS14 VDD VDD VDD VDD pfet_03v3 L=1u W=0.5u nf=1
XDPS15 VDD VDD VDD VDD pfet_03v3 L=1u W=0.5u nf=1
XDPS16 VDD VDD VDD VDD pfet_03v3 L=1u W=0.5u nf=1
XDPS17 VDD VDD VDD VDD pfet_03v3 L=1u W=0.5u nf=1
XDPS18 VDD VDD VDD VDD pfet_03v3 L=1u W=0.5u nf=1
XDPS19 VDD VDD VDD VDD pfet_03v3 L=1u W=0.5u nf=1
XDPS20 VDD VDD VDD VDD pfet_03v3 L=1u W=0.5u nf=1
XDPS21 VDD VDD VDD VDD pfet_03v3 L=1u W=0.5u nf=1
XDPS22 VDD VDD VDD VDD pfet_03v3 L=1u W=0.5u nf=1
XDPS23 VDD VDD VDD VDD pfet_03v3 L=1u W=0.5u nf=1
XDPS24 VDD VDD VDD VDD pfet_03v3 L=1u W=0.5u nf=1
XDPS25 VDD VDD VDD VDD pfet_03v3 L=1u W=0.5u nf=1
XDPW0 VDD VDD VDD VDD pfet_03v3 L=1u W=1u nf=1
XDPE0 VDD VDD VDD VDD pfet_03v3 L=1u W=1u nf=1
Cpred_VIp VIp VSS 1.292e-14
Cpred_VK VK VSS 2.089e-14
Cpred_VKdn VKdn VSS 1.522e-14
Cpred_VKup VKup VSS 1.175e-14
Cpred_VMEM VMEM VSS 5.054e-14
Cpred_VNA VNA VSS 1.907e-14
Cpred_VT VT VSS 1.128e-14
Cpred_Vamp_bias Vamp_bias VSS 5.766e-15
Cpred_Vlk Vlk VSS 1.888e-14
Cpred_net1 net1 VSS 5.231e-14
Cpred_net2 net2 VSS 6.231e-14
Cpred_net3 net3 VSS 6.423e-15
Cpred_net4 net4 VSS 8.652e-15
Cpred_net5 net5 VSS 9.123e-15
Cpred_net6 net6 VSS 1.273e-14
Cpred_net7 net7 VSS 5.903e-15
Cpred_spike spike VSS 5.929e-14
Cpred_x1_net1 x1_net1 VSS 1.02e-14
Cpred_x1_net3 x1_net3 VSS 3.463e-14
.ends
