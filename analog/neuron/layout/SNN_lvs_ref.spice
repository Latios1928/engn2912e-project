* LVS reference for the SNN top-level layout (gen_snn.py), written by make_snn_lvs_ref.py.
* Instances and nets as in analog/snn/snn_analog_inh.sch (xschem netlist), with these
* layout-only changes:
*   - the six plain DACs are DAC_binary (weights 1:2:4:8, not the schematic's 1:2:3:4 DAC.sym); DAC_signed contains the binary DAC
*   - every block is its layout cell; the subcircuits below are copied from the blocks'
*     own LVS references (*_lvs_ref.spice: dummies, MIM caps, substrate / DNWELL ports)
*   - the blocks' GND (DACs, DAC_signed, DPI_inh) and the substrate are the top-level VSS

.subckt neuron_sized VSS VDD VMEM VNA Vlk VK VIp VKup VKdn Vamp_bias VT spike
* spike amplifier (x1): A1/A2 diff pair, A3 tail, A4/A5 mirror
XA1 amp_n2 VMEM tail VSS nfet_03v3 L=0.28u W=0.22u nf=1
XA2 net1 VT tail VSS nfet_03v3 L=0.28u W=0.22u nf=1
XA3 tail Vamp_bias VSS VSS nfet_03v3 L=0.28u W=0.22u nf=1
XA4 amp_n2 amp_n2 VDD VDD pfet_03v3 L=0.28u W=0.22u nf=1
XA5 net1 amp_n2 VDD VDD pfet_03v3 L=0.28u W=0.22u nf=1
* neuron
XM1 net2 net1 net4 VSS nfet_03v3 L=0.28u W=0.22u nf=1
XM2 spike net2 net5 VSS nfet_03v3 L=0.28u W=0.22u nf=1
XM3 net2 net1 VDD VDD pfet_03v3 L=0.28u W=0.22u nf=1
XM4 spike net2 net3 VDD pfet_03v3 L=0.28u W=0.22u nf=1
XM5 VMEM net2 net7 VDD pfet_03v3 L=0.28u W=0.22u nf=1
XM6 VMEM spike net6 VSS nfet_03v3 L=5u W=0.22u nf=1
XM7 net5 VKdn VSS VSS nfet_03v3 L=1u W=1u nf=1
XM8 net4 VIp VSS VSS nfet_03v3 L=1u W=1u nf=1
XM9 net7 VNA VDD VDD pfet_03v3 L=1u W=1u nf=1
XM10 net6 VK VSS VSS nfet_03v3 L=1u W=1u nf=1
XM11 VMEM Vlk VSS VSS nfet_03v3 L=1u W=1u nf=1
XM12 net3 VKup VDD VDD pfet_03v3 L=1u W=1u nf=1
XC1 spike VSS cap_mim_2f0fF c_width=10e-6 c_length=10e-6 m=1
XC2 VMEM VSS cap_mim_2f0fF c_width=22.18e-6 c_length=22.18e-6 m=1
* dummies in the critical rows
XEN1 VSS VSS VSS VSS nfet_03v3 L=1u W=1u nf=1
XFN1 VSS VSS VSS VSS nfet_03v3 L=0.28u W=0.22u nf=1
XFN2 VSS VSS VSS VSS nfet_03v3 L=0.28u W=0.22u nf=1
XEN2 VSS VSS VSS VSS nfet_03v3 L=1u W=1u nf=1
XEP1 VDD VDD VDD VDD pfet_03v3 L=1u W=1u nf=1
XFP1 VDD VDD VDD VDD pfet_03v3 L=0.28u W=0.22u nf=1
XFP2 VDD VDD VDD VDD pfet_03v3 L=0.28u W=0.22u nf=1
XEP2 VDD VDD VDD VDD pfet_03v3 L=1u W=1u nf=1
* NMOS dummy rows (below / above the critical row)
XDB_EN1 VSS VSS VSS VSS nfet_03v3 L=1u W=1u nf=1
XDB_M11 VSS VSS VSS VSS nfet_03v3 L=1u W=1u nf=1
XDB_M10 VSS VSS VSS VSS nfet_03v3 L=1u W=1u nf=1
XDB_FN1 VSS VSS VSS VSS nfet_03v3 L=0.28u W=0.22u nf=1
XDB_A1 VSS VSS VSS VSS nfet_03v3 L=0.28u W=0.22u nf=1
XDB_A2 VSS VSS VSS VSS nfet_03v3 L=0.28u W=0.22u nf=1
XDB_FN2 VSS VSS VSS VSS nfet_03v3 L=0.28u W=0.22u nf=1
XDB_A3 VSS VSS VSS VSS nfet_03v3 L=0.28u W=0.22u nf=1
XDB_M8 VSS VSS VSS VSS nfet_03v3 L=1u W=1u nf=1
XDB_M7 VSS VSS VSS VSS nfet_03v3 L=1u W=1u nf=1
XDB_EN2 VSS VSS VSS VSS nfet_03v3 L=1u W=1u nf=1
XDT_EN1 VSS VSS VSS VSS nfet_03v3 L=1u W=1u nf=1
XDT_M11 VSS VSS VSS VSS nfet_03v3 L=1u W=1u nf=1
XDT_M10 VSS VSS VSS VSS nfet_03v3 L=1u W=1u nf=1
XDT_FN1 VSS VSS VSS VSS nfet_03v3 L=0.28u W=0.22u nf=1
XDT_A1 VSS VSS VSS VSS nfet_03v3 L=0.28u W=0.22u nf=1
XDT_A2 VSS VSS VSS VSS nfet_03v3 L=0.28u W=0.22u nf=1
XDT_FN2 VSS VSS VSS VSS nfet_03v3 L=0.28u W=0.22u nf=1
XDT_A3 VSS VSS VSS VSS nfet_03v3 L=0.28u W=0.22u nf=1
XDT_M8 VSS VSS VSS VSS nfet_03v3 L=1u W=1u nf=1
XDT_M7 VSS VSS VSS VSS nfet_03v3 L=1u W=1u nf=1
XDT_EN2 VSS VSS VSS VSS nfet_03v3 L=1u W=1u nf=1
* PMOS dummy rows (below / above the critical row)
XPB_EP1 VDD VDD VDD VDD pfet_03v3 L=1u W=1u nf=1
XPB_M9 VDD VDD VDD VDD pfet_03v3 L=1u W=1u nf=1
XPB_FP1 VDD VDD VDD VDD pfet_03v3 L=0.28u W=0.22u nf=1
XPB_A4 VDD VDD VDD VDD pfet_03v3 L=0.28u W=0.22u nf=1
XPB_A5 VDD VDD VDD VDD pfet_03v3 L=0.28u W=0.22u nf=1
XPB_FP2 VDD VDD VDD VDD pfet_03v3 L=0.28u W=0.22u nf=1
XPB_M12 VDD VDD VDD VDD pfet_03v3 L=1u W=1u nf=1
XPB_EP2 VDD VDD VDD VDD pfet_03v3 L=1u W=1u nf=1
XPT_EP1 VDD VDD VDD VDD pfet_03v3 L=1u W=1u nf=1
XPT_M9 VDD VDD VDD VDD pfet_03v3 L=1u W=1u nf=1
XPT_FP1 VDD VDD VDD VDD pfet_03v3 L=0.28u W=0.22u nf=1
XPT_A4 VDD VDD VDD VDD pfet_03v3 L=0.28u W=0.22u nf=1
XPT_A5 VDD VDD VDD VDD pfet_03v3 L=0.28u W=0.22u nf=1
XPT_FP2 VDD VDD VDD VDD pfet_03v3 L=0.28u W=0.22u nf=1
XPT_M12 VDD VDD VDD VDD pfet_03v3 L=1u W=1u nf=1
XPT_EP2 VDD VDD VDD VDD pfet_03v3 L=1u W=1u nf=1
.ends

.subckt DPI VDD Vthr Isyn Isum VT VSS
XM1 VDD Vthr Isum Isum nfet_03v3 L=0.28u W=0.22u nf=1
XM2 net1 net1 Isum Isum nfet_03v3 L=0.28u W=0.22u nf=1
XM3 net1 VT VDD VDD pfet_03v3 L=0.28u W=0.22u nf=1
XM4 Isyn net1 VDD VDD pfet_03v3 L=0.28u W=0.22u nf=1
XC4 VDD net1 cap_mim_2f0fF c_width=22.36e-6 c_length=22.36e-6 m=1
.ends

.subckt DAC_binary Isum Vb w[3] w[2] w[1] w[0] en VDD GND
XMen Isum en X GND nfet_03v3 L=0.28u W=0.22u nf=1
XM1 X w[0] net4 net4 nfet_03v3 L=0.28u W=0.22u nf=1
XM2 net4 Vb GND GND nfet_03v3 L=8u W=1u nf=1
XM3 X w[1] net2 net2 nfet_03v3 L=0.28u W=0.44u nf=2
XM4 net2 Vb GND GND nfet_03v3 L=8u W=2u nf=2
XM5 X w[2] net3 net3 nfet_03v3 L=0.28u W=0.88u nf=4
XM6 net3 Vb GND GND nfet_03v3 L=8u W=4u nf=4
XM7 X w[3] net1 net1 nfet_03v3 L=0.28u W=1.76u nf=8
XM8 net1 Vb GND GND nfet_03v3 L=8u W=8u nf=8
* dummies at the ends of the switch rows
XMEN_DL GND GND GND GND nfet_03v3 L=0.28u W=0.22u nf=1
XMEN_DR GND GND GND GND nfet_03v3 L=0.28u W=0.22u nf=1
XA_DL net4 net4 net4 net4 nfet_03v3 L=0.28u W=0.22u nf=1
XA_DR net4 net4 net4 net4 nfet_03v3 L=0.28u W=0.22u nf=1
XB_DL net2 net2 net2 net2 nfet_03v3 L=0.28u W=0.22u nf=1
XB_DR net2 net2 net2 net2 nfet_03v3 L=0.28u W=0.22u nf=1
XC_DL net3 net3 net3 net3 nfet_03v3 L=0.28u W=0.22u nf=1
XC_DR net3 net3 net3 net3 nfet_03v3 L=0.28u W=0.22u nf=1
XD_DL net1 net1 net1 net1 nfet_03v3 L=0.28u W=0.22u nf=1
XD_DR net1 net1 net1 net1 nfet_03v3 L=0.28u W=0.22u nf=1
* dummy rows above (_T) and below (_B) each switch row (all terminals on that well's body net)
XMEN_T0 GND GND GND GND nfet_03v3 L=0.28u W=0.22u nf=1
XMEN_T1 GND GND GND GND nfet_03v3 L=0.28u W=0.22u nf=1
XMEN_T2 GND GND GND GND nfet_03v3 L=0.28u W=0.22u nf=1
XMEN_B0 GND GND GND GND nfet_03v3 L=0.28u W=0.22u nf=1
XMEN_B1 GND GND GND GND nfet_03v3 L=0.28u W=0.22u nf=1
XMEN_B2 GND GND GND GND nfet_03v3 L=0.28u W=0.22u nf=1
XA_T0 net4 net4 net4 net4 nfet_03v3 L=0.28u W=0.22u nf=1
XA_T1 net4 net4 net4 net4 nfet_03v3 L=0.28u W=0.22u nf=1
XA_T2 net4 net4 net4 net4 nfet_03v3 L=0.28u W=0.22u nf=1
XA_B0 net4 net4 net4 net4 nfet_03v3 L=0.28u W=0.22u nf=1
XA_B1 net4 net4 net4 net4 nfet_03v3 L=0.28u W=0.22u nf=1
XA_B2 net4 net4 net4 net4 nfet_03v3 L=0.28u W=0.22u nf=1
XB_T0 net2 net2 net2 net2 nfet_03v3 L=0.28u W=0.22u nf=1
XB_T1 net2 net2 net2 net2 nfet_03v3 L=0.28u W=0.22u nf=1
XB_T2 net2 net2 net2 net2 nfet_03v3 L=0.28u W=0.22u nf=1
XB_T3 net2 net2 net2 net2 nfet_03v3 L=0.28u W=0.22u nf=1
XB_B0 net2 net2 net2 net2 nfet_03v3 L=0.28u W=0.22u nf=1
XB_B1 net2 net2 net2 net2 nfet_03v3 L=0.28u W=0.22u nf=1
XB_B2 net2 net2 net2 net2 nfet_03v3 L=0.28u W=0.22u nf=1
XB_B3 net2 net2 net2 net2 nfet_03v3 L=0.28u W=0.22u nf=1
XC_T0 net3 net3 net3 net3 nfet_03v3 L=0.28u W=0.22u nf=1
XC_T1 net3 net3 net3 net3 nfet_03v3 L=0.28u W=0.22u nf=1
XC_T2 net3 net3 net3 net3 nfet_03v3 L=0.28u W=0.22u nf=1
XC_T3 net3 net3 net3 net3 nfet_03v3 L=0.28u W=0.22u nf=1
XC_T4 net3 net3 net3 net3 nfet_03v3 L=0.28u W=0.22u nf=1
XC_T5 net3 net3 net3 net3 nfet_03v3 L=0.28u W=0.22u nf=1
XC_B0 net3 net3 net3 net3 nfet_03v3 L=0.28u W=0.22u nf=1
XC_B1 net3 net3 net3 net3 nfet_03v3 L=0.28u W=0.22u nf=1
XC_B2 net3 net3 net3 net3 nfet_03v3 L=0.28u W=0.22u nf=1
XC_B3 net3 net3 net3 net3 nfet_03v3 L=0.28u W=0.22u nf=1
XC_B4 net3 net3 net3 net3 nfet_03v3 L=0.28u W=0.22u nf=1
XC_B5 net3 net3 net3 net3 nfet_03v3 L=0.28u W=0.22u nf=1
XD_T0 net1 net1 net1 net1 nfet_03v3 L=0.28u W=0.22u nf=1
XD_T1 net1 net1 net1 net1 nfet_03v3 L=0.28u W=0.22u nf=1
XD_T2 net1 net1 net1 net1 nfet_03v3 L=0.28u W=0.22u nf=1
XD_T3 net1 net1 net1 net1 nfet_03v3 L=0.28u W=0.22u nf=1
XD_T4 net1 net1 net1 net1 nfet_03v3 L=0.28u W=0.22u nf=1
XD_T5 net1 net1 net1 net1 nfet_03v3 L=0.28u W=0.22u nf=1
XD_T6 net1 net1 net1 net1 nfet_03v3 L=0.28u W=0.22u nf=1
XD_T7 net1 net1 net1 net1 nfet_03v3 L=0.28u W=0.22u nf=1
XD_T8 net1 net1 net1 net1 nfet_03v3 L=0.28u W=0.22u nf=1
XD_T9 net1 net1 net1 net1 nfet_03v3 L=0.28u W=0.22u nf=1
XD_B0 net1 net1 net1 net1 nfet_03v3 L=0.28u W=0.22u nf=1
XD_B1 net1 net1 net1 net1 nfet_03v3 L=0.28u W=0.22u nf=1
XD_B2 net1 net1 net1 net1 nfet_03v3 L=0.28u W=0.22u nf=1
XD_B3 net1 net1 net1 net1 nfet_03v3 L=0.28u W=0.22u nf=1
XD_B4 net1 net1 net1 net1 nfet_03v3 L=0.28u W=0.22u nf=1
XD_B5 net1 net1 net1 net1 nfet_03v3 L=0.28u W=0.22u nf=1
XD_B6 net1 net1 net1 net1 nfet_03v3 L=0.28u W=0.22u nf=1
XD_B7 net1 net1 net1 net1 nfet_03v3 L=0.28u W=0.22u nf=1
XD_B8 net1 net1 net1 net1 nfet_03v3 L=0.28u W=0.22u nf=1
XD_B9 net1 net1 net1 net1 nfet_03v3 L=0.28u W=0.22u nf=1
* dummy ring around the current-source array (20 devices, all GND)
XDA_b0 GND GND GND GND nfet_03v3 L=8u W=1u nf=1
XDA_b1 GND GND GND GND nfet_03v3 L=8u W=1u nf=1
XDA_b2 GND GND GND GND nfet_03v3 L=8u W=1u nf=1
XDA_b3 GND GND GND GND nfet_03v3 L=8u W=1u nf=1
XDA_b4 GND GND GND GND nfet_03v3 L=8u W=1u nf=1
XDA_b5 GND GND GND GND nfet_03v3 L=8u W=1u nf=1
XDA_b6 GND GND GND GND nfet_03v3 L=8u W=1u nf=1
XDA_t0 GND GND GND GND nfet_03v3 L=8u W=1u nf=1
XDA_t1 GND GND GND GND nfet_03v3 L=8u W=1u nf=1
XDA_t2 GND GND GND GND nfet_03v3 L=8u W=1u nf=1
XDA_t3 GND GND GND GND nfet_03v3 L=8u W=1u nf=1
XDA_t4 GND GND GND GND nfet_03v3 L=8u W=1u nf=1
XDA_t5 GND GND GND GND nfet_03v3 L=8u W=1u nf=1
XDA_t6 GND GND GND GND nfet_03v3 L=8u W=1u nf=1
XDA_10 GND GND GND GND nfet_03v3 L=8u W=1u nf=1
XDA_16 GND GND GND GND nfet_03v3 L=8u W=1u nf=1
XDA_20 GND GND GND GND nfet_03v3 L=8u W=1u nf=1
XDA_26 GND GND GND GND nfet_03v3 L=8u W=1u nf=1
XDA_30 GND GND GND GND nfet_03v3 L=8u W=1u nf=1
XDA_36 GND GND GND GND nfet_03v3 L=8u W=1u nf=1
.ends

.subckt DAC_signed Isum_e Isum_i s Vb w[3] w[2] w[1] w[0] en VDD GND
x1 Y Vb w[3] w[2] w[1] w[0] en VDD GND DAC_binary
XMse Isum_e sb Y GND nfet_03v3 L=0.28u W=0.22u nf=1
XMsi Isum_i s Y GND nfet_03v3 L=0.28u W=0.22u nf=1
XMpi sb s VDD VDD pfet_03v3 L=0.28u W=0.44u nf=1
XMni sb s GND GND nfet_03v3 L=0.28u W=0.22u nf=1
.ends

.subckt DPI_sized VDD Vthr Isyn Isum VT VSS
XM1 VDD Vthr Isum Isum nfet_03v3 L=1.12u W=0.88u nf=1
XM2 net1 net1 Isum Isum nfet_03v3 L=1.12u W=0.88u nf=1
XM3 net1 VT VDD VDD pfet_03v3 L=1.12u W=0.88u nf=1
XM4 Isyn net1 VDD VDD pfet_03v3 L=1.12u W=0.88u nf=1
XC4 VDD net1 cap_mim_2f0fF c_width=22.36e-6 c_length=22.36e-6 m=1
.ends

.subckt DPI_inh VDD Vthr VT Isum Iout GND
x1 VDD Vthr Im Isum VT GND DPI_sized
XMi1 Im Im GND GND nfet_03v3 L=8u W=2u nf=1
XMi2 Iout Im GND GND nfet_03v3 L=8u W=2u nf=1
XMD_L GND GND GND GND nfet_03v3 L=8u W=2u nf=1
XMD_R GND GND GND GND nfet_03v3 L=8u W=2u nf=1
.ends

.subckt SNN VDD VSS Vb w[0] w[1] w[2] w[3] w[4] w[5] w[6] w[7] w[8] w[9] w[10] w[11] w[12] w[13] w[14] w[15] w[16] w[17] w[18] w[19] w[20] w[21] w[22] w[23] w[24] w[25] w[26] w[27] w[28] w[29] w[30] w[31] pulse[0] pulse[1] s[0] s[1] Vthr VT_dpi VT_inh VNA Vlk VK VIp VKup VKdn Vamp_bias VT spike[0] spike[1] spike[2] spike[3] spike[4]
xdac0_0 Isum_0 Vb w[3] w[2] w[1] w[0] pulse[0] VDD VSS DAC_binary
xdac1_0 Isum_1 Vb w[7] w[6] w[5] w[4] pulse[1] VDD VSS DAC_binary
xdac2_0 Isum_2 Vb w[11] w[10] w[9] w[8] spike[0] VDD VSS DAC_binary
xdac2_1 Isum_2 Vb w[15] w[14] w[13] w[12] spike[1] VDD VSS DAC_binary
xdac3_0 Isum_3 Vb w[19] w[18] w[17] w[16] spike[0] VDD VSS DAC_binary
xdac3_1 Isum_3 Vb w[23] w[22] w[21] w[20] spike[1] VDD VSS DAC_binary
xdac4_0 Isum_4 Isum_5 s[0] Vb w[27] w[26] w[25] w[24] spike[2] VDD VSS DAC_signed
xdac4_1 Isum_4 Isum_5 s[1] Vb w[31] w[30] w[29] w[28] spike[3] VDD VSS DAC_signed
xdpi0 VDD Vthr VMEM_0 Isum_0 VT_dpi VSS DPI
xdpi1 VDD Vthr VMEM_1 Isum_1 VT_dpi VSS DPI
xdpi2 VDD Vthr VMEM_2 Isum_2 VT_dpi VSS DPI
xdpi3 VDD Vthr VMEM_3 Isum_3 VT_dpi VSS DPI
xdpi4 VDD Vthr VMEM_4 Isum_4 VT_dpi VSS DPI
xdpi5 VDD Vthr VT_inh Isum_5 VMEM_4 VSS DPI_inh
xneu0 VSS VDD VMEM_0 VNA Vlk VK VIp VKup VKdn Vamp_bias VT spike[0] neuron_sized
xneu1 VSS VDD VMEM_1 VNA Vlk VK VIp VKup VKdn Vamp_bias VT spike[1] neuron_sized
xneu2 VSS VDD VMEM_2 VNA Vlk VK VIp VKup VKdn Vamp_bias VT spike[2] neuron_sized
xneu3 VSS VDD VMEM_3 VNA Vlk VK VIp VKup VKdn Vamp_bias VT spike[3] neuron_sized
xneu4 VSS VDD VMEM_4 VNA Vlk VK VIp VKup VKdn Vamp_bias VT spike[4] neuron_sized
.ends
