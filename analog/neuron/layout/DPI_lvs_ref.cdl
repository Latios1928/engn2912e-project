* LVS reference for the DPI layout.
* Built from the xschem netlist of analog/neuron/DPI.sch with two layout-only changes:
*   1. C4 (ideal 1 pF in the schematic) -> GF180 MIM cap cap_mim_2f0fF (LVS device name), 22.36 x 22.36 um = 1.000 pF
*   2. port VSS added: the substrate guard ring that rule DN.3 requires
.subckt DPI VDD Vthr Isyn Isum VT VSS
MM1 VDD Vthr Isum Isum nfet_03v3 L=0.28u W=0.22u nf=1
MM2 net1 net1 Isum Isum nfet_03v3 L=0.28u W=0.22u nf=1
MM3 net1 VT VDD VDD pfet_03v3 L=0.28u W=0.22u nf=1
MM4 Isyn net1 VDD VDD pfet_03v3 L=0.28u W=0.22u nf=1
C4 VDD net1 cap_mim_2f0fF W=22.36e-6 L=22.36e-6 m=1
.ends
