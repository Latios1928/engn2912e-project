* LVS reference for spike_amp_fp.gds (glayout_floorplan.two_row)
* note: net net2 -> VN (1 terminals)
.subckt spike_amp_fp VDD VSS VP VN VB spike_out
XM1 net3 VP net1 VSS nfet_03v3 L=2u W=4u nf=1
XM2 spike_out VN net1 VSS nfet_03v3 L=2u W=4u nf=1
XM3 net1 VB VSS VSS nfet_03v3 L=0.64u W=0.5u nf=1
XM4 net3 net3 VDD VDD pfet_03v3 L=8u W=0.5u nf=1
XM5 spike_out net3 VDD VDD pfet_03v3 L=8u W=0.5u nf=1
XDNN0 VSS VSS VSS VSS nfet_03v3 L=1u W=0.5u nf=1
XDNN1 VSS VSS VSS VSS nfet_03v3 L=1u W=0.5u nf=1
XDNN2 VSS VSS VSS VSS nfet_03v3 L=1u W=0.5u nf=1
XDNN3 VSS VSS VSS VSS nfet_03v3 L=1u W=0.5u nf=1
XDNN4 VSS VSS VSS VSS nfet_03v3 L=1u W=0.5u nf=1
XDNN5 VSS VSS VSS VSS nfet_03v3 L=1u W=0.5u nf=1
XDNN6 VSS VSS VSS VSS nfet_03v3 L=1u W=0.5u nf=1
XDNN7 VSS VSS VSS VSS nfet_03v3 L=1u W=0.5u nf=1
XDNN8 VSS VSS VSS VSS nfet_03v3 L=1u W=0.5u nf=1
XDNN9 VSS VSS VSS VSS nfet_03v3 L=1u W=0.5u nf=1
XDNS0 VSS VSS VSS VSS nfet_03v3 L=1u W=0.5u nf=1
XDNS1 VSS VSS VSS VSS nfet_03v3 L=1u W=0.5u nf=1
XDNS2 VSS VSS VSS VSS nfet_03v3 L=1u W=0.5u nf=1
XDNS3 VSS VSS VSS VSS nfet_03v3 L=1u W=0.5u nf=1
XDNS4 VSS VSS VSS VSS nfet_03v3 L=1u W=0.5u nf=1
XDNS5 VSS VSS VSS VSS nfet_03v3 L=1u W=0.5u nf=1
XDNS6 VSS VSS VSS VSS nfet_03v3 L=1u W=0.5u nf=1
XDNS7 VSS VSS VSS VSS nfet_03v3 L=1u W=0.5u nf=1
XDNS8 VSS VSS VSS VSS nfet_03v3 L=1u W=0.5u nf=1
XDNS9 VSS VSS VSS VSS nfet_03v3 L=1u W=0.5u nf=1
XDNW0 VSS VSS VSS VSS nfet_03v3 L=1u W=4u nf=1
XDNE0 VSS VSS VSS VSS nfet_03v3 L=1u W=4u nf=1
XDPN0 VDD VDD VDD VDD pfet_03v3 L=1u W=0.5u nf=1
XDPN1 VDD VDD VDD VDD pfet_03v3 L=1u W=0.5u nf=1
XDPN2 VDD VDD VDD VDD pfet_03v3 L=1u W=0.5u nf=1
XDPN3 VDD VDD VDD VDD pfet_03v3 L=1u W=0.5u nf=1
XDPN4 VDD VDD VDD VDD pfet_03v3 L=1u W=0.5u nf=1
XDPN5 VDD VDD VDD VDD pfet_03v3 L=1u W=0.5u nf=1
XDPN6 VDD VDD VDD VDD pfet_03v3 L=1u W=0.5u nf=1
XDPN7 VDD VDD VDD VDD pfet_03v3 L=1u W=0.5u nf=1
XDPN8 VDD VDD VDD VDD pfet_03v3 L=1u W=0.5u nf=1
XDPN9 VDD VDD VDD VDD pfet_03v3 L=1u W=0.5u nf=1
XDPN10 VDD VDD VDD VDD pfet_03v3 L=1u W=0.5u nf=1
XDPN11 VDD VDD VDD VDD pfet_03v3 L=1u W=0.5u nf=1
XDPN12 VDD VDD VDD VDD pfet_03v3 L=1u W=0.5u nf=1
XDPN13 VDD VDD VDD VDD pfet_03v3 L=1u W=0.5u nf=1
XDPN14 VDD VDD VDD VDD pfet_03v3 L=1u W=0.5u nf=1
XDPN15 VDD VDD VDD VDD pfet_03v3 L=1u W=0.5u nf=1
XDPS0 VDD VDD VDD VDD pfet_03v3 L=1u W=0.5u nf=1
XDPS1 VDD VDD VDD VDD pfet_03v3 L=1u W=0.5u nf=1
XDPS2 VDD VDD VDD VDD pfet_03v3 L=1u W=0.5u nf=1
XDPS3 VDD VDD VDD VDD pfet_03v3 L=1u W=0.5u nf=1
XDPS4 VDD VDD VDD VDD pfet_03v3 L=1u W=0.5u nf=1
XDPS5 VDD VDD VDD VDD pfet_03v3 L=1u W=0.5u nf=1
XDPS6 VDD VDD VDD VDD pfet_03v3 L=1u W=0.5u nf=1
XDPS7 VDD VDD VDD VDD pfet_03v3 L=1u W=0.5u nf=1
XDPS8 VDD VDD VDD VDD pfet_03v3 L=1u W=0.5u nf=1
XDPS9 VDD VDD VDD VDD pfet_03v3 L=1u W=0.5u nf=1
XDPS10 VDD VDD VDD VDD pfet_03v3 L=1u W=0.5u nf=1
XDPS11 VDD VDD VDD VDD pfet_03v3 L=1u W=0.5u nf=1
XDPS12 VDD VDD VDD VDD pfet_03v3 L=1u W=0.5u nf=1
XDPS13 VDD VDD VDD VDD pfet_03v3 L=1u W=0.5u nf=1
XDPS14 VDD VDD VDD VDD pfet_03v3 L=1u W=0.5u nf=1
XDPS15 VDD VDD VDD VDD pfet_03v3 L=1u W=0.5u nf=1
XDPW0 VDD VDD VDD VDD pfet_03v3 L=1u W=0.5u nf=1
XDPE0 VDD VDD VDD VDD pfet_03v3 L=1u W=0.5u nf=1
Cpred_VB VB VSS 5.506e-15
Cpred_VN VN VSS 5.849e-15
Cpred_VP VP VSS 4.613e-15
Cpred_net1 net1 VSS 9.955e-15
Cpred_net3 net3 VSS 1.558e-14
Cpred_spike_out spike_out VSS 7.193e-15
.ends
